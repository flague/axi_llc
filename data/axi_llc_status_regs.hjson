// Copyright 2025 Politecnico di Torino.
// Copyright and related rights are licensed under the Solderpad Hardware
// License, Version 2.0 (the "License"); you may not use this file except in
// compliance with the License. You may obtain a copy of the License at
// http://solderpad.org/licenses/SHL-2.0. Unless required by applicable law
// or agreed to in writing, software, hardware and materials distributed under
// this License is distributed on an "AS IS" BASIS, WITHOUT WARRANTIES OR
// CONDITIONS OF ANY KIND, either express or implied. See the License for the
// specific language governing permissions and limitations under the License.
//
// File: axi_llc_status_regs.hjson
// Author: Flavia Guella
// Date: 04/06/2025



{ name: "axi_llc_status",
  clock_primary: "clk_i",
  reset_primary: "rst_ni",
  bus_interfaces: [
    {
      protocol: "reg_iface",
      direction: "device",
    },
  ],
  regwidth: "32",
  registers: [
    {
      name:     "STATUS_0",
      desc:     "Status register of cache line 0",
      swaccess: "rw",
      hwaccess: "hrw",
      hwext:    "true",
      hwqe:     "true", // enable `qe` latched signal of software write pulse
      hwre:     "true",
      fields: [
        {
          bits: "5+3:5", // 2 bits for status
          name: "CL_STATUS",
          desc: "Contain the current status of the corresponding cache line                [0]: valid, [1]: dirty, [2]: cmpt",
        }
      ]
    },
    { name:     "TAG_0",
      desc:     "Tag Address stored in cache line 0",
      swaccess: "rw",
      hwaccess: "hrw",
      hwext:    "true",
      hwqe:     "true", // enable `qe` latched signal of software write pulse
      hwre:     "true",
      fields: [
        { bits: "5-1:0",
          name: "CL_TAG",
          desc: "Tag Address"
        }
      ]
    },
    {
      name:     "STATUS_1",
      desc:     "Status register of cache line 1",
      swaccess: "rw",
      hwaccess: "hrw",
      hwext:    "true",
      hwqe:     "true", // enable `qe` latched signal of software write pulse
      hwre:     "true",
      fields: [
        {
          bits: "5+3:5", // 2 bits for status
          name: "CL_STATUS",
          desc: "Contain the current status of the corresponding cache line                [0]: valid, [1]: dirty, [2]: cmpt",
        }
      ]
    },
    { name:     "TAG_1",
      desc:     "Tag Address stored in cache line 1",
      swaccess: "rw",
      hwaccess: "hrw",
      hwext:    "true",
      hwqe:     "true", // enable `qe` latched signal of software write pulse
      hwre:     "true",
      fields: [
        { bits: "5-1:0",
          name: "CL_TAG",
          desc: "Tag Address"
        }
      ]
    },
    {
      name:     "STATUS_2",
      desc:     "Status register of cache line 2",
      swaccess: "rw",
      hwaccess: "hrw",
      hwext:    "true",
      hwqe:     "true", // enable `qe` latched signal of software write pulse
      hwre:     "true",
      fields: [
        {
          bits: "5+3:5", // 2 bits for status
          name: "CL_STATUS",
          desc: "Contain the current status of the corresponding cache line                [0]: valid, [1]: dirty, [2]: cmpt",
        }
      ]
    },
    { name:     "TAG_2",
      desc:     "Tag Address stored in cache line 2",
      swaccess: "rw",
      hwaccess: "hrw",
      hwext:    "true",
      hwqe:     "true", // enable `qe` latched signal of software write pulse
      hwre:     "true",
      fields: [
        { bits: "5-1:0",
          name: "CL_TAG",
          desc: "Tag Address"
        }
      ]
    },
    {
      name:     "STATUS_3",
      desc:     "Status register of cache line 3",
      swaccess: "rw",
      hwaccess: "hrw",
      hwext:    "true",
      hwqe:     "true", // enable `qe` latched signal of software write pulse
      hwre:     "true",
      fields: [
        {
          bits: "5+3:5", // 2 bits for status
          name: "CL_STATUS",
          desc: "Contain the current status of the corresponding cache line                [0]: valid, [1]: dirty, [2]: cmpt",
        }
      ]
    },
    { name:     "TAG_3",
      desc:     "Tag Address stored in cache line 3",
      swaccess: "rw",
      hwaccess: "hrw",
      hwext:    "true",
      hwqe:     "true", // enable `qe` latched signal of software write pulse
      hwre:     "true",
      fields: [
        { bits: "5-1:0",
          name: "CL_TAG",
          desc: "Tag Address"
        }
      ]
    },
    {
      name:     "STATUS_4",
      desc:     "Status register of cache line 4",
      swaccess: "rw",
      hwaccess: "hrw",
      hwext:    "true",
      hwqe:     "true", // enable `qe` latched signal of software write pulse
      hwre:     "true",
      fields: [
        {
          bits: "5+3:5", // 2 bits for status
          name: "CL_STATUS",
          desc: "Contain the current status of the corresponding cache line                [0]: valid, [1]: dirty, [2]: cmpt",
        }
      ]
    },
    { name:     "TAG_4",
      desc:     "Tag Address stored in cache line 4",
      swaccess: "rw",
      hwaccess: "hrw",
      hwext:    "true",
      hwqe:     "true", // enable `qe` latched signal of software write pulse
      hwre:     "true",
      fields: [
        { bits: "5-1:0",
          name: "CL_TAG",
          desc: "Tag Address"
        }
      ]
    },
    {
      name:     "STATUS_5",
      desc:     "Status register of cache line 5",
      swaccess: "rw",
      hwaccess: "hrw",
      hwext:    "true",
      hwqe:     "true", // enable `qe` latched signal of software write pulse
      hwre:     "true",
      fields: [
        {
          bits: "5+3:5", // 2 bits for status
          name: "CL_STATUS",
          desc: "Contain the current status of the corresponding cache line                [0]: valid, [1]: dirty, [2]: cmpt",
        }
      ]
    },
    { name:     "TAG_5",
      desc:     "Tag Address stored in cache line 5",
      swaccess: "rw",
      hwaccess: "hrw",
      hwext:    "true",
      hwqe:     "true", // enable `qe` latched signal of software write pulse
      hwre:     "true",
      fields: [
        { bits: "5-1:0",
          name: "CL_TAG",
          desc: "Tag Address"
        }
      ]
    },
    {
      name:     "STATUS_6",
      desc:     "Status register of cache line 6",
      swaccess: "rw",
      hwaccess: "hrw",
      hwext:    "true",
      hwqe:     "true", // enable `qe` latched signal of software write pulse
      hwre:     "true",
      fields: [
        {
          bits: "5+3:5", // 2 bits for status
          name: "CL_STATUS",
          desc: "Contain the current status of the corresponding cache line                [0]: valid, [1]: dirty, [2]: cmpt",
        }
      ]
    },
    { name:     "TAG_6",
      desc:     "Tag Address stored in cache line 6",
      swaccess: "rw",
      hwaccess: "hrw",
      hwext:    "true",
      hwqe:     "true", // enable `qe` latched signal of software write pulse
      hwre:     "true",
      fields: [
        { bits: "5-1:0",
          name: "CL_TAG",
          desc: "Tag Address"
        }
      ]
    },
    {
      name:     "STATUS_7",
      desc:     "Status register of cache line 7",
      swaccess: "rw",
      hwaccess: "hrw",
      hwext:    "true",
      hwqe:     "true", // enable `qe` latched signal of software write pulse
      hwre:     "true",
      fields: [
        {
          bits: "5+3:5", // 2 bits for status
          name: "CL_STATUS",
          desc: "Contain the current status of the corresponding cache line                [0]: valid, [1]: dirty, [2]: cmpt",
        }
      ]
    },
    { name:     "TAG_7",
      desc:     "Tag Address stored in cache line 7",
      swaccess: "rw",
      hwaccess: "hrw",
      hwext:    "true",
      hwqe:     "true", // enable `qe` latched signal of software write pulse
      hwre:     "true",
      fields: [
        { bits: "5-1:0",
          name: "CL_TAG",
          desc: "Tag Address"
        }
      ]
    },
    {
      name:     "STATUS_8",
      desc:     "Status register of cache line 8",
      swaccess: "rw",
      hwaccess: "hrw",
      hwext:    "true",
      hwqe:     "true", // enable `qe` latched signal of software write pulse
      hwre:     "true",
      fields: [
        {
          bits: "5+3:5", // 2 bits for status
          name: "CL_STATUS",
          desc: "Contain the current status of the corresponding cache line                [0]: valid, [1]: dirty, [2]: cmpt",
        }
      ]
    },
    { name:     "TAG_8",
      desc:     "Tag Address stored in cache line 8",
      swaccess: "rw",
      hwaccess: "hrw",
      hwext:    "true",
      hwqe:     "true", // enable `qe` latched signal of software write pulse
      hwre:     "true",
      fields: [
        { bits: "5-1:0",
          name: "CL_TAG",
          desc: "Tag Address"
        }
      ]
    },
    {
      name:     "STATUS_9",
      desc:     "Status register of cache line 9",
      swaccess: "rw",
      hwaccess: "hrw",
      hwext:    "true",
      hwqe:     "true", // enable `qe` latched signal of software write pulse
      hwre:     "true",
      fields: [
        {
          bits: "5+3:5", // 2 bits for status
          name: "CL_STATUS",
          desc: "Contain the current status of the corresponding cache line                [0]: valid, [1]: dirty, [2]: cmpt",
        }
      ]
    },
    { name:     "TAG_9",
      desc:     "Tag Address stored in cache line 9",
      swaccess: "rw",
      hwaccess: "hrw",
      hwext:    "true",
      hwqe:     "true", // enable `qe` latched signal of software write pulse
      hwre:     "true",
      fields: [
        { bits: "5-1:0",
          name: "CL_TAG",
          desc: "Tag Address"
        }
      ]
    },
    {
      name:     "STATUS_10",
      desc:     "Status register of cache line 10",
      swaccess: "rw",
      hwaccess: "hrw",
      hwext:    "true",
      hwqe:     "true", // enable `qe` latched signal of software write pulse
      hwre:     "true",
      fields: [
        {
          bits: "5+3:5", // 2 bits for status
          name: "CL_STATUS",
          desc: "Contain the current status of the corresponding cache line                [0]: valid, [1]: dirty, [2]: cmpt",
        }
      ]
    },
    { name:     "TAG_10",
      desc:     "Tag Address stored in cache line 10",
      swaccess: "rw",
      hwaccess: "hrw",
      hwext:    "true",
      hwqe:     "true", // enable `qe` latched signal of software write pulse
      hwre:     "true",
      fields: [
        { bits: "5-1:0",
          name: "CL_TAG",
          desc: "Tag Address"
        }
      ]
    },
    {
      name:     "STATUS_11",
      desc:     "Status register of cache line 11",
      swaccess: "rw",
      hwaccess: "hrw",
      hwext:    "true",
      hwqe:     "true", // enable `qe` latched signal of software write pulse
      hwre:     "true",
      fields: [
        {
          bits: "5+3:5", // 2 bits for status
          name: "CL_STATUS",
          desc: "Contain the current status of the corresponding cache line                [0]: valid, [1]: dirty, [2]: cmpt",
        }
      ]
    },
    { name:     "TAG_11",
      desc:     "Tag Address stored in cache line 11",
      swaccess: "rw",
      hwaccess: "hrw",
      hwext:    "true",
      hwqe:     "true", // enable `qe` latched signal of software write pulse
      hwre:     "true",
      fields: [
        { bits: "5-1:0",
          name: "CL_TAG",
          desc: "Tag Address"
        }
      ]
    },
    {
      name:     "STATUS_12",
      desc:     "Status register of cache line 12",
      swaccess: "rw",
      hwaccess: "hrw",
      hwext:    "true",
      hwqe:     "true", // enable `qe` latched signal of software write pulse
      hwre:     "true",
      fields: [
        {
          bits: "5+3:5", // 2 bits for status
          name: "CL_STATUS",
          desc: "Contain the current status of the corresponding cache line                [0]: valid, [1]: dirty, [2]: cmpt",
        }
      ]
    },
    { name:     "TAG_12",
      desc:     "Tag Address stored in cache line 12",
      swaccess: "rw",
      hwaccess: "hrw",
      hwext:    "true",
      hwqe:     "true", // enable `qe` latched signal of software write pulse
      hwre:     "true",
      fields: [
        { bits: "5-1:0",
          name: "CL_TAG",
          desc: "Tag Address"
        }
      ]
    },
    {
      name:     "STATUS_13",
      desc:     "Status register of cache line 13",
      swaccess: "rw",
      hwaccess: "hrw",
      hwext:    "true",
      hwqe:     "true", // enable `qe` latched signal of software write pulse
      hwre:     "true",
      fields: [
        {
          bits: "5+3:5", // 2 bits for status
          name: "CL_STATUS",
          desc: "Contain the current status of the corresponding cache line                [0]: valid, [1]: dirty, [2]: cmpt",
        }
      ]
    },
    { name:     "TAG_13",
      desc:     "Tag Address stored in cache line 13",
      swaccess: "rw",
      hwaccess: "hrw",
      hwext:    "true",
      hwqe:     "true", // enable `qe` latched signal of software write pulse
      hwre:     "true",
      fields: [
        { bits: "5-1:0",
          name: "CL_TAG",
          desc: "Tag Address"
        }
      ]
    },
    {
      name:     "STATUS_14",
      desc:     "Status register of cache line 14",
      swaccess: "rw",
      hwaccess: "hrw",
      hwext:    "true",
      hwqe:     "true", // enable `qe` latched signal of software write pulse
      hwre:     "true",
      fields: [
        {
          bits: "5+3:5", // 2 bits for status
          name: "CL_STATUS",
          desc: "Contain the current status of the corresponding cache line                [0]: valid, [1]: dirty, [2]: cmpt",
        }
      ]
    },
    { name:     "TAG_14",
      desc:     "Tag Address stored in cache line 14",
      swaccess: "rw",
      hwaccess: "hrw",
      hwext:    "true",
      hwqe:     "true", // enable `qe` latched signal of software write pulse
      hwre:     "true",
      fields: [
        { bits: "5-1:0",
          name: "CL_TAG",
          desc: "Tag Address"
        }
      ]
    },
    {
      name:     "STATUS_15",
      desc:     "Status register of cache line 15",
      swaccess: "rw",
      hwaccess: "hrw",
      hwext:    "true",
      hwqe:     "true", // enable `qe` latched signal of software write pulse
      hwre:     "true",
      fields: [
        {
          bits: "5+3:5", // 2 bits for status
          name: "CL_STATUS",
          desc: "Contain the current status of the corresponding cache line                [0]: valid, [1]: dirty, [2]: cmpt",
        }
      ]
    },
    { name:     "TAG_15",
      desc:     "Tag Address stored in cache line 15",
      swaccess: "rw",
      hwaccess: "hrw",
      hwext:    "true",
      hwqe:     "true", // enable `qe` latched signal of software write pulse
      hwre:     "true",
      fields: [
        { bits: "5-1:0",
          name: "CL_TAG",
          desc: "Tag Address"
        }
      ]
    },
    {
      name:     "STATUS_16",
      desc:     "Status register of cache line 16",
      swaccess: "rw",
      hwaccess: "hrw",
      hwext:    "true",
      hwqe:     "true", // enable `qe` latched signal of software write pulse
      hwre:     "true",
      fields: [
        {
          bits: "5+3:5", // 2 bits for status
          name: "CL_STATUS",
          desc: "Contain the current status of the corresponding cache line                [0]: valid, [1]: dirty, [2]: cmpt",
        }
      ]
    },
    { name:     "TAG_16",
      desc:     "Tag Address stored in cache line 16",
      swaccess: "rw",
      hwaccess: "hrw",
      hwext:    "true",
      hwqe:     "true", // enable `qe` latched signal of software write pulse
      hwre:     "true",
      fields: [
        { bits: "5-1:0",
          name: "CL_TAG",
          desc: "Tag Address"
        }
      ]
    },
    {
      name:     "STATUS_17",
      desc:     "Status register of cache line 17",
      swaccess: "rw",
      hwaccess: "hrw",
      hwext:    "true",
      hwqe:     "true", // enable `qe` latched signal of software write pulse
      hwre:     "true",
      fields: [
        {
          bits: "5+3:5", // 2 bits for status
          name: "CL_STATUS",
          desc: "Contain the current status of the corresponding cache line                [0]: valid, [1]: dirty, [2]: cmpt",
        }
      ]
    },
    { name:     "TAG_17",
      desc:     "Tag Address stored in cache line 17",
      swaccess: "rw",
      hwaccess: "hrw",
      hwext:    "true",
      hwqe:     "true", // enable `qe` latched signal of software write pulse
      hwre:     "true",
      fields: [
        { bits: "5-1:0",
          name: "CL_TAG",
          desc: "Tag Address"
        }
      ]
    },
    {
      name:     "STATUS_18",
      desc:     "Status register of cache line 18",
      swaccess: "rw",
      hwaccess: "hrw",
      hwext:    "true",
      hwqe:     "true", // enable `qe` latched signal of software write pulse
      hwre:     "true",
      fields: [
        {
          bits: "5+3:5", // 2 bits for status
          name: "CL_STATUS",
          desc: "Contain the current status of the corresponding cache line                [0]: valid, [1]: dirty, [2]: cmpt",
        }
      ]
    },
    { name:     "TAG_18",
      desc:     "Tag Address stored in cache line 18",
      swaccess: "rw",
      hwaccess: "hrw",
      hwext:    "true",
      hwqe:     "true", // enable `qe` latched signal of software write pulse
      hwre:     "true",
      fields: [
        { bits: "5-1:0",
          name: "CL_TAG",
          desc: "Tag Address"
        }
      ]
    },
    {
      name:     "STATUS_19",
      desc:     "Status register of cache line 19",
      swaccess: "rw",
      hwaccess: "hrw",
      hwext:    "true",
      hwqe:     "true", // enable `qe` latched signal of software write pulse
      hwre:     "true",
      fields: [
        {
          bits: "5+3:5", // 2 bits for status
          name: "CL_STATUS",
          desc: "Contain the current status of the corresponding cache line                [0]: valid, [1]: dirty, [2]: cmpt",
        }
      ]
    },
    { name:     "TAG_19",
      desc:     "Tag Address stored in cache line 19",
      swaccess: "rw",
      hwaccess: "hrw",
      hwext:    "true",
      hwqe:     "true", // enable `qe` latched signal of software write pulse
      hwre:     "true",
      fields: [
        { bits: "5-1:0",
          name: "CL_TAG",
          desc: "Tag Address"
        }
      ]
    },
    {
      name:     "STATUS_20",
      desc:     "Status register of cache line 20",
      swaccess: "rw",
      hwaccess: "hrw",
      hwext:    "true",
      hwqe:     "true", // enable `qe` latched signal of software write pulse
      hwre:     "true",
      fields: [
        {
          bits: "5+3:5", // 2 bits for status
          name: "CL_STATUS",
          desc: "Contain the current status of the corresponding cache line                [0]: valid, [1]: dirty, [2]: cmpt",
        }
      ]
    },
    { name:     "TAG_20",
      desc:     "Tag Address stored in cache line 20",
      swaccess: "rw",
      hwaccess: "hrw",
      hwext:    "true",
      hwqe:     "true", // enable `qe` latched signal of software write pulse
      hwre:     "true",
      fields: [
        { bits: "5-1:0",
          name: "CL_TAG",
          desc: "Tag Address"
        }
      ]
    },
    {
      name:     "STATUS_21",
      desc:     "Status register of cache line 21",
      swaccess: "rw",
      hwaccess: "hrw",
      hwext:    "true",
      hwqe:     "true", // enable `qe` latched signal of software write pulse
      hwre:     "true",
      fields: [
        {
          bits: "5+3:5", // 2 bits for status
          name: "CL_STATUS",
          desc: "Contain the current status of the corresponding cache line                [0]: valid, [1]: dirty, [2]: cmpt",
        }
      ]
    },
    { name:     "TAG_21",
      desc:     "Tag Address stored in cache line 21",
      swaccess: "rw",
      hwaccess: "hrw",
      hwext:    "true",
      hwqe:     "true", // enable `qe` latched signal of software write pulse
      hwre:     "true",
      fields: [
        { bits: "5-1:0",
          name: "CL_TAG",
          desc: "Tag Address"
        }
      ]
    },
    {
      name:     "STATUS_22",
      desc:     "Status register of cache line 22",
      swaccess: "rw",
      hwaccess: "hrw",
      hwext:    "true",
      hwqe:     "true", // enable `qe` latched signal of software write pulse
      hwre:     "true",
      fields: [
        {
          bits: "5+3:5", // 2 bits for status
          name: "CL_STATUS",
          desc: "Contain the current status of the corresponding cache line                [0]: valid, [1]: dirty, [2]: cmpt",
        }
      ]
    },
    { name:     "TAG_22",
      desc:     "Tag Address stored in cache line 22",
      swaccess: "rw",
      hwaccess: "hrw",
      hwext:    "true",
      hwqe:     "true", // enable `qe` latched signal of software write pulse
      hwre:     "true",
      fields: [
        { bits: "5-1:0",
          name: "CL_TAG",
          desc: "Tag Address"
        }
      ]
    },
    {
      name:     "STATUS_23",
      desc:     "Status register of cache line 23",
      swaccess: "rw",
      hwaccess: "hrw",
      hwext:    "true",
      hwqe:     "true", // enable `qe` latched signal of software write pulse
      hwre:     "true",
      fields: [
        {
          bits: "5+3:5", // 2 bits for status
          name: "CL_STATUS",
          desc: "Contain the current status of the corresponding cache line                [0]: valid, [1]: dirty, [2]: cmpt",
        }
      ]
    },
    { name:     "TAG_23",
      desc:     "Tag Address stored in cache line 23",
      swaccess: "rw",
      hwaccess: "hrw",
      hwext:    "true",
      hwqe:     "true", // enable `qe` latched signal of software write pulse
      hwre:     "true",
      fields: [
        { bits: "5-1:0",
          name: "CL_TAG",
          desc: "Tag Address"
        }
      ]
    },
    {
      name:     "STATUS_24",
      desc:     "Status register of cache line 24",
      swaccess: "rw",
      hwaccess: "hrw",
      hwext:    "true",
      hwqe:     "true", // enable `qe` latched signal of software write pulse
      hwre:     "true",
      fields: [
        {
          bits: "5+3:5", // 2 bits for status
          name: "CL_STATUS",
          desc: "Contain the current status of the corresponding cache line                [0]: valid, [1]: dirty, [2]: cmpt",
        }
      ]
    },
    { name:     "TAG_24",
      desc:     "Tag Address stored in cache line 24",
      swaccess: "rw",
      hwaccess: "hrw",
      hwext:    "true",
      hwqe:     "true", // enable `qe` latched signal of software write pulse
      hwre:     "true",
      fields: [
        { bits: "5-1:0",
          name: "CL_TAG",
          desc: "Tag Address"
        }
      ]
    },
    {
      name:     "STATUS_25",
      desc:     "Status register of cache line 25",
      swaccess: "rw",
      hwaccess: "hrw",
      hwext:    "true",
      hwqe:     "true", // enable `qe` latched signal of software write pulse
      hwre:     "true",
      fields: [
        {
          bits: "5+3:5", // 2 bits for status
          name: "CL_STATUS",
          desc: "Contain the current status of the corresponding cache line                [0]: valid, [1]: dirty, [2]: cmpt",
        }
      ]
    },
    { name:     "TAG_25",
      desc:     "Tag Address stored in cache line 25",
      swaccess: "rw",
      hwaccess: "hrw",
      hwext:    "true",
      hwqe:     "true", // enable `qe` latched signal of software write pulse
      hwre:     "true",
      fields: [
        { bits: "5-1:0",
          name: "CL_TAG",
          desc: "Tag Address"
        }
      ]
    },
    {
      name:     "STATUS_26",
      desc:     "Status register of cache line 26",
      swaccess: "rw",
      hwaccess: "hrw",
      hwext:    "true",
      hwqe:     "true", // enable `qe` latched signal of software write pulse
      hwre:     "true",
      fields: [
        {
          bits: "5+3:5", // 2 bits for status
          name: "CL_STATUS",
          desc: "Contain the current status of the corresponding cache line                [0]: valid, [1]: dirty, [2]: cmpt",
        }
      ]
    },
    { name:     "TAG_26",
      desc:     "Tag Address stored in cache line 26",
      swaccess: "rw",
      hwaccess: "hrw",
      hwext:    "true",
      hwqe:     "true", // enable `qe` latched signal of software write pulse
      hwre:     "true",
      fields: [
        { bits: "5-1:0",
          name: "CL_TAG",
          desc: "Tag Address"
        }
      ]
    },
    {
      name:     "STATUS_27",
      desc:     "Status register of cache line 27",
      swaccess: "rw",
      hwaccess: "hrw",
      hwext:    "true",
      hwqe:     "true", // enable `qe` latched signal of software write pulse
      hwre:     "true",
      fields: [
        {
          bits: "5+3:5", // 2 bits for status
          name: "CL_STATUS",
          desc: "Contain the current status of the corresponding cache line                [0]: valid, [1]: dirty, [2]: cmpt",
        }
      ]
    },
    { name:     "TAG_27",
      desc:     "Tag Address stored in cache line 27",
      swaccess: "rw",
      hwaccess: "hrw",
      hwext:    "true",
      hwqe:     "true", // enable `qe` latched signal of software write pulse
      hwre:     "true",
      fields: [
        { bits: "5-1:0",
          name: "CL_TAG",
          desc: "Tag Address"
        }
      ]
    },
    {
      name:     "STATUS_28",
      desc:     "Status register of cache line 28",
      swaccess: "rw",
      hwaccess: "hrw",
      hwext:    "true",
      hwqe:     "true", // enable `qe` latched signal of software write pulse
      hwre:     "true",
      fields: [
        {
          bits: "5+3:5", // 2 bits for status
          name: "CL_STATUS",
          desc: "Contain the current status of the corresponding cache line                [0]: valid, [1]: dirty, [2]: cmpt",
        }
      ]
    },
    { name:     "TAG_28",
      desc:     "Tag Address stored in cache line 28",
      swaccess: "rw",
      hwaccess: "hrw",
      hwext:    "true",
      hwqe:     "true", // enable `qe` latched signal of software write pulse
      hwre:     "true",
      fields: [
        { bits: "5-1:0",
          name: "CL_TAG",
          desc: "Tag Address"
        }
      ]
    },
    {
      name:     "STATUS_29",
      desc:     "Status register of cache line 29",
      swaccess: "rw",
      hwaccess: "hrw",
      hwext:    "true",
      hwqe:     "true", // enable `qe` latched signal of software write pulse
      hwre:     "true",
      fields: [
        {
          bits: "5+3:5", // 2 bits for status
          name: "CL_STATUS",
          desc: "Contain the current status of the corresponding cache line                [0]: valid, [1]: dirty, [2]: cmpt",
        }
      ]
    },
    { name:     "TAG_29",
      desc:     "Tag Address stored in cache line 29",
      swaccess: "rw",
      hwaccess: "hrw",
      hwext:    "true",
      hwqe:     "true", // enable `qe` latched signal of software write pulse
      hwre:     "true",
      fields: [
        { bits: "5-1:0",
          name: "CL_TAG",
          desc: "Tag Address"
        }
      ]
    },
    {
      name:     "STATUS_30",
      desc:     "Status register of cache line 30",
      swaccess: "rw",
      hwaccess: "hrw",
      hwext:    "true",
      hwqe:     "true", // enable `qe` latched signal of software write pulse
      hwre:     "true",
      fields: [
        {
          bits: "5+3:5", // 2 bits for status
          name: "CL_STATUS",
          desc: "Contain the current status of the corresponding cache line                [0]: valid, [1]: dirty, [2]: cmpt",
        }
      ]
    },
    { name:     "TAG_30",
      desc:     "Tag Address stored in cache line 30",
      swaccess: "rw",
      hwaccess: "hrw",
      hwext:    "true",
      hwqe:     "true", // enable `qe` latched signal of software write pulse
      hwre:     "true",
      fields: [
        { bits: "5-1:0",
          name: "CL_TAG",
          desc: "Tag Address"
        }
      ]
    },
    {
      name:     "STATUS_31",
      desc:     "Status register of cache line 31",
      swaccess: "rw",
      hwaccess: "hrw",
      hwext:    "true",
      hwqe:     "true", // enable `qe` latched signal of software write pulse
      hwre:     "true",
      fields: [
        {
          bits: "5+3:5", // 2 bits for status
          name: "CL_STATUS",
          desc: "Contain the current status of the corresponding cache line                [0]: valid, [1]: dirty, [2]: cmpt",
        }
      ]
    },
    { name:     "TAG_31",
      desc:     "Tag Address stored in cache line 31",
      swaccess: "rw",
      hwaccess: "hrw",
      hwext:    "true",
      hwqe:     "true", // enable `qe` latched signal of software write pulse
      hwre:     "true",
      fields: [
        { bits: "5-1:0",
          name: "CL_TAG",
          desc: "Tag Address"
        }
      ]
    },
    {
      name:     "STATUS_32",
      desc:     "Status register of cache line 32",
      swaccess: "rw",
      hwaccess: "hrw",
      hwext:    "true",
      hwqe:     "true", // enable `qe` latched signal of software write pulse
      hwre:     "true",
      fields: [
        {
          bits: "5+3:5", // 2 bits for status
          name: "CL_STATUS",
          desc: "Contain the current status of the corresponding cache line                [0]: valid, [1]: dirty, [2]: cmpt",
        }
      ]
    },
    { name:     "TAG_32",
      desc:     "Tag Address stored in cache line 32",
      swaccess: "rw",
      hwaccess: "hrw",
      hwext:    "true",
      hwqe:     "true", // enable `qe` latched signal of software write pulse
      hwre:     "true",
      fields: [
        { bits: "5-1:0",
          name: "CL_TAG",
          desc: "Tag Address"
        }
      ]
    },
    {
      name:     "STATUS_33",
      desc:     "Status register of cache line 33",
      swaccess: "rw",
      hwaccess: "hrw",
      hwext:    "true",
      hwqe:     "true", // enable `qe` latched signal of software write pulse
      hwre:     "true",
      fields: [
        {
          bits: "5+3:5", // 2 bits for status
          name: "CL_STATUS",
          desc: "Contain the current status of the corresponding cache line                [0]: valid, [1]: dirty, [2]: cmpt",
        }
      ]
    },
    { name:     "TAG_33",
      desc:     "Tag Address stored in cache line 33",
      swaccess: "rw",
      hwaccess: "hrw",
      hwext:    "true",
      hwqe:     "true", // enable `qe` latched signal of software write pulse
      hwre:     "true",
      fields: [
        { bits: "5-1:0",
          name: "CL_TAG",
          desc: "Tag Address"
        }
      ]
    },
    {
      name:     "STATUS_34",
      desc:     "Status register of cache line 34",
      swaccess: "rw",
      hwaccess: "hrw",
      hwext:    "true",
      hwqe:     "true", // enable `qe` latched signal of software write pulse
      hwre:     "true",
      fields: [
        {
          bits: "5+3:5", // 2 bits for status
          name: "CL_STATUS",
          desc: "Contain the current status of the corresponding cache line                [0]: valid, [1]: dirty, [2]: cmpt",
        }
      ]
    },
    { name:     "TAG_34",
      desc:     "Tag Address stored in cache line 34",
      swaccess: "rw",
      hwaccess: "hrw",
      hwext:    "true",
      hwqe:     "true", // enable `qe` latched signal of software write pulse
      hwre:     "true",
      fields: [
        { bits: "5-1:0",
          name: "CL_TAG",
          desc: "Tag Address"
        }
      ]
    },
    {
      name:     "STATUS_35",
      desc:     "Status register of cache line 35",
      swaccess: "rw",
      hwaccess: "hrw",
      hwext:    "true",
      hwqe:     "true", // enable `qe` latched signal of software write pulse
      hwre:     "true",
      fields: [
        {
          bits: "5+3:5", // 2 bits for status
          name: "CL_STATUS",
          desc: "Contain the current status of the corresponding cache line                [0]: valid, [1]: dirty, [2]: cmpt",
        }
      ]
    },
    { name:     "TAG_35",
      desc:     "Tag Address stored in cache line 35",
      swaccess: "rw",
      hwaccess: "hrw",
      hwext:    "true",
      hwqe:     "true", // enable `qe` latched signal of software write pulse
      hwre:     "true",
      fields: [
        { bits: "5-1:0",
          name: "CL_TAG",
          desc: "Tag Address"
        }
      ]
    },
    {
      name:     "STATUS_36",
      desc:     "Status register of cache line 36",
      swaccess: "rw",
      hwaccess: "hrw",
      hwext:    "true",
      hwqe:     "true", // enable `qe` latched signal of software write pulse
      hwre:     "true",
      fields: [
        {
          bits: "5+3:5", // 2 bits for status
          name: "CL_STATUS",
          desc: "Contain the current status of the corresponding cache line                [0]: valid, [1]: dirty, [2]: cmpt",
        }
      ]
    },
    { name:     "TAG_36",
      desc:     "Tag Address stored in cache line 36",
      swaccess: "rw",
      hwaccess: "hrw",
      hwext:    "true",
      hwqe:     "true", // enable `qe` latched signal of software write pulse
      hwre:     "true",
      fields: [
        { bits: "5-1:0",
          name: "CL_TAG",
          desc: "Tag Address"
        }
      ]
    },
    {
      name:     "STATUS_37",
      desc:     "Status register of cache line 37",
      swaccess: "rw",
      hwaccess: "hrw",
      hwext:    "true",
      hwqe:     "true", // enable `qe` latched signal of software write pulse
      hwre:     "true",
      fields: [
        {
          bits: "5+3:5", // 2 bits for status
          name: "CL_STATUS",
          desc: "Contain the current status of the corresponding cache line                [0]: valid, [1]: dirty, [2]: cmpt",
        }
      ]
    },
    { name:     "TAG_37",
      desc:     "Tag Address stored in cache line 37",
      swaccess: "rw",
      hwaccess: "hrw",
      hwext:    "true",
      hwqe:     "true", // enable `qe` latched signal of software write pulse
      hwre:     "true",
      fields: [
        { bits: "5-1:0",
          name: "CL_TAG",
          desc: "Tag Address"
        }
      ]
    },
    {
      name:     "STATUS_38",
      desc:     "Status register of cache line 38",
      swaccess: "rw",
      hwaccess: "hrw",
      hwext:    "true",
      hwqe:     "true", // enable `qe` latched signal of software write pulse
      hwre:     "true",
      fields: [
        {
          bits: "5+3:5", // 2 bits for status
          name: "CL_STATUS",
          desc: "Contain the current status of the corresponding cache line                [0]: valid, [1]: dirty, [2]: cmpt",
        }
      ]
    },
    { name:     "TAG_38",
      desc:     "Tag Address stored in cache line 38",
      swaccess: "rw",
      hwaccess: "hrw",
      hwext:    "true",
      hwqe:     "true", // enable `qe` latched signal of software write pulse
      hwre:     "true",
      fields: [
        { bits: "5-1:0",
          name: "CL_TAG",
          desc: "Tag Address"
        }
      ]
    },
    {
      name:     "STATUS_39",
      desc:     "Status register of cache line 39",
      swaccess: "rw",
      hwaccess: "hrw",
      hwext:    "true",
      hwqe:     "true", // enable `qe` latched signal of software write pulse
      hwre:     "true",
      fields: [
        {
          bits: "5+3:5", // 2 bits for status
          name: "CL_STATUS",
          desc: "Contain the current status of the corresponding cache line                [0]: valid, [1]: dirty, [2]: cmpt",
        }
      ]
    },
    { name:     "TAG_39",
      desc:     "Tag Address stored in cache line 39",
      swaccess: "rw",
      hwaccess: "hrw",
      hwext:    "true",
      hwqe:     "true", // enable `qe` latched signal of software write pulse
      hwre:     "true",
      fields: [
        { bits: "5-1:0",
          name: "CL_TAG",
          desc: "Tag Address"
        }
      ]
    },
    {
      name:     "STATUS_40",
      desc:     "Status register of cache line 40",
      swaccess: "rw",
      hwaccess: "hrw",
      hwext:    "true",
      hwqe:     "true", // enable `qe` latched signal of software write pulse
      hwre:     "true",
      fields: [
        {
          bits: "5+3:5", // 2 bits for status
          name: "CL_STATUS",
          desc: "Contain the current status of the corresponding cache line                [0]: valid, [1]: dirty, [2]: cmpt",
        }
      ]
    },
    { name:     "TAG_40",
      desc:     "Tag Address stored in cache line 40",
      swaccess: "rw",
      hwaccess: "hrw",
      hwext:    "true",
      hwqe:     "true", // enable `qe` latched signal of software write pulse
      hwre:     "true",
      fields: [
        { bits: "5-1:0",
          name: "CL_TAG",
          desc: "Tag Address"
        }
      ]
    },
    {
      name:     "STATUS_41",
      desc:     "Status register of cache line 41",
      swaccess: "rw",
      hwaccess: "hrw",
      hwext:    "true",
      hwqe:     "true", // enable `qe` latched signal of software write pulse
      hwre:     "true",
      fields: [
        {
          bits: "5+3:5", // 2 bits for status
          name: "CL_STATUS",
          desc: "Contain the current status of the corresponding cache line                [0]: valid, [1]: dirty, [2]: cmpt",
        }
      ]
    },
    { name:     "TAG_41",
      desc:     "Tag Address stored in cache line 41",
      swaccess: "rw",
      hwaccess: "hrw",
      hwext:    "true",
      hwqe:     "true", // enable `qe` latched signal of software write pulse
      hwre:     "true",
      fields: [
        { bits: "5-1:0",
          name: "CL_TAG",
          desc: "Tag Address"
        }
      ]
    },
    {
      name:     "STATUS_42",
      desc:     "Status register of cache line 42",
      swaccess: "rw",
      hwaccess: "hrw",
      hwext:    "true",
      hwqe:     "true", // enable `qe` latched signal of software write pulse
      hwre:     "true",
      fields: [
        {
          bits: "5+3:5", // 2 bits for status
          name: "CL_STATUS",
          desc: "Contain the current status of the corresponding cache line                [0]: valid, [1]: dirty, [2]: cmpt",
        }
      ]
    },
    { name:     "TAG_42",
      desc:     "Tag Address stored in cache line 42",
      swaccess: "rw",
      hwaccess: "hrw",
      hwext:    "true",
      hwqe:     "true", // enable `qe` latched signal of software write pulse
      hwre:     "true",
      fields: [
        { bits: "5-1:0",
          name: "CL_TAG",
          desc: "Tag Address"
        }
      ]
    },
    {
      name:     "STATUS_43",
      desc:     "Status register of cache line 43",
      swaccess: "rw",
      hwaccess: "hrw",
      hwext:    "true",
      hwqe:     "true", // enable `qe` latched signal of software write pulse
      hwre:     "true",
      fields: [
        {
          bits: "5+3:5", // 2 bits for status
          name: "CL_STATUS",
          desc: "Contain the current status of the corresponding cache line                [0]: valid, [1]: dirty, [2]: cmpt",
        }
      ]
    },
    { name:     "TAG_43",
      desc:     "Tag Address stored in cache line 43",
      swaccess: "rw",
      hwaccess: "hrw",
      hwext:    "true",
      hwqe:     "true", // enable `qe` latched signal of software write pulse
      hwre:     "true",
      fields: [
        { bits: "5-1:0",
          name: "CL_TAG",
          desc: "Tag Address"
        }
      ]
    },
    {
      name:     "STATUS_44",
      desc:     "Status register of cache line 44",
      swaccess: "rw",
      hwaccess: "hrw",
      hwext:    "true",
      hwqe:     "true", // enable `qe` latched signal of software write pulse
      hwre:     "true",
      fields: [
        {
          bits: "5+3:5", // 2 bits for status
          name: "CL_STATUS",
          desc: "Contain the current status of the corresponding cache line                [0]: valid, [1]: dirty, [2]: cmpt",
        }
      ]
    },
    { name:     "TAG_44",
      desc:     "Tag Address stored in cache line 44",
      swaccess: "rw",
      hwaccess: "hrw",
      hwext:    "true",
      hwqe:     "true", // enable `qe` latched signal of software write pulse
      hwre:     "true",
      fields: [
        { bits: "5-1:0",
          name: "CL_TAG",
          desc: "Tag Address"
        }
      ]
    },
    {
      name:     "STATUS_45",
      desc:     "Status register of cache line 45",
      swaccess: "rw",
      hwaccess: "hrw",
      hwext:    "true",
      hwqe:     "true", // enable `qe` latched signal of software write pulse
      hwre:     "true",
      fields: [
        {
          bits: "5+3:5", // 2 bits for status
          name: "CL_STATUS",
          desc: "Contain the current status of the corresponding cache line                [0]: valid, [1]: dirty, [2]: cmpt",
        }
      ]
    },
    { name:     "TAG_45",
      desc:     "Tag Address stored in cache line 45",
      swaccess: "rw",
      hwaccess: "hrw",
      hwext:    "true",
      hwqe:     "true", // enable `qe` latched signal of software write pulse
      hwre:     "true",
      fields: [
        { bits: "5-1:0",
          name: "CL_TAG",
          desc: "Tag Address"
        }
      ]
    },
    {
      name:     "STATUS_46",
      desc:     "Status register of cache line 46",
      swaccess: "rw",
      hwaccess: "hrw",
      hwext:    "true",
      hwqe:     "true", // enable `qe` latched signal of software write pulse
      hwre:     "true",
      fields: [
        {
          bits: "5+3:5", // 2 bits for status
          name: "CL_STATUS",
          desc: "Contain the current status of the corresponding cache line                [0]: valid, [1]: dirty, [2]: cmpt",
        }
      ]
    },
    { name:     "TAG_46",
      desc:     "Tag Address stored in cache line 46",
      swaccess: "rw",
      hwaccess: "hrw",
      hwext:    "true",
      hwqe:     "true", // enable `qe` latched signal of software write pulse
      hwre:     "true",
      fields: [
        { bits: "5-1:0",
          name: "CL_TAG",
          desc: "Tag Address"
        }
      ]
    },
    {
      name:     "STATUS_47",
      desc:     "Status register of cache line 47",
      swaccess: "rw",
      hwaccess: "hrw",
      hwext:    "true",
      hwqe:     "true", // enable `qe` latched signal of software write pulse
      hwre:     "true",
      fields: [
        {
          bits: "5+3:5", // 2 bits for status
          name: "CL_STATUS",
          desc: "Contain the current status of the corresponding cache line                [0]: valid, [1]: dirty, [2]: cmpt",
        }
      ]
    },
    { name:     "TAG_47",
      desc:     "Tag Address stored in cache line 47",
      swaccess: "rw",
      hwaccess: "hrw",
      hwext:    "true",
      hwqe:     "true", // enable `qe` latched signal of software write pulse
      hwre:     "true",
      fields: [
        { bits: "5-1:0",
          name: "CL_TAG",
          desc: "Tag Address"
        }
      ]
    },
    {
      name:     "STATUS_48",
      desc:     "Status register of cache line 48",
      swaccess: "rw",
      hwaccess: "hrw",
      hwext:    "true",
      hwqe:     "true", // enable `qe` latched signal of software write pulse
      hwre:     "true",
      fields: [
        {
          bits: "5+3:5", // 2 bits for status
          name: "CL_STATUS",
          desc: "Contain the current status of the corresponding cache line                [0]: valid, [1]: dirty, [2]: cmpt",
        }
      ]
    },
    { name:     "TAG_48",
      desc:     "Tag Address stored in cache line 48",
      swaccess: "rw",
      hwaccess: "hrw",
      hwext:    "true",
      hwqe:     "true", // enable `qe` latched signal of software write pulse
      hwre:     "true",
      fields: [
        { bits: "5-1:0",
          name: "CL_TAG",
          desc: "Tag Address"
        }
      ]
    },
    {
      name:     "STATUS_49",
      desc:     "Status register of cache line 49",
      swaccess: "rw",
      hwaccess: "hrw",
      hwext:    "true",
      hwqe:     "true", // enable `qe` latched signal of software write pulse
      hwre:     "true",
      fields: [
        {
          bits: "5+3:5", // 2 bits for status
          name: "CL_STATUS",
          desc: "Contain the current status of the corresponding cache line                [0]: valid, [1]: dirty, [2]: cmpt",
        }
      ]
    },
    { name:     "TAG_49",
      desc:     "Tag Address stored in cache line 49",
      swaccess: "rw",
      hwaccess: "hrw",
      hwext:    "true",
      hwqe:     "true", // enable `qe` latched signal of software write pulse
      hwre:     "true",
      fields: [
        { bits: "5-1:0",
          name: "CL_TAG",
          desc: "Tag Address"
        }
      ]
    },
    {
      name:     "STATUS_50",
      desc:     "Status register of cache line 50",
      swaccess: "rw",
      hwaccess: "hrw",
      hwext:    "true",
      hwqe:     "true", // enable `qe` latched signal of software write pulse
      hwre:     "true",
      fields: [
        {
          bits: "5+3:5", // 2 bits for status
          name: "CL_STATUS",
          desc: "Contain the current status of the corresponding cache line                [0]: valid, [1]: dirty, [2]: cmpt",
        }
      ]
    },
    { name:     "TAG_50",
      desc:     "Tag Address stored in cache line 50",
      swaccess: "rw",
      hwaccess: "hrw",
      hwext:    "true",
      hwqe:     "true", // enable `qe` latched signal of software write pulse
      hwre:     "true",
      fields: [
        { bits: "5-1:0",
          name: "CL_TAG",
          desc: "Tag Address"
        }
      ]
    },
    {
      name:     "STATUS_51",
      desc:     "Status register of cache line 51",
      swaccess: "rw",
      hwaccess: "hrw",
      hwext:    "true",
      hwqe:     "true", // enable `qe` latched signal of software write pulse
      hwre:     "true",
      fields: [
        {
          bits: "5+3:5", // 2 bits for status
          name: "CL_STATUS",
          desc: "Contain the current status of the corresponding cache line                [0]: valid, [1]: dirty, [2]: cmpt",
        }
      ]
    },
    { name:     "TAG_51",
      desc:     "Tag Address stored in cache line 51",
      swaccess: "rw",
      hwaccess: "hrw",
      hwext:    "true",
      hwqe:     "true", // enable `qe` latched signal of software write pulse
      hwre:     "true",
      fields: [
        { bits: "5-1:0",
          name: "CL_TAG",
          desc: "Tag Address"
        }
      ]
    },
    {
      name:     "STATUS_52",
      desc:     "Status register of cache line 52",
      swaccess: "rw",
      hwaccess: "hrw",
      hwext:    "true",
      hwqe:     "true", // enable `qe` latched signal of software write pulse
      hwre:     "true",
      fields: [
        {
          bits: "5+3:5", // 2 bits for status
          name: "CL_STATUS",
          desc: "Contain the current status of the corresponding cache line                [0]: valid, [1]: dirty, [2]: cmpt",
        }
      ]
    },
    { name:     "TAG_52",
      desc:     "Tag Address stored in cache line 52",
      swaccess: "rw",
      hwaccess: "hrw",
      hwext:    "true",
      hwqe:     "true", // enable `qe` latched signal of software write pulse
      hwre:     "true",
      fields: [
        { bits: "5-1:0",
          name: "CL_TAG",
          desc: "Tag Address"
        }
      ]
    },
    {
      name:     "STATUS_53",
      desc:     "Status register of cache line 53",
      swaccess: "rw",
      hwaccess: "hrw",
      hwext:    "true",
      hwqe:     "true", // enable `qe` latched signal of software write pulse
      hwre:     "true",
      fields: [
        {
          bits: "5+3:5", // 2 bits for status
          name: "CL_STATUS",
          desc: "Contain the current status of the corresponding cache line                [0]: valid, [1]: dirty, [2]: cmpt",
        }
      ]
    },
    { name:     "TAG_53",
      desc:     "Tag Address stored in cache line 53",
      swaccess: "rw",
      hwaccess: "hrw",
      hwext:    "true",
      hwqe:     "true", // enable `qe` latched signal of software write pulse
      hwre:     "true",
      fields: [
        { bits: "5-1:0",
          name: "CL_TAG",
          desc: "Tag Address"
        }
      ]
    },
    {
      name:     "STATUS_54",
      desc:     "Status register of cache line 54",
      swaccess: "rw",
      hwaccess: "hrw",
      hwext:    "true",
      hwqe:     "true", // enable `qe` latched signal of software write pulse
      hwre:     "true",
      fields: [
        {
          bits: "5+3:5", // 2 bits for status
          name: "CL_STATUS",
          desc: "Contain the current status of the corresponding cache line                [0]: valid, [1]: dirty, [2]: cmpt",
        }
      ]
    },
    { name:     "TAG_54",
      desc:     "Tag Address stored in cache line 54",
      swaccess: "rw",
      hwaccess: "hrw",
      hwext:    "true",
      hwqe:     "true", // enable `qe` latched signal of software write pulse
      hwre:     "true",
      fields: [
        { bits: "5-1:0",
          name: "CL_TAG",
          desc: "Tag Address"
        }
      ]
    },
    {
      name:     "STATUS_55",
      desc:     "Status register of cache line 55",
      swaccess: "rw",
      hwaccess: "hrw",
      hwext:    "true",
      hwqe:     "true", // enable `qe` latched signal of software write pulse
      hwre:     "true",
      fields: [
        {
          bits: "5+3:5", // 2 bits for status
          name: "CL_STATUS",
          desc: "Contain the current status of the corresponding cache line                [0]: valid, [1]: dirty, [2]: cmpt",
        }
      ]
    },
    { name:     "TAG_55",
      desc:     "Tag Address stored in cache line 55",
      swaccess: "rw",
      hwaccess: "hrw",
      hwext:    "true",
      hwqe:     "true", // enable `qe` latched signal of software write pulse
      hwre:     "true",
      fields: [
        { bits: "5-1:0",
          name: "CL_TAG",
          desc: "Tag Address"
        }
      ]
    },
    {
      name:     "STATUS_56",
      desc:     "Status register of cache line 56",
      swaccess: "rw",
      hwaccess: "hrw",
      hwext:    "true",
      hwqe:     "true", // enable `qe` latched signal of software write pulse
      hwre:     "true",
      fields: [
        {
          bits: "5+3:5", // 2 bits for status
          name: "CL_STATUS",
          desc: "Contain the current status of the corresponding cache line                [0]: valid, [1]: dirty, [2]: cmpt",
        }
      ]
    },
    { name:     "TAG_56",
      desc:     "Tag Address stored in cache line 56",
      swaccess: "rw",
      hwaccess: "hrw",
      hwext:    "true",
      hwqe:     "true", // enable `qe` latched signal of software write pulse
      hwre:     "true",
      fields: [
        { bits: "5-1:0",
          name: "CL_TAG",
          desc: "Tag Address"
        }
      ]
    },
    {
      name:     "STATUS_57",
      desc:     "Status register of cache line 57",
      swaccess: "rw",
      hwaccess: "hrw",
      hwext:    "true",
      hwqe:     "true", // enable `qe` latched signal of software write pulse
      hwre:     "true",
      fields: [
        {
          bits: "5+3:5", // 2 bits for status
          name: "CL_STATUS",
          desc: "Contain the current status of the corresponding cache line                [0]: valid, [1]: dirty, [2]: cmpt",
        }
      ]
    },
    { name:     "TAG_57",
      desc:     "Tag Address stored in cache line 57",
      swaccess: "rw",
      hwaccess: "hrw",
      hwext:    "true",
      hwqe:     "true", // enable `qe` latched signal of software write pulse
      hwre:     "true",
      fields: [
        { bits: "5-1:0",
          name: "CL_TAG",
          desc: "Tag Address"
        }
      ]
    },
    {
      name:     "STATUS_58",
      desc:     "Status register of cache line 58",
      swaccess: "rw",
      hwaccess: "hrw",
      hwext:    "true",
      hwqe:     "true", // enable `qe` latched signal of software write pulse
      hwre:     "true",
      fields: [
        {
          bits: "5+3:5", // 2 bits for status
          name: "CL_STATUS",
          desc: "Contain the current status of the corresponding cache line                [0]: valid, [1]: dirty, [2]: cmpt",
        }
      ]
    },
    { name:     "TAG_58",
      desc:     "Tag Address stored in cache line 58",
      swaccess: "rw",
      hwaccess: "hrw",
      hwext:    "true",
      hwqe:     "true", // enable `qe` latched signal of software write pulse
      hwre:     "true",
      fields: [
        { bits: "5-1:0",
          name: "CL_TAG",
          desc: "Tag Address"
        }
      ]
    },
    {
      name:     "STATUS_59",
      desc:     "Status register of cache line 59",
      swaccess: "rw",
      hwaccess: "hrw",
      hwext:    "true",
      hwqe:     "true", // enable `qe` latched signal of software write pulse
      hwre:     "true",
      fields: [
        {
          bits: "5+3:5", // 2 bits for status
          name: "CL_STATUS",
          desc: "Contain the current status of the corresponding cache line                [0]: valid, [1]: dirty, [2]: cmpt",
        }
      ]
    },
    { name:     "TAG_59",
      desc:     "Tag Address stored in cache line 59",
      swaccess: "rw",
      hwaccess: "hrw",
      hwext:    "true",
      hwqe:     "true", // enable `qe` latched signal of software write pulse
      hwre:     "true",
      fields: [
        { bits: "5-1:0",
          name: "CL_TAG",
          desc: "Tag Address"
        }
      ]
    },
    {
      name:     "STATUS_60",
      desc:     "Status register of cache line 60",
      swaccess: "rw",
      hwaccess: "hrw",
      hwext:    "true",
      hwqe:     "true", // enable `qe` latched signal of software write pulse
      hwre:     "true",
      fields: [
        {
          bits: "5+3:5", // 2 bits for status
          name: "CL_STATUS",
          desc: "Contain the current status of the corresponding cache line                [0]: valid, [1]: dirty, [2]: cmpt",
        }
      ]
    },
    { name:     "TAG_60",
      desc:     "Tag Address stored in cache line 60",
      swaccess: "rw",
      hwaccess: "hrw",
      hwext:    "true",
      hwqe:     "true", // enable `qe` latched signal of software write pulse
      hwre:     "true",
      fields: [
        { bits: "5-1:0",
          name: "CL_TAG",
          desc: "Tag Address"
        }
      ]
    },
    {
      name:     "STATUS_61",
      desc:     "Status register of cache line 61",
      swaccess: "rw",
      hwaccess: "hrw",
      hwext:    "true",
      hwqe:     "true", // enable `qe` latched signal of software write pulse
      hwre:     "true",
      fields: [
        {
          bits: "5+3:5", // 2 bits for status
          name: "CL_STATUS",
          desc: "Contain the current status of the corresponding cache line                [0]: valid, [1]: dirty, [2]: cmpt",
        }
      ]
    },
    { name:     "TAG_61",
      desc:     "Tag Address stored in cache line 61",
      swaccess: "rw",
      hwaccess: "hrw",
      hwext:    "true",
      hwqe:     "true", // enable `qe` latched signal of software write pulse
      hwre:     "true",
      fields: [
        { bits: "5-1:0",
          name: "CL_TAG",
          desc: "Tag Address"
        }
      ]
    },
    {
      name:     "STATUS_62",
      desc:     "Status register of cache line 62",
      swaccess: "rw",
      hwaccess: "hrw",
      hwext:    "true",
      hwqe:     "true", // enable `qe` latched signal of software write pulse
      hwre:     "true",
      fields: [
        {
          bits: "5+3:5", // 2 bits for status
          name: "CL_STATUS",
          desc: "Contain the current status of the corresponding cache line                [0]: valid, [1]: dirty, [2]: cmpt",
        }
      ]
    },
    { name:     "TAG_62",
      desc:     "Tag Address stored in cache line 62",
      swaccess: "rw",
      hwaccess: "hrw",
      hwext:    "true",
      hwqe:     "true", // enable `qe` latched signal of software write pulse
      hwre:     "true",
      fields: [
        { bits: "5-1:0",
          name: "CL_TAG",
          desc: "Tag Address"
        }
      ]
    },
    {
      name:     "STATUS_63",
      desc:     "Status register of cache line 63",
      swaccess: "rw",
      hwaccess: "hrw",
      hwext:    "true",
      hwqe:     "true", // enable `qe` latched signal of software write pulse
      hwre:     "true",
      fields: [
        {
          bits: "5+3:5", // 2 bits for status
          name: "CL_STATUS",
          desc: "Contain the current status of the corresponding cache line                [0]: valid, [1]: dirty, [2]: cmpt",
        }
      ]
    },
    { name:     "TAG_63",
      desc:     "Tag Address stored in cache line 63",
      swaccess: "rw",
      hwaccess: "hrw",
      hwext:    "true",
      hwqe:     "true", // enable `qe` latched signal of software write pulse
      hwre:     "true",
      fields: [
        { bits: "5-1:0",
          name: "CL_TAG",
          desc: "Tag Address"
        }
      ]
    },
    {
      name:     "STATUS_64",
      desc:     "Status register of cache line 64",
      swaccess: "rw",
      hwaccess: "hrw",
      hwext:    "true",
      hwqe:     "true", // enable `qe` latched signal of software write pulse
      hwre:     "true",
      fields: [
        {
          bits: "5+3:5", // 2 bits for status
          name: "CL_STATUS",
          desc: "Contain the current status of the corresponding cache line                [0]: valid, [1]: dirty, [2]: cmpt",
        }
      ]
    },
    { name:     "TAG_64",
      desc:     "Tag Address stored in cache line 64",
      swaccess: "rw",
      hwaccess: "hrw",
      hwext:    "true",
      hwqe:     "true", // enable `qe` latched signal of software write pulse
      hwre:     "true",
      fields: [
        { bits: "5-1:0",
          name: "CL_TAG",
          desc: "Tag Address"
        }
      ]
    },
    {
      name:     "STATUS_65",
      desc:     "Status register of cache line 65",
      swaccess: "rw",
      hwaccess: "hrw",
      hwext:    "true",
      hwqe:     "true", // enable `qe` latched signal of software write pulse
      hwre:     "true",
      fields: [
        {
          bits: "5+3:5", // 2 bits for status
          name: "CL_STATUS",
          desc: "Contain the current status of the corresponding cache line                [0]: valid, [1]: dirty, [2]: cmpt",
        }
      ]
    },
    { name:     "TAG_65",
      desc:     "Tag Address stored in cache line 65",
      swaccess: "rw",
      hwaccess: "hrw",
      hwext:    "true",
      hwqe:     "true", // enable `qe` latched signal of software write pulse
      hwre:     "true",
      fields: [
        { bits: "5-1:0",
          name: "CL_TAG",
          desc: "Tag Address"
        }
      ]
    },
    {
      name:     "STATUS_66",
      desc:     "Status register of cache line 66",
      swaccess: "rw",
      hwaccess: "hrw",
      hwext:    "true",
      hwqe:     "true", // enable `qe` latched signal of software write pulse
      hwre:     "true",
      fields: [
        {
          bits: "5+3:5", // 2 bits for status
          name: "CL_STATUS",
          desc: "Contain the current status of the corresponding cache line                [0]: valid, [1]: dirty, [2]: cmpt",
        }
      ]
    },
    { name:     "TAG_66",
      desc:     "Tag Address stored in cache line 66",
      swaccess: "rw",
      hwaccess: "hrw",
      hwext:    "true",
      hwqe:     "true", // enable `qe` latched signal of software write pulse
      hwre:     "true",
      fields: [
        { bits: "5-1:0",
          name: "CL_TAG",
          desc: "Tag Address"
        }
      ]
    },
    {
      name:     "STATUS_67",
      desc:     "Status register of cache line 67",
      swaccess: "rw",
      hwaccess: "hrw",
      hwext:    "true",
      hwqe:     "true", // enable `qe` latched signal of software write pulse
      hwre:     "true",
      fields: [
        {
          bits: "5+3:5", // 2 bits for status
          name: "CL_STATUS",
          desc: "Contain the current status of the corresponding cache line                [0]: valid, [1]: dirty, [2]: cmpt",
        }
      ]
    },
    { name:     "TAG_67",
      desc:     "Tag Address stored in cache line 67",
      swaccess: "rw",
      hwaccess: "hrw",
      hwext:    "true",
      hwqe:     "true", // enable `qe` latched signal of software write pulse
      hwre:     "true",
      fields: [
        { bits: "5-1:0",
          name: "CL_TAG",
          desc: "Tag Address"
        }
      ]
    },
    {
      name:     "STATUS_68",
      desc:     "Status register of cache line 68",
      swaccess: "rw",
      hwaccess: "hrw",
      hwext:    "true",
      hwqe:     "true", // enable `qe` latched signal of software write pulse
      hwre:     "true",
      fields: [
        {
          bits: "5+3:5", // 2 bits for status
          name: "CL_STATUS",
          desc: "Contain the current status of the corresponding cache line                [0]: valid, [1]: dirty, [2]: cmpt",
        }
      ]
    },
    { name:     "TAG_68",
      desc:     "Tag Address stored in cache line 68",
      swaccess: "rw",
      hwaccess: "hrw",
      hwext:    "true",
      hwqe:     "true", // enable `qe` latched signal of software write pulse
      hwre:     "true",
      fields: [
        { bits: "5-1:0",
          name: "CL_TAG",
          desc: "Tag Address"
        }
      ]
    },
    {
      name:     "STATUS_69",
      desc:     "Status register of cache line 69",
      swaccess: "rw",
      hwaccess: "hrw",
      hwext:    "true",
      hwqe:     "true", // enable `qe` latched signal of software write pulse
      hwre:     "true",
      fields: [
        {
          bits: "5+3:5", // 2 bits for status
          name: "CL_STATUS",
          desc: "Contain the current status of the corresponding cache line                [0]: valid, [1]: dirty, [2]: cmpt",
        }
      ]
    },
    { name:     "TAG_69",
      desc:     "Tag Address stored in cache line 69",
      swaccess: "rw",
      hwaccess: "hrw",
      hwext:    "true",
      hwqe:     "true", // enable `qe` latched signal of software write pulse
      hwre:     "true",
      fields: [
        { bits: "5-1:0",
          name: "CL_TAG",
          desc: "Tag Address"
        }
      ]
    },
    {
      name:     "STATUS_70",
      desc:     "Status register of cache line 70",
      swaccess: "rw",
      hwaccess: "hrw",
      hwext:    "true",
      hwqe:     "true", // enable `qe` latched signal of software write pulse
      hwre:     "true",
      fields: [
        {
          bits: "5+3:5", // 2 bits for status
          name: "CL_STATUS",
          desc: "Contain the current status of the corresponding cache line                [0]: valid, [1]: dirty, [2]: cmpt",
        }
      ]
    },
    { name:     "TAG_70",
      desc:     "Tag Address stored in cache line 70",
      swaccess: "rw",
      hwaccess: "hrw",
      hwext:    "true",
      hwqe:     "true", // enable `qe` latched signal of software write pulse
      hwre:     "true",
      fields: [
        { bits: "5-1:0",
          name: "CL_TAG",
          desc: "Tag Address"
        }
      ]
    },
    {
      name:     "STATUS_71",
      desc:     "Status register of cache line 71",
      swaccess: "rw",
      hwaccess: "hrw",
      hwext:    "true",
      hwqe:     "true", // enable `qe` latched signal of software write pulse
      hwre:     "true",
      fields: [
        {
          bits: "5+3:5", // 2 bits for status
          name: "CL_STATUS",
          desc: "Contain the current status of the corresponding cache line                [0]: valid, [1]: dirty, [2]: cmpt",
        }
      ]
    },
    { name:     "TAG_71",
      desc:     "Tag Address stored in cache line 71",
      swaccess: "rw",
      hwaccess: "hrw",
      hwext:    "true",
      hwqe:     "true", // enable `qe` latched signal of software write pulse
      hwre:     "true",
      fields: [
        { bits: "5-1:0",
          name: "CL_TAG",
          desc: "Tag Address"
        }
      ]
    },
    {
      name:     "STATUS_72",
      desc:     "Status register of cache line 72",
      swaccess: "rw",
      hwaccess: "hrw",
      hwext:    "true",
      hwqe:     "true", // enable `qe` latched signal of software write pulse
      hwre:     "true",
      fields: [
        {
          bits: "5+3:5", // 2 bits for status
          name: "CL_STATUS",
          desc: "Contain the current status of the corresponding cache line                [0]: valid, [1]: dirty, [2]: cmpt",
        }
      ]
    },
    { name:     "TAG_72",
      desc:     "Tag Address stored in cache line 72",
      swaccess: "rw",
      hwaccess: "hrw",
      hwext:    "true",
      hwqe:     "true", // enable `qe` latched signal of software write pulse
      hwre:     "true",
      fields: [
        { bits: "5-1:0",
          name: "CL_TAG",
          desc: "Tag Address"
        }
      ]
    },
    {
      name:     "STATUS_73",
      desc:     "Status register of cache line 73",
      swaccess: "rw",
      hwaccess: "hrw",
      hwext:    "true",
      hwqe:     "true", // enable `qe` latched signal of software write pulse
      hwre:     "true",
      fields: [
        {
          bits: "5+3:5", // 2 bits for status
          name: "CL_STATUS",
          desc: "Contain the current status of the corresponding cache line                [0]: valid, [1]: dirty, [2]: cmpt",
        }
      ]
    },
    { name:     "TAG_73",
      desc:     "Tag Address stored in cache line 73",
      swaccess: "rw",
      hwaccess: "hrw",
      hwext:    "true",
      hwqe:     "true", // enable `qe` latched signal of software write pulse
      hwre:     "true",
      fields: [
        { bits: "5-1:0",
          name: "CL_TAG",
          desc: "Tag Address"
        }
      ]
    },
    {
      name:     "STATUS_74",
      desc:     "Status register of cache line 74",
      swaccess: "rw",
      hwaccess: "hrw",
      hwext:    "true",
      hwqe:     "true", // enable `qe` latched signal of software write pulse
      hwre:     "true",
      fields: [
        {
          bits: "5+3:5", // 2 bits for status
          name: "CL_STATUS",
          desc: "Contain the current status of the corresponding cache line                [0]: valid, [1]: dirty, [2]: cmpt",
        }
      ]
    },
    { name:     "TAG_74",
      desc:     "Tag Address stored in cache line 74",
      swaccess: "rw",
      hwaccess: "hrw",
      hwext:    "true",
      hwqe:     "true", // enable `qe` latched signal of software write pulse
      hwre:     "true",
      fields: [
        { bits: "5-1:0",
          name: "CL_TAG",
          desc: "Tag Address"
        }
      ]
    },
    {
      name:     "STATUS_75",
      desc:     "Status register of cache line 75",
      swaccess: "rw",
      hwaccess: "hrw",
      hwext:    "true",
      hwqe:     "true", // enable `qe` latched signal of software write pulse
      hwre:     "true",
      fields: [
        {
          bits: "5+3:5", // 2 bits for status
          name: "CL_STATUS",
          desc: "Contain the current status of the corresponding cache line                [0]: valid, [1]: dirty, [2]: cmpt",
        }
      ]
    },
    { name:     "TAG_75",
      desc:     "Tag Address stored in cache line 75",
      swaccess: "rw",
      hwaccess: "hrw",
      hwext:    "true",
      hwqe:     "true", // enable `qe` latched signal of software write pulse
      hwre:     "true",
      fields: [
        { bits: "5-1:0",
          name: "CL_TAG",
          desc: "Tag Address"
        }
      ]
    },
    {
      name:     "STATUS_76",
      desc:     "Status register of cache line 76",
      swaccess: "rw",
      hwaccess: "hrw",
      hwext:    "true",
      hwqe:     "true", // enable `qe` latched signal of software write pulse
      hwre:     "true",
      fields: [
        {
          bits: "5+3:5", // 2 bits for status
          name: "CL_STATUS",
          desc: "Contain the current status of the corresponding cache line                [0]: valid, [1]: dirty, [2]: cmpt",
        }
      ]
    },
    { name:     "TAG_76",
      desc:     "Tag Address stored in cache line 76",
      swaccess: "rw",
      hwaccess: "hrw",
      hwext:    "true",
      hwqe:     "true", // enable `qe` latched signal of software write pulse
      hwre:     "true",
      fields: [
        { bits: "5-1:0",
          name: "CL_TAG",
          desc: "Tag Address"
        }
      ]
    },
    {
      name:     "STATUS_77",
      desc:     "Status register of cache line 77",
      swaccess: "rw",
      hwaccess: "hrw",
      hwext:    "true",
      hwqe:     "true", // enable `qe` latched signal of software write pulse
      hwre:     "true",
      fields: [
        {
          bits: "5+3:5", // 2 bits for status
          name: "CL_STATUS",
          desc: "Contain the current status of the corresponding cache line                [0]: valid, [1]: dirty, [2]: cmpt",
        }
      ]
    },
    { name:     "TAG_77",
      desc:     "Tag Address stored in cache line 77",
      swaccess: "rw",
      hwaccess: "hrw",
      hwext:    "true",
      hwqe:     "true", // enable `qe` latched signal of software write pulse
      hwre:     "true",
      fields: [
        { bits: "5-1:0",
          name: "CL_TAG",
          desc: "Tag Address"
        }
      ]
    },
    {
      name:     "STATUS_78",
      desc:     "Status register of cache line 78",
      swaccess: "rw",
      hwaccess: "hrw",
      hwext:    "true",
      hwqe:     "true", // enable `qe` latched signal of software write pulse
      hwre:     "true",
      fields: [
        {
          bits: "5+3:5", // 2 bits for status
          name: "CL_STATUS",
          desc: "Contain the current status of the corresponding cache line                [0]: valid, [1]: dirty, [2]: cmpt",
        }
      ]
    },
    { name:     "TAG_78",
      desc:     "Tag Address stored in cache line 78",
      swaccess: "rw",
      hwaccess: "hrw",
      hwext:    "true",
      hwqe:     "true", // enable `qe` latched signal of software write pulse
      hwre:     "true",
      fields: [
        { bits: "5-1:0",
          name: "CL_TAG",
          desc: "Tag Address"
        }
      ]
    },
    {
      name:     "STATUS_79",
      desc:     "Status register of cache line 79",
      swaccess: "rw",
      hwaccess: "hrw",
      hwext:    "true",
      hwqe:     "true", // enable `qe` latched signal of software write pulse
      hwre:     "true",
      fields: [
        {
          bits: "5+3:5", // 2 bits for status
          name: "CL_STATUS",
          desc: "Contain the current status of the corresponding cache line                [0]: valid, [1]: dirty, [2]: cmpt",
        }
      ]
    },
    { name:     "TAG_79",
      desc:     "Tag Address stored in cache line 79",
      swaccess: "rw",
      hwaccess: "hrw",
      hwext:    "true",
      hwqe:     "true", // enable `qe` latched signal of software write pulse
      hwre:     "true",
      fields: [
        { bits: "5-1:0",
          name: "CL_TAG",
          desc: "Tag Address"
        }
      ]
    },
    {
      name:     "STATUS_80",
      desc:     "Status register of cache line 80",
      swaccess: "rw",
      hwaccess: "hrw",
      hwext:    "true",
      hwqe:     "true", // enable `qe` latched signal of software write pulse
      hwre:     "true",
      fields: [
        {
          bits: "5+3:5", // 2 bits for status
          name: "CL_STATUS",
          desc: "Contain the current status of the corresponding cache line                [0]: valid, [1]: dirty, [2]: cmpt",
        }
      ]
    },
    { name:     "TAG_80",
      desc:     "Tag Address stored in cache line 80",
      swaccess: "rw",
      hwaccess: "hrw",
      hwext:    "true",
      hwqe:     "true", // enable `qe` latched signal of software write pulse
      hwre:     "true",
      fields: [
        { bits: "5-1:0",
          name: "CL_TAG",
          desc: "Tag Address"
        }
      ]
    },
    {
      name:     "STATUS_81",
      desc:     "Status register of cache line 81",
      swaccess: "rw",
      hwaccess: "hrw",
      hwext:    "true",
      hwqe:     "true", // enable `qe` latched signal of software write pulse
      hwre:     "true",
      fields: [
        {
          bits: "5+3:5", // 2 bits for status
          name: "CL_STATUS",
          desc: "Contain the current status of the corresponding cache line                [0]: valid, [1]: dirty, [2]: cmpt",
        }
      ]
    },
    { name:     "TAG_81",
      desc:     "Tag Address stored in cache line 81",
      swaccess: "rw",
      hwaccess: "hrw",
      hwext:    "true",
      hwqe:     "true", // enable `qe` latched signal of software write pulse
      hwre:     "true",
      fields: [
        { bits: "5-1:0",
          name: "CL_TAG",
          desc: "Tag Address"
        }
      ]
    },
    {
      name:     "STATUS_82",
      desc:     "Status register of cache line 82",
      swaccess: "rw",
      hwaccess: "hrw",
      hwext:    "true",
      hwqe:     "true", // enable `qe` latched signal of software write pulse
      hwre:     "true",
      fields: [
        {
          bits: "5+3:5", // 2 bits for status
          name: "CL_STATUS",
          desc: "Contain the current status of the corresponding cache line                [0]: valid, [1]: dirty, [2]: cmpt",
        }
      ]
    },
    { name:     "TAG_82",
      desc:     "Tag Address stored in cache line 82",
      swaccess: "rw",
      hwaccess: "hrw",
      hwext:    "true",
      hwqe:     "true", // enable `qe` latched signal of software write pulse
      hwre:     "true",
      fields: [
        { bits: "5-1:0",
          name: "CL_TAG",
          desc: "Tag Address"
        }
      ]
    },
    {
      name:     "STATUS_83",
      desc:     "Status register of cache line 83",
      swaccess: "rw",
      hwaccess: "hrw",
      hwext:    "true",
      hwqe:     "true", // enable `qe` latched signal of software write pulse
      hwre:     "true",
      fields: [
        {
          bits: "5+3:5", // 2 bits for status
          name: "CL_STATUS",
          desc: "Contain the current status of the corresponding cache line                [0]: valid, [1]: dirty, [2]: cmpt",
        }
      ]
    },
    { name:     "TAG_83",
      desc:     "Tag Address stored in cache line 83",
      swaccess: "rw",
      hwaccess: "hrw",
      hwext:    "true",
      hwqe:     "true", // enable `qe` latched signal of software write pulse
      hwre:     "true",
      fields: [
        { bits: "5-1:0",
          name: "CL_TAG",
          desc: "Tag Address"
        }
      ]
    },
    {
      name:     "STATUS_84",
      desc:     "Status register of cache line 84",
      swaccess: "rw",
      hwaccess: "hrw",
      hwext:    "true",
      hwqe:     "true", // enable `qe` latched signal of software write pulse
      hwre:     "true",
      fields: [
        {
          bits: "5+3:5", // 2 bits for status
          name: "CL_STATUS",
          desc: "Contain the current status of the corresponding cache line                [0]: valid, [1]: dirty, [2]: cmpt",
        }
      ]
    },
    { name:     "TAG_84",
      desc:     "Tag Address stored in cache line 84",
      swaccess: "rw",
      hwaccess: "hrw",
      hwext:    "true",
      hwqe:     "true", // enable `qe` latched signal of software write pulse
      hwre:     "true",
      fields: [
        { bits: "5-1:0",
          name: "CL_TAG",
          desc: "Tag Address"
        }
      ]
    },
    {
      name:     "STATUS_85",
      desc:     "Status register of cache line 85",
      swaccess: "rw",
      hwaccess: "hrw",
      hwext:    "true",
      hwqe:     "true", // enable `qe` latched signal of software write pulse
      hwre:     "true",
      fields: [
        {
          bits: "5+3:5", // 2 bits for status
          name: "CL_STATUS",
          desc: "Contain the current status of the corresponding cache line                [0]: valid, [1]: dirty, [2]: cmpt",
        }
      ]
    },
    { name:     "TAG_85",
      desc:     "Tag Address stored in cache line 85",
      swaccess: "rw",
      hwaccess: "hrw",
      hwext:    "true",
      hwqe:     "true", // enable `qe` latched signal of software write pulse
      hwre:     "true",
      fields: [
        { bits: "5-1:0",
          name: "CL_TAG",
          desc: "Tag Address"
        }
      ]
    },
    {
      name:     "STATUS_86",
      desc:     "Status register of cache line 86",
      swaccess: "rw",
      hwaccess: "hrw",
      hwext:    "true",
      hwqe:     "true", // enable `qe` latched signal of software write pulse
      hwre:     "true",
      fields: [
        {
          bits: "5+3:5", // 2 bits for status
          name: "CL_STATUS",
          desc: "Contain the current status of the corresponding cache line                [0]: valid, [1]: dirty, [2]: cmpt",
        }
      ]
    },
    { name:     "TAG_86",
      desc:     "Tag Address stored in cache line 86",
      swaccess: "rw",
      hwaccess: "hrw",
      hwext:    "true",
      hwqe:     "true", // enable `qe` latched signal of software write pulse
      hwre:     "true",
      fields: [
        { bits: "5-1:0",
          name: "CL_TAG",
          desc: "Tag Address"
        }
      ]
    },
    {
      name:     "STATUS_87",
      desc:     "Status register of cache line 87",
      swaccess: "rw",
      hwaccess: "hrw",
      hwext:    "true",
      hwqe:     "true", // enable `qe` latched signal of software write pulse
      hwre:     "true",
      fields: [
        {
          bits: "5+3:5", // 2 bits for status
          name: "CL_STATUS",
          desc: "Contain the current status of the corresponding cache line                [0]: valid, [1]: dirty, [2]: cmpt",
        }
      ]
    },
    { name:     "TAG_87",
      desc:     "Tag Address stored in cache line 87",
      swaccess: "rw",
      hwaccess: "hrw",
      hwext:    "true",
      hwqe:     "true", // enable `qe` latched signal of software write pulse
      hwre:     "true",
      fields: [
        { bits: "5-1:0",
          name: "CL_TAG",
          desc: "Tag Address"
        }
      ]
    },
    {
      name:     "STATUS_88",
      desc:     "Status register of cache line 88",
      swaccess: "rw",
      hwaccess: "hrw",
      hwext:    "true",
      hwqe:     "true", // enable `qe` latched signal of software write pulse
      hwre:     "true",
      fields: [
        {
          bits: "5+3:5", // 2 bits for status
          name: "CL_STATUS",
          desc: "Contain the current status of the corresponding cache line                [0]: valid, [1]: dirty, [2]: cmpt",
        }
      ]
    },
    { name:     "TAG_88",
      desc:     "Tag Address stored in cache line 88",
      swaccess: "rw",
      hwaccess: "hrw",
      hwext:    "true",
      hwqe:     "true", // enable `qe` latched signal of software write pulse
      hwre:     "true",
      fields: [
        { bits: "5-1:0",
          name: "CL_TAG",
          desc: "Tag Address"
        }
      ]
    },
    {
      name:     "STATUS_89",
      desc:     "Status register of cache line 89",
      swaccess: "rw",
      hwaccess: "hrw",
      hwext:    "true",
      hwqe:     "true", // enable `qe` latched signal of software write pulse
      hwre:     "true",
      fields: [
        {
          bits: "5+3:5", // 2 bits for status
          name: "CL_STATUS",
          desc: "Contain the current status of the corresponding cache line                [0]: valid, [1]: dirty, [2]: cmpt",
        }
      ]
    },
    { name:     "TAG_89",
      desc:     "Tag Address stored in cache line 89",
      swaccess: "rw",
      hwaccess: "hrw",
      hwext:    "true",
      hwqe:     "true", // enable `qe` latched signal of software write pulse
      hwre:     "true",
      fields: [
        { bits: "5-1:0",
          name: "CL_TAG",
          desc: "Tag Address"
        }
      ]
    },
    {
      name:     "STATUS_90",
      desc:     "Status register of cache line 90",
      swaccess: "rw",
      hwaccess: "hrw",
      hwext:    "true",
      hwqe:     "true", // enable `qe` latched signal of software write pulse
      hwre:     "true",
      fields: [
        {
          bits: "5+3:5", // 2 bits for status
          name: "CL_STATUS",
          desc: "Contain the current status of the corresponding cache line                [0]: valid, [1]: dirty, [2]: cmpt",
        }
      ]
    },
    { name:     "TAG_90",
      desc:     "Tag Address stored in cache line 90",
      swaccess: "rw",
      hwaccess: "hrw",
      hwext:    "true",
      hwqe:     "true", // enable `qe` latched signal of software write pulse
      hwre:     "true",
      fields: [
        { bits: "5-1:0",
          name: "CL_TAG",
          desc: "Tag Address"
        }
      ]
    },
    {
      name:     "STATUS_91",
      desc:     "Status register of cache line 91",
      swaccess: "rw",
      hwaccess: "hrw",
      hwext:    "true",
      hwqe:     "true", // enable `qe` latched signal of software write pulse
      hwre:     "true",
      fields: [
        {
          bits: "5+3:5", // 2 bits for status
          name: "CL_STATUS",
          desc: "Contain the current status of the corresponding cache line                [0]: valid, [1]: dirty, [2]: cmpt",
        }
      ]
    },
    { name:     "TAG_91",
      desc:     "Tag Address stored in cache line 91",
      swaccess: "rw",
      hwaccess: "hrw",
      hwext:    "true",
      hwqe:     "true", // enable `qe` latched signal of software write pulse
      hwre:     "true",
      fields: [
        { bits: "5-1:0",
          name: "CL_TAG",
          desc: "Tag Address"
        }
      ]
    },
    {
      name:     "STATUS_92",
      desc:     "Status register of cache line 92",
      swaccess: "rw",
      hwaccess: "hrw",
      hwext:    "true",
      hwqe:     "true", // enable `qe` latched signal of software write pulse
      hwre:     "true",
      fields: [
        {
          bits: "5+3:5", // 2 bits for status
          name: "CL_STATUS",
          desc: "Contain the current status of the corresponding cache line                [0]: valid, [1]: dirty, [2]: cmpt",
        }
      ]
    },
    { name:     "TAG_92",
      desc:     "Tag Address stored in cache line 92",
      swaccess: "rw",
      hwaccess: "hrw",
      hwext:    "true",
      hwqe:     "true", // enable `qe` latched signal of software write pulse
      hwre:     "true",
      fields: [
        { bits: "5-1:0",
          name: "CL_TAG",
          desc: "Tag Address"
        }
      ]
    },
    {
      name:     "STATUS_93",
      desc:     "Status register of cache line 93",
      swaccess: "rw",
      hwaccess: "hrw",
      hwext:    "true",
      hwqe:     "true", // enable `qe` latched signal of software write pulse
      hwre:     "true",
      fields: [
        {
          bits: "5+3:5", // 2 bits for status
          name: "CL_STATUS",
          desc: "Contain the current status of the corresponding cache line                [0]: valid, [1]: dirty, [2]: cmpt",
        }
      ]
    },
    { name:     "TAG_93",
      desc:     "Tag Address stored in cache line 93",
      swaccess: "rw",
      hwaccess: "hrw",
      hwext:    "true",
      hwqe:     "true", // enable `qe` latched signal of software write pulse
      hwre:     "true",
      fields: [
        { bits: "5-1:0",
          name: "CL_TAG",
          desc: "Tag Address"
        }
      ]
    },
    {
      name:     "STATUS_94",
      desc:     "Status register of cache line 94",
      swaccess: "rw",
      hwaccess: "hrw",
      hwext:    "true",
      hwqe:     "true", // enable `qe` latched signal of software write pulse
      hwre:     "true",
      fields: [
        {
          bits: "5+3:5", // 2 bits for status
          name: "CL_STATUS",
          desc: "Contain the current status of the corresponding cache line                [0]: valid, [1]: dirty, [2]: cmpt",
        }
      ]
    },
    { name:     "TAG_94",
      desc:     "Tag Address stored in cache line 94",
      swaccess: "rw",
      hwaccess: "hrw",
      hwext:    "true",
      hwqe:     "true", // enable `qe` latched signal of software write pulse
      hwre:     "true",
      fields: [
        { bits: "5-1:0",
          name: "CL_TAG",
          desc: "Tag Address"
        }
      ]
    },
    {
      name:     "STATUS_95",
      desc:     "Status register of cache line 95",
      swaccess: "rw",
      hwaccess: "hrw",
      hwext:    "true",
      hwqe:     "true", // enable `qe` latched signal of software write pulse
      hwre:     "true",
      fields: [
        {
          bits: "5+3:5", // 2 bits for status
          name: "CL_STATUS",
          desc: "Contain the current status of the corresponding cache line                [0]: valid, [1]: dirty, [2]: cmpt",
        }
      ]
    },
    { name:     "TAG_95",
      desc:     "Tag Address stored in cache line 95",
      swaccess: "rw",
      hwaccess: "hrw",
      hwext:    "true",
      hwqe:     "true", // enable `qe` latched signal of software write pulse
      hwre:     "true",
      fields: [
        { bits: "5-1:0",
          name: "CL_TAG",
          desc: "Tag Address"
        }
      ]
    },
    {
      name:     "STATUS_96",
      desc:     "Status register of cache line 96",
      swaccess: "rw",
      hwaccess: "hrw",
      hwext:    "true",
      hwqe:     "true", // enable `qe` latched signal of software write pulse
      hwre:     "true",
      fields: [
        {
          bits: "5+3:5", // 2 bits for status
          name: "CL_STATUS",
          desc: "Contain the current status of the corresponding cache line                [0]: valid, [1]: dirty, [2]: cmpt",
        }
      ]
    },
    { name:     "TAG_96",
      desc:     "Tag Address stored in cache line 96",
      swaccess: "rw",
      hwaccess: "hrw",
      hwext:    "true",
      hwqe:     "true", // enable `qe` latched signal of software write pulse
      hwre:     "true",
      fields: [
        { bits: "5-1:0",
          name: "CL_TAG",
          desc: "Tag Address"
        }
      ]
    },
    {
      name:     "STATUS_97",
      desc:     "Status register of cache line 97",
      swaccess: "rw",
      hwaccess: "hrw",
      hwext:    "true",
      hwqe:     "true", // enable `qe` latched signal of software write pulse
      hwre:     "true",
      fields: [
        {
          bits: "5+3:5", // 2 bits for status
          name: "CL_STATUS",
          desc: "Contain the current status of the corresponding cache line                [0]: valid, [1]: dirty, [2]: cmpt",
        }
      ]
    },
    { name:     "TAG_97",
      desc:     "Tag Address stored in cache line 97",
      swaccess: "rw",
      hwaccess: "hrw",
      hwext:    "true",
      hwqe:     "true", // enable `qe` latched signal of software write pulse
      hwre:     "true",
      fields: [
        { bits: "5-1:0",
          name: "CL_TAG",
          desc: "Tag Address"
        }
      ]
    },
    {
      name:     "STATUS_98",
      desc:     "Status register of cache line 98",
      swaccess: "rw",
      hwaccess: "hrw",
      hwext:    "true",
      hwqe:     "true", // enable `qe` latched signal of software write pulse
      hwre:     "true",
      fields: [
        {
          bits: "5+3:5", // 2 bits for status
          name: "CL_STATUS",
          desc: "Contain the current status of the corresponding cache line                [0]: valid, [1]: dirty, [2]: cmpt",
        }
      ]
    },
    { name:     "TAG_98",
      desc:     "Tag Address stored in cache line 98",
      swaccess: "rw",
      hwaccess: "hrw",
      hwext:    "true",
      hwqe:     "true", // enable `qe` latched signal of software write pulse
      hwre:     "true",
      fields: [
        { bits: "5-1:0",
          name: "CL_TAG",
          desc: "Tag Address"
        }
      ]
    },
    {
      name:     "STATUS_99",
      desc:     "Status register of cache line 99",
      swaccess: "rw",
      hwaccess: "hrw",
      hwext:    "true",
      hwqe:     "true", // enable `qe` latched signal of software write pulse
      hwre:     "true",
      fields: [
        {
          bits: "5+3:5", // 2 bits for status
          name: "CL_STATUS",
          desc: "Contain the current status of the corresponding cache line                [0]: valid, [1]: dirty, [2]: cmpt",
        }
      ]
    },
    { name:     "TAG_99",
      desc:     "Tag Address stored in cache line 99",
      swaccess: "rw",
      hwaccess: "hrw",
      hwext:    "true",
      hwqe:     "true", // enable `qe` latched signal of software write pulse
      hwre:     "true",
      fields: [
        { bits: "5-1:0",
          name: "CL_TAG",
          desc: "Tag Address"
        }
      ]
    },
    {
      name:     "STATUS_100",
      desc:     "Status register of cache line 100",
      swaccess: "rw",
      hwaccess: "hrw",
      hwext:    "true",
      hwqe:     "true", // enable `qe` latched signal of software write pulse
      hwre:     "true",
      fields: [
        {
          bits: "5+3:5", // 2 bits for status
          name: "CL_STATUS",
          desc: "Contain the current status of the corresponding cache line                [0]: valid, [1]: dirty, [2]: cmpt",
        }
      ]
    },
    { name:     "TAG_100",
      desc:     "Tag Address stored in cache line 100",
      swaccess: "rw",
      hwaccess: "hrw",
      hwext:    "true",
      hwqe:     "true", // enable `qe` latched signal of software write pulse
      hwre:     "true",
      fields: [
        { bits: "5-1:0",
          name: "CL_TAG",
          desc: "Tag Address"
        }
      ]
    },
    {
      name:     "STATUS_101",
      desc:     "Status register of cache line 101",
      swaccess: "rw",
      hwaccess: "hrw",
      hwext:    "true",
      hwqe:     "true", // enable `qe` latched signal of software write pulse
      hwre:     "true",
      fields: [
        {
          bits: "5+3:5", // 2 bits for status
          name: "CL_STATUS",
          desc: "Contain the current status of the corresponding cache line                [0]: valid, [1]: dirty, [2]: cmpt",
        }
      ]
    },
    { name:     "TAG_101",
      desc:     "Tag Address stored in cache line 101",
      swaccess: "rw",
      hwaccess: "hrw",
      hwext:    "true",
      hwqe:     "true", // enable `qe` latched signal of software write pulse
      hwre:     "true",
      fields: [
        { bits: "5-1:0",
          name: "CL_TAG",
          desc: "Tag Address"
        }
      ]
    },
    {
      name:     "STATUS_102",
      desc:     "Status register of cache line 102",
      swaccess: "rw",
      hwaccess: "hrw",
      hwext:    "true",
      hwqe:     "true", // enable `qe` latched signal of software write pulse
      hwre:     "true",
      fields: [
        {
          bits: "5+3:5", // 2 bits for status
          name: "CL_STATUS",
          desc: "Contain the current status of the corresponding cache line                [0]: valid, [1]: dirty, [2]: cmpt",
        }
      ]
    },
    { name:     "TAG_102",
      desc:     "Tag Address stored in cache line 102",
      swaccess: "rw",
      hwaccess: "hrw",
      hwext:    "true",
      hwqe:     "true", // enable `qe` latched signal of software write pulse
      hwre:     "true",
      fields: [
        { bits: "5-1:0",
          name: "CL_TAG",
          desc: "Tag Address"
        }
      ]
    },
    {
      name:     "STATUS_103",
      desc:     "Status register of cache line 103",
      swaccess: "rw",
      hwaccess: "hrw",
      hwext:    "true",
      hwqe:     "true", // enable `qe` latched signal of software write pulse
      hwre:     "true",
      fields: [
        {
          bits: "5+3:5", // 2 bits for status
          name: "CL_STATUS",
          desc: "Contain the current status of the corresponding cache line                [0]: valid, [1]: dirty, [2]: cmpt",
        }
      ]
    },
    { name:     "TAG_103",
      desc:     "Tag Address stored in cache line 103",
      swaccess: "rw",
      hwaccess: "hrw",
      hwext:    "true",
      hwqe:     "true", // enable `qe` latched signal of software write pulse
      hwre:     "true",
      fields: [
        { bits: "5-1:0",
          name: "CL_TAG",
          desc: "Tag Address"
        }
      ]
    },
    {
      name:     "STATUS_104",
      desc:     "Status register of cache line 104",
      swaccess: "rw",
      hwaccess: "hrw",
      hwext:    "true",
      hwqe:     "true", // enable `qe` latched signal of software write pulse
      hwre:     "true",
      fields: [
        {
          bits: "5+3:5", // 2 bits for status
          name: "CL_STATUS",
          desc: "Contain the current status of the corresponding cache line                [0]: valid, [1]: dirty, [2]: cmpt",
        }
      ]
    },
    { name:     "TAG_104",
      desc:     "Tag Address stored in cache line 104",
      swaccess: "rw",
      hwaccess: "hrw",
      hwext:    "true",
      hwqe:     "true", // enable `qe` latched signal of software write pulse
      hwre:     "true",
      fields: [
        { bits: "5-1:0",
          name: "CL_TAG",
          desc: "Tag Address"
        }
      ]
    },
    {
      name:     "STATUS_105",
      desc:     "Status register of cache line 105",
      swaccess: "rw",
      hwaccess: "hrw",
      hwext:    "true",
      hwqe:     "true", // enable `qe` latched signal of software write pulse
      hwre:     "true",
      fields: [
        {
          bits: "5+3:5", // 2 bits for status
          name: "CL_STATUS",
          desc: "Contain the current status of the corresponding cache line                [0]: valid, [1]: dirty, [2]: cmpt",
        }
      ]
    },
    { name:     "TAG_105",
      desc:     "Tag Address stored in cache line 105",
      swaccess: "rw",
      hwaccess: "hrw",
      hwext:    "true",
      hwqe:     "true", // enable `qe` latched signal of software write pulse
      hwre:     "true",
      fields: [
        { bits: "5-1:0",
          name: "CL_TAG",
          desc: "Tag Address"
        }
      ]
    },
    {
      name:     "STATUS_106",
      desc:     "Status register of cache line 106",
      swaccess: "rw",
      hwaccess: "hrw",
      hwext:    "true",
      hwqe:     "true", // enable `qe` latched signal of software write pulse
      hwre:     "true",
      fields: [
        {
          bits: "5+3:5", // 2 bits for status
          name: "CL_STATUS",
          desc: "Contain the current status of the corresponding cache line                [0]: valid, [1]: dirty, [2]: cmpt",
        }
      ]
    },
    { name:     "TAG_106",
      desc:     "Tag Address stored in cache line 106",
      swaccess: "rw",
      hwaccess: "hrw",
      hwext:    "true",
      hwqe:     "true", // enable `qe` latched signal of software write pulse
      hwre:     "true",
      fields: [
        { bits: "5-1:0",
          name: "CL_TAG",
          desc: "Tag Address"
        }
      ]
    },
    {
      name:     "STATUS_107",
      desc:     "Status register of cache line 107",
      swaccess: "rw",
      hwaccess: "hrw",
      hwext:    "true",
      hwqe:     "true", // enable `qe` latched signal of software write pulse
      hwre:     "true",
      fields: [
        {
          bits: "5+3:5", // 2 bits for status
          name: "CL_STATUS",
          desc: "Contain the current status of the corresponding cache line                [0]: valid, [1]: dirty, [2]: cmpt",
        }
      ]
    },
    { name:     "TAG_107",
      desc:     "Tag Address stored in cache line 107",
      swaccess: "rw",
      hwaccess: "hrw",
      hwext:    "true",
      hwqe:     "true", // enable `qe` latched signal of software write pulse
      hwre:     "true",
      fields: [
        { bits: "5-1:0",
          name: "CL_TAG",
          desc: "Tag Address"
        }
      ]
    },
    {
      name:     "STATUS_108",
      desc:     "Status register of cache line 108",
      swaccess: "rw",
      hwaccess: "hrw",
      hwext:    "true",
      hwqe:     "true", // enable `qe` latched signal of software write pulse
      hwre:     "true",
      fields: [
        {
          bits: "5+3:5", // 2 bits for status
          name: "CL_STATUS",
          desc: "Contain the current status of the corresponding cache line                [0]: valid, [1]: dirty, [2]: cmpt",
        }
      ]
    },
    { name:     "TAG_108",
      desc:     "Tag Address stored in cache line 108",
      swaccess: "rw",
      hwaccess: "hrw",
      hwext:    "true",
      hwqe:     "true", // enable `qe` latched signal of software write pulse
      hwre:     "true",
      fields: [
        { bits: "5-1:0",
          name: "CL_TAG",
          desc: "Tag Address"
        }
      ]
    },
    {
      name:     "STATUS_109",
      desc:     "Status register of cache line 109",
      swaccess: "rw",
      hwaccess: "hrw",
      hwext:    "true",
      hwqe:     "true", // enable `qe` latched signal of software write pulse
      hwre:     "true",
      fields: [
        {
          bits: "5+3:5", // 2 bits for status
          name: "CL_STATUS",
          desc: "Contain the current status of the corresponding cache line                [0]: valid, [1]: dirty, [2]: cmpt",
        }
      ]
    },
    { name:     "TAG_109",
      desc:     "Tag Address stored in cache line 109",
      swaccess: "rw",
      hwaccess: "hrw",
      hwext:    "true",
      hwqe:     "true", // enable `qe` latched signal of software write pulse
      hwre:     "true",
      fields: [
        { bits: "5-1:0",
          name: "CL_TAG",
          desc: "Tag Address"
        }
      ]
    },
    {
      name:     "STATUS_110",
      desc:     "Status register of cache line 110",
      swaccess: "rw",
      hwaccess: "hrw",
      hwext:    "true",
      hwqe:     "true", // enable `qe` latched signal of software write pulse
      hwre:     "true",
      fields: [
        {
          bits: "5+3:5", // 2 bits for status
          name: "CL_STATUS",
          desc: "Contain the current status of the corresponding cache line                [0]: valid, [1]: dirty, [2]: cmpt",
        }
      ]
    },
    { name:     "TAG_110",
      desc:     "Tag Address stored in cache line 110",
      swaccess: "rw",
      hwaccess: "hrw",
      hwext:    "true",
      hwqe:     "true", // enable `qe` latched signal of software write pulse
      hwre:     "true",
      fields: [
        { bits: "5-1:0",
          name: "CL_TAG",
          desc: "Tag Address"
        }
      ]
    },
    {
      name:     "STATUS_111",
      desc:     "Status register of cache line 111",
      swaccess: "rw",
      hwaccess: "hrw",
      hwext:    "true",
      hwqe:     "true", // enable `qe` latched signal of software write pulse
      hwre:     "true",
      fields: [
        {
          bits: "5+3:5", // 2 bits for status
          name: "CL_STATUS",
          desc: "Contain the current status of the corresponding cache line                [0]: valid, [1]: dirty, [2]: cmpt",
        }
      ]
    },
    { name:     "TAG_111",
      desc:     "Tag Address stored in cache line 111",
      swaccess: "rw",
      hwaccess: "hrw",
      hwext:    "true",
      hwqe:     "true", // enable `qe` latched signal of software write pulse
      hwre:     "true",
      fields: [
        { bits: "5-1:0",
          name: "CL_TAG",
          desc: "Tag Address"
        }
      ]
    },
    {
      name:     "STATUS_112",
      desc:     "Status register of cache line 112",
      swaccess: "rw",
      hwaccess: "hrw",
      hwext:    "true",
      hwqe:     "true", // enable `qe` latched signal of software write pulse
      hwre:     "true",
      fields: [
        {
          bits: "5+3:5", // 2 bits for status
          name: "CL_STATUS",
          desc: "Contain the current status of the corresponding cache line                [0]: valid, [1]: dirty, [2]: cmpt",
        }
      ]
    },
    { name:     "TAG_112",
      desc:     "Tag Address stored in cache line 112",
      swaccess: "rw",
      hwaccess: "hrw",
      hwext:    "true",
      hwqe:     "true", // enable `qe` latched signal of software write pulse
      hwre:     "true",
      fields: [
        { bits: "5-1:0",
          name: "CL_TAG",
          desc: "Tag Address"
        }
      ]
    },
    {
      name:     "STATUS_113",
      desc:     "Status register of cache line 113",
      swaccess: "rw",
      hwaccess: "hrw",
      hwext:    "true",
      hwqe:     "true", // enable `qe` latched signal of software write pulse
      hwre:     "true",
      fields: [
        {
          bits: "5+3:5", // 2 bits for status
          name: "CL_STATUS",
          desc: "Contain the current status of the corresponding cache line                [0]: valid, [1]: dirty, [2]: cmpt",
        }
      ]
    },
    { name:     "TAG_113",
      desc:     "Tag Address stored in cache line 113",
      swaccess: "rw",
      hwaccess: "hrw",
      hwext:    "true",
      hwqe:     "true", // enable `qe` latched signal of software write pulse
      hwre:     "true",
      fields: [
        { bits: "5-1:0",
          name: "CL_TAG",
          desc: "Tag Address"
        }
      ]
    },
    {
      name:     "STATUS_114",
      desc:     "Status register of cache line 114",
      swaccess: "rw",
      hwaccess: "hrw",
      hwext:    "true",
      hwqe:     "true", // enable `qe` latched signal of software write pulse
      hwre:     "true",
      fields: [
        {
          bits: "5+3:5", // 2 bits for status
          name: "CL_STATUS",
          desc: "Contain the current status of the corresponding cache line                [0]: valid, [1]: dirty, [2]: cmpt",
        }
      ]
    },
    { name:     "TAG_114",
      desc:     "Tag Address stored in cache line 114",
      swaccess: "rw",
      hwaccess: "hrw",
      hwext:    "true",
      hwqe:     "true", // enable `qe` latched signal of software write pulse
      hwre:     "true",
      fields: [
        { bits: "5-1:0",
          name: "CL_TAG",
          desc: "Tag Address"
        }
      ]
    },
    {
      name:     "STATUS_115",
      desc:     "Status register of cache line 115",
      swaccess: "rw",
      hwaccess: "hrw",
      hwext:    "true",
      hwqe:     "true", // enable `qe` latched signal of software write pulse
      hwre:     "true",
      fields: [
        {
          bits: "5+3:5", // 2 bits for status
          name: "CL_STATUS",
          desc: "Contain the current status of the corresponding cache line                [0]: valid, [1]: dirty, [2]: cmpt",
        }
      ]
    },
    { name:     "TAG_115",
      desc:     "Tag Address stored in cache line 115",
      swaccess: "rw",
      hwaccess: "hrw",
      hwext:    "true",
      hwqe:     "true", // enable `qe` latched signal of software write pulse
      hwre:     "true",
      fields: [
        { bits: "5-1:0",
          name: "CL_TAG",
          desc: "Tag Address"
        }
      ]
    },
    {
      name:     "STATUS_116",
      desc:     "Status register of cache line 116",
      swaccess: "rw",
      hwaccess: "hrw",
      hwext:    "true",
      hwqe:     "true", // enable `qe` latched signal of software write pulse
      hwre:     "true",
      fields: [
        {
          bits: "5+3:5", // 2 bits for status
          name: "CL_STATUS",
          desc: "Contain the current status of the corresponding cache line                [0]: valid, [1]: dirty, [2]: cmpt",
        }
      ]
    },
    { name:     "TAG_116",
      desc:     "Tag Address stored in cache line 116",
      swaccess: "rw",
      hwaccess: "hrw",
      hwext:    "true",
      hwqe:     "true", // enable `qe` latched signal of software write pulse
      hwre:     "true",
      fields: [
        { bits: "5-1:0",
          name: "CL_TAG",
          desc: "Tag Address"
        }
      ]
    },
    {
      name:     "STATUS_117",
      desc:     "Status register of cache line 117",
      swaccess: "rw",
      hwaccess: "hrw",
      hwext:    "true",
      hwqe:     "true", // enable `qe` latched signal of software write pulse
      hwre:     "true",
      fields: [
        {
          bits: "5+3:5", // 2 bits for status
          name: "CL_STATUS",
          desc: "Contain the current status of the corresponding cache line                [0]: valid, [1]: dirty, [2]: cmpt",
        }
      ]
    },
    { name:     "TAG_117",
      desc:     "Tag Address stored in cache line 117",
      swaccess: "rw",
      hwaccess: "hrw",
      hwext:    "true",
      hwqe:     "true", // enable `qe` latched signal of software write pulse
      hwre:     "true",
      fields: [
        { bits: "5-1:0",
          name: "CL_TAG",
          desc: "Tag Address"
        }
      ]
    },
    {
      name:     "STATUS_118",
      desc:     "Status register of cache line 118",
      swaccess: "rw",
      hwaccess: "hrw",
      hwext:    "true",
      hwqe:     "true", // enable `qe` latched signal of software write pulse
      hwre:     "true",
      fields: [
        {
          bits: "5+3:5", // 2 bits for status
          name: "CL_STATUS",
          desc: "Contain the current status of the corresponding cache line                [0]: valid, [1]: dirty, [2]: cmpt",
        }
      ]
    },
    { name:     "TAG_118",
      desc:     "Tag Address stored in cache line 118",
      swaccess: "rw",
      hwaccess: "hrw",
      hwext:    "true",
      hwqe:     "true", // enable `qe` latched signal of software write pulse
      hwre:     "true",
      fields: [
        { bits: "5-1:0",
          name: "CL_TAG",
          desc: "Tag Address"
        }
      ]
    },
    {
      name:     "STATUS_119",
      desc:     "Status register of cache line 119",
      swaccess: "rw",
      hwaccess: "hrw",
      hwext:    "true",
      hwqe:     "true", // enable `qe` latched signal of software write pulse
      hwre:     "true",
      fields: [
        {
          bits: "5+3:5", // 2 bits for status
          name: "CL_STATUS",
          desc: "Contain the current status of the corresponding cache line                [0]: valid, [1]: dirty, [2]: cmpt",
        }
      ]
    },
    { name:     "TAG_119",
      desc:     "Tag Address stored in cache line 119",
      swaccess: "rw",
      hwaccess: "hrw",
      hwext:    "true",
      hwqe:     "true", // enable `qe` latched signal of software write pulse
      hwre:     "true",
      fields: [
        { bits: "5-1:0",
          name: "CL_TAG",
          desc: "Tag Address"
        }
      ]
    },
    {
      name:     "STATUS_120",
      desc:     "Status register of cache line 120",
      swaccess: "rw",
      hwaccess: "hrw",
      hwext:    "true",
      hwqe:     "true", // enable `qe` latched signal of software write pulse
      hwre:     "true",
      fields: [
        {
          bits: "5+3:5", // 2 bits for status
          name: "CL_STATUS",
          desc: "Contain the current status of the corresponding cache line                [0]: valid, [1]: dirty, [2]: cmpt",
        }
      ]
    },
    { name:     "TAG_120",
      desc:     "Tag Address stored in cache line 120",
      swaccess: "rw",
      hwaccess: "hrw",
      hwext:    "true",
      hwqe:     "true", // enable `qe` latched signal of software write pulse
      hwre:     "true",
      fields: [
        { bits: "5-1:0",
          name: "CL_TAG",
          desc: "Tag Address"
        }
      ]
    },
    {
      name:     "STATUS_121",
      desc:     "Status register of cache line 121",
      swaccess: "rw",
      hwaccess: "hrw",
      hwext:    "true",
      hwqe:     "true", // enable `qe` latched signal of software write pulse
      hwre:     "true",
      fields: [
        {
          bits: "5+3:5", // 2 bits for status
          name: "CL_STATUS",
          desc: "Contain the current status of the corresponding cache line                [0]: valid, [1]: dirty, [2]: cmpt",
        }
      ]
    },
    { name:     "TAG_121",
      desc:     "Tag Address stored in cache line 121",
      swaccess: "rw",
      hwaccess: "hrw",
      hwext:    "true",
      hwqe:     "true", // enable `qe` latched signal of software write pulse
      hwre:     "true",
      fields: [
        { bits: "5-1:0",
          name: "CL_TAG",
          desc: "Tag Address"
        }
      ]
    },
    {
      name:     "STATUS_122",
      desc:     "Status register of cache line 122",
      swaccess: "rw",
      hwaccess: "hrw",
      hwext:    "true",
      hwqe:     "true", // enable `qe` latched signal of software write pulse
      hwre:     "true",
      fields: [
        {
          bits: "5+3:5", // 2 bits for status
          name: "CL_STATUS",
          desc: "Contain the current status of the corresponding cache line                [0]: valid, [1]: dirty, [2]: cmpt",
        }
      ]
    },
    { name:     "TAG_122",
      desc:     "Tag Address stored in cache line 122",
      swaccess: "rw",
      hwaccess: "hrw",
      hwext:    "true",
      hwqe:     "true", // enable `qe` latched signal of software write pulse
      hwre:     "true",
      fields: [
        { bits: "5-1:0",
          name: "CL_TAG",
          desc: "Tag Address"
        }
      ]
    },
    {
      name:     "STATUS_123",
      desc:     "Status register of cache line 123",
      swaccess: "rw",
      hwaccess: "hrw",
      hwext:    "true",
      hwqe:     "true", // enable `qe` latched signal of software write pulse
      hwre:     "true",
      fields: [
        {
          bits: "5+3:5", // 2 bits for status
          name: "CL_STATUS",
          desc: "Contain the current status of the corresponding cache line                [0]: valid, [1]: dirty, [2]: cmpt",
        }
      ]
    },
    { name:     "TAG_123",
      desc:     "Tag Address stored in cache line 123",
      swaccess: "rw",
      hwaccess: "hrw",
      hwext:    "true",
      hwqe:     "true", // enable `qe` latched signal of software write pulse
      hwre:     "true",
      fields: [
        { bits: "5-1:0",
          name: "CL_TAG",
          desc: "Tag Address"
        }
      ]
    },
    {
      name:     "STATUS_124",
      desc:     "Status register of cache line 124",
      swaccess: "rw",
      hwaccess: "hrw",
      hwext:    "true",
      hwqe:     "true", // enable `qe` latched signal of software write pulse
      hwre:     "true",
      fields: [
        {
          bits: "5+3:5", // 2 bits for status
          name: "CL_STATUS",
          desc: "Contain the current status of the corresponding cache line                [0]: valid, [1]: dirty, [2]: cmpt",
        }
      ]
    },
    { name:     "TAG_124",
      desc:     "Tag Address stored in cache line 124",
      swaccess: "rw",
      hwaccess: "hrw",
      hwext:    "true",
      hwqe:     "true", // enable `qe` latched signal of software write pulse
      hwre:     "true",
      fields: [
        { bits: "5-1:0",
          name: "CL_TAG",
          desc: "Tag Address"
        }
      ]
    },
    {
      name:     "STATUS_125",
      desc:     "Status register of cache line 125",
      swaccess: "rw",
      hwaccess: "hrw",
      hwext:    "true",
      hwqe:     "true", // enable `qe` latched signal of software write pulse
      hwre:     "true",
      fields: [
        {
          bits: "5+3:5", // 2 bits for status
          name: "CL_STATUS",
          desc: "Contain the current status of the corresponding cache line                [0]: valid, [1]: dirty, [2]: cmpt",
        }
      ]
    },
    { name:     "TAG_125",
      desc:     "Tag Address stored in cache line 125",
      swaccess: "rw",
      hwaccess: "hrw",
      hwext:    "true",
      hwqe:     "true", // enable `qe` latched signal of software write pulse
      hwre:     "true",
      fields: [
        { bits: "5-1:0",
          name: "CL_TAG",
          desc: "Tag Address"
        }
      ]
    },
    {
      name:     "STATUS_126",
      desc:     "Status register of cache line 126",
      swaccess: "rw",
      hwaccess: "hrw",
      hwext:    "true",
      hwqe:     "true", // enable `qe` latched signal of software write pulse
      hwre:     "true",
      fields: [
        {
          bits: "5+3:5", // 2 bits for status
          name: "CL_STATUS",
          desc: "Contain the current status of the corresponding cache line                [0]: valid, [1]: dirty, [2]: cmpt",
        }
      ]
    },
    { name:     "TAG_126",
      desc:     "Tag Address stored in cache line 126",
      swaccess: "rw",
      hwaccess: "hrw",
      hwext:    "true",
      hwqe:     "true", // enable `qe` latched signal of software write pulse
      hwre:     "true",
      fields: [
        { bits: "5-1:0",
          name: "CL_TAG",
          desc: "Tag Address"
        }
      ]
    },
    {
      name:     "STATUS_127",
      desc:     "Status register of cache line 127",
      swaccess: "rw",
      hwaccess: "hrw",
      hwext:    "true",
      hwqe:     "true", // enable `qe` latched signal of software write pulse
      hwre:     "true",
      fields: [
        {
          bits: "5+3:5", // 2 bits for status
          name: "CL_STATUS",
          desc: "Contain the current status of the corresponding cache line                [0]: valid, [1]: dirty, [2]: cmpt",
        }
      ]
    },
    { name:     "TAG_127",
      desc:     "Tag Address stored in cache line 127",
      swaccess: "rw",
      hwaccess: "hrw",
      hwext:    "true",
      hwqe:     "true", // enable `qe` latched signal of software write pulse
      hwre:     "true",
      fields: [
        { bits: "5-1:0",
          name: "CL_TAG",
          desc: "Tag Address"
        }
      ]
    },
    {
      name:     "STATUS_128",
      desc:     "Status register of cache line 128",
      swaccess: "rw",
      hwaccess: "hrw",
      hwext:    "true",
      hwqe:     "true", // enable `qe` latched signal of software write pulse
      hwre:     "true",
      fields: [
        {
          bits: "5+3:5", // 2 bits for status
          name: "CL_STATUS",
          desc: "Contain the current status of the corresponding cache line                [0]: valid, [1]: dirty, [2]: cmpt",
        }
      ]
    },
    { name:     "TAG_128",
      desc:     "Tag Address stored in cache line 128",
      swaccess: "rw",
      hwaccess: "hrw",
      hwext:    "true",
      hwqe:     "true", // enable `qe` latched signal of software write pulse
      hwre:     "true",
      fields: [
        { bits: "5-1:0",
          name: "CL_TAG",
          desc: "Tag Address"
        }
      ]
    },
    {
      name:     "STATUS_129",
      desc:     "Status register of cache line 129",
      swaccess: "rw",
      hwaccess: "hrw",
      hwext:    "true",
      hwqe:     "true", // enable `qe` latched signal of software write pulse
      hwre:     "true",
      fields: [
        {
          bits: "5+3:5", // 2 bits for status
          name: "CL_STATUS",
          desc: "Contain the current status of the corresponding cache line                [0]: valid, [1]: dirty, [2]: cmpt",
        }
      ]
    },
    { name:     "TAG_129",
      desc:     "Tag Address stored in cache line 129",
      swaccess: "rw",
      hwaccess: "hrw",
      hwext:    "true",
      hwqe:     "true", // enable `qe` latched signal of software write pulse
      hwre:     "true",
      fields: [
        { bits: "5-1:0",
          name: "CL_TAG",
          desc: "Tag Address"
        }
      ]
    },
    {
      name:     "STATUS_130",
      desc:     "Status register of cache line 130",
      swaccess: "rw",
      hwaccess: "hrw",
      hwext:    "true",
      hwqe:     "true", // enable `qe` latched signal of software write pulse
      hwre:     "true",
      fields: [
        {
          bits: "5+3:5", // 2 bits for status
          name: "CL_STATUS",
          desc: "Contain the current status of the corresponding cache line                [0]: valid, [1]: dirty, [2]: cmpt",
        }
      ]
    },
    { name:     "TAG_130",
      desc:     "Tag Address stored in cache line 130",
      swaccess: "rw",
      hwaccess: "hrw",
      hwext:    "true",
      hwqe:     "true", // enable `qe` latched signal of software write pulse
      hwre:     "true",
      fields: [
        { bits: "5-1:0",
          name: "CL_TAG",
          desc: "Tag Address"
        }
      ]
    },
    {
      name:     "STATUS_131",
      desc:     "Status register of cache line 131",
      swaccess: "rw",
      hwaccess: "hrw",
      hwext:    "true",
      hwqe:     "true", // enable `qe` latched signal of software write pulse
      hwre:     "true",
      fields: [
        {
          bits: "5+3:5", // 2 bits for status
          name: "CL_STATUS",
          desc: "Contain the current status of the corresponding cache line                [0]: valid, [1]: dirty, [2]: cmpt",
        }
      ]
    },
    { name:     "TAG_131",
      desc:     "Tag Address stored in cache line 131",
      swaccess: "rw",
      hwaccess: "hrw",
      hwext:    "true",
      hwqe:     "true", // enable `qe` latched signal of software write pulse
      hwre:     "true",
      fields: [
        { bits: "5-1:0",
          name: "CL_TAG",
          desc: "Tag Address"
        }
      ]
    },
    {
      name:     "STATUS_132",
      desc:     "Status register of cache line 132",
      swaccess: "rw",
      hwaccess: "hrw",
      hwext:    "true",
      hwqe:     "true", // enable `qe` latched signal of software write pulse
      hwre:     "true",
      fields: [
        {
          bits: "5+3:5", // 2 bits for status
          name: "CL_STATUS",
          desc: "Contain the current status of the corresponding cache line                [0]: valid, [1]: dirty, [2]: cmpt",
        }
      ]
    },
    { name:     "TAG_132",
      desc:     "Tag Address stored in cache line 132",
      swaccess: "rw",
      hwaccess: "hrw",
      hwext:    "true",
      hwqe:     "true", // enable `qe` latched signal of software write pulse
      hwre:     "true",
      fields: [
        { bits: "5-1:0",
          name: "CL_TAG",
          desc: "Tag Address"
        }
      ]
    },
    {
      name:     "STATUS_133",
      desc:     "Status register of cache line 133",
      swaccess: "rw",
      hwaccess: "hrw",
      hwext:    "true",
      hwqe:     "true", // enable `qe` latched signal of software write pulse
      hwre:     "true",
      fields: [
        {
          bits: "5+3:5", // 2 bits for status
          name: "CL_STATUS",
          desc: "Contain the current status of the corresponding cache line                [0]: valid, [1]: dirty, [2]: cmpt",
        }
      ]
    },
    { name:     "TAG_133",
      desc:     "Tag Address stored in cache line 133",
      swaccess: "rw",
      hwaccess: "hrw",
      hwext:    "true",
      hwqe:     "true", // enable `qe` latched signal of software write pulse
      hwre:     "true",
      fields: [
        { bits: "5-1:0",
          name: "CL_TAG",
          desc: "Tag Address"
        }
      ]
    },
    {
      name:     "STATUS_134",
      desc:     "Status register of cache line 134",
      swaccess: "rw",
      hwaccess: "hrw",
      hwext:    "true",
      hwqe:     "true", // enable `qe` latched signal of software write pulse
      hwre:     "true",
      fields: [
        {
          bits: "5+3:5", // 2 bits for status
          name: "CL_STATUS",
          desc: "Contain the current status of the corresponding cache line                [0]: valid, [1]: dirty, [2]: cmpt",
        }
      ]
    },
    { name:     "TAG_134",
      desc:     "Tag Address stored in cache line 134",
      swaccess: "rw",
      hwaccess: "hrw",
      hwext:    "true",
      hwqe:     "true", // enable `qe` latched signal of software write pulse
      hwre:     "true",
      fields: [
        { bits: "5-1:0",
          name: "CL_TAG",
          desc: "Tag Address"
        }
      ]
    },
    {
      name:     "STATUS_135",
      desc:     "Status register of cache line 135",
      swaccess: "rw",
      hwaccess: "hrw",
      hwext:    "true",
      hwqe:     "true", // enable `qe` latched signal of software write pulse
      hwre:     "true",
      fields: [
        {
          bits: "5+3:5", // 2 bits for status
          name: "CL_STATUS",
          desc: "Contain the current status of the corresponding cache line                [0]: valid, [1]: dirty, [2]: cmpt",
        }
      ]
    },
    { name:     "TAG_135",
      desc:     "Tag Address stored in cache line 135",
      swaccess: "rw",
      hwaccess: "hrw",
      hwext:    "true",
      hwqe:     "true", // enable `qe` latched signal of software write pulse
      hwre:     "true",
      fields: [
        { bits: "5-1:0",
          name: "CL_TAG",
          desc: "Tag Address"
        }
      ]
    },
    {
      name:     "STATUS_136",
      desc:     "Status register of cache line 136",
      swaccess: "rw",
      hwaccess: "hrw",
      hwext:    "true",
      hwqe:     "true", // enable `qe` latched signal of software write pulse
      hwre:     "true",
      fields: [
        {
          bits: "5+3:5", // 2 bits for status
          name: "CL_STATUS",
          desc: "Contain the current status of the corresponding cache line                [0]: valid, [1]: dirty, [2]: cmpt",
        }
      ]
    },
    { name:     "TAG_136",
      desc:     "Tag Address stored in cache line 136",
      swaccess: "rw",
      hwaccess: "hrw",
      hwext:    "true",
      hwqe:     "true", // enable `qe` latched signal of software write pulse
      hwre:     "true",
      fields: [
        { bits: "5-1:0",
          name: "CL_TAG",
          desc: "Tag Address"
        }
      ]
    },
    {
      name:     "STATUS_137",
      desc:     "Status register of cache line 137",
      swaccess: "rw",
      hwaccess: "hrw",
      hwext:    "true",
      hwqe:     "true", // enable `qe` latched signal of software write pulse
      hwre:     "true",
      fields: [
        {
          bits: "5+3:5", // 2 bits for status
          name: "CL_STATUS",
          desc: "Contain the current status of the corresponding cache line                [0]: valid, [1]: dirty, [2]: cmpt",
        }
      ]
    },
    { name:     "TAG_137",
      desc:     "Tag Address stored in cache line 137",
      swaccess: "rw",
      hwaccess: "hrw",
      hwext:    "true",
      hwqe:     "true", // enable `qe` latched signal of software write pulse
      hwre:     "true",
      fields: [
        { bits: "5-1:0",
          name: "CL_TAG",
          desc: "Tag Address"
        }
      ]
    },
    {
      name:     "STATUS_138",
      desc:     "Status register of cache line 138",
      swaccess: "rw",
      hwaccess: "hrw",
      hwext:    "true",
      hwqe:     "true", // enable `qe` latched signal of software write pulse
      hwre:     "true",
      fields: [
        {
          bits: "5+3:5", // 2 bits for status
          name: "CL_STATUS",
          desc: "Contain the current status of the corresponding cache line                [0]: valid, [1]: dirty, [2]: cmpt",
        }
      ]
    },
    { name:     "TAG_138",
      desc:     "Tag Address stored in cache line 138",
      swaccess: "rw",
      hwaccess: "hrw",
      hwext:    "true",
      hwqe:     "true", // enable `qe` latched signal of software write pulse
      hwre:     "true",
      fields: [
        { bits: "5-1:0",
          name: "CL_TAG",
          desc: "Tag Address"
        }
      ]
    },
    {
      name:     "STATUS_139",
      desc:     "Status register of cache line 139",
      swaccess: "rw",
      hwaccess: "hrw",
      hwext:    "true",
      hwqe:     "true", // enable `qe` latched signal of software write pulse
      hwre:     "true",
      fields: [
        {
          bits: "5+3:5", // 2 bits for status
          name: "CL_STATUS",
          desc: "Contain the current status of the corresponding cache line                [0]: valid, [1]: dirty, [2]: cmpt",
        }
      ]
    },
    { name:     "TAG_139",
      desc:     "Tag Address stored in cache line 139",
      swaccess: "rw",
      hwaccess: "hrw",
      hwext:    "true",
      hwqe:     "true", // enable `qe` latched signal of software write pulse
      hwre:     "true",
      fields: [
        { bits: "5-1:0",
          name: "CL_TAG",
          desc: "Tag Address"
        }
      ]
    },
    {
      name:     "STATUS_140",
      desc:     "Status register of cache line 140",
      swaccess: "rw",
      hwaccess: "hrw",
      hwext:    "true",
      hwqe:     "true", // enable `qe` latched signal of software write pulse
      hwre:     "true",
      fields: [
        {
          bits: "5+3:5", // 2 bits for status
          name: "CL_STATUS",
          desc: "Contain the current status of the corresponding cache line                [0]: valid, [1]: dirty, [2]: cmpt",
        }
      ]
    },
    { name:     "TAG_140",
      desc:     "Tag Address stored in cache line 140",
      swaccess: "rw",
      hwaccess: "hrw",
      hwext:    "true",
      hwqe:     "true", // enable `qe` latched signal of software write pulse
      hwre:     "true",
      fields: [
        { bits: "5-1:0",
          name: "CL_TAG",
          desc: "Tag Address"
        }
      ]
    },
    {
      name:     "STATUS_141",
      desc:     "Status register of cache line 141",
      swaccess: "rw",
      hwaccess: "hrw",
      hwext:    "true",
      hwqe:     "true", // enable `qe` latched signal of software write pulse
      hwre:     "true",
      fields: [
        {
          bits: "5+3:5", // 2 bits for status
          name: "CL_STATUS",
          desc: "Contain the current status of the corresponding cache line                [0]: valid, [1]: dirty, [2]: cmpt",
        }
      ]
    },
    { name:     "TAG_141",
      desc:     "Tag Address stored in cache line 141",
      swaccess: "rw",
      hwaccess: "hrw",
      hwext:    "true",
      hwqe:     "true", // enable `qe` latched signal of software write pulse
      hwre:     "true",
      fields: [
        { bits: "5-1:0",
          name: "CL_TAG",
          desc: "Tag Address"
        }
      ]
    },
    {
      name:     "STATUS_142",
      desc:     "Status register of cache line 142",
      swaccess: "rw",
      hwaccess: "hrw",
      hwext:    "true",
      hwqe:     "true", // enable `qe` latched signal of software write pulse
      hwre:     "true",
      fields: [
        {
          bits: "5+3:5", // 2 bits for status
          name: "CL_STATUS",
          desc: "Contain the current status of the corresponding cache line                [0]: valid, [1]: dirty, [2]: cmpt",
        }
      ]
    },
    { name:     "TAG_142",
      desc:     "Tag Address stored in cache line 142",
      swaccess: "rw",
      hwaccess: "hrw",
      hwext:    "true",
      hwqe:     "true", // enable `qe` latched signal of software write pulse
      hwre:     "true",
      fields: [
        { bits: "5-1:0",
          name: "CL_TAG",
          desc: "Tag Address"
        }
      ]
    },
    {
      name:     "STATUS_143",
      desc:     "Status register of cache line 143",
      swaccess: "rw",
      hwaccess: "hrw",
      hwext:    "true",
      hwqe:     "true", // enable `qe` latched signal of software write pulse
      hwre:     "true",
      fields: [
        {
          bits: "5+3:5", // 2 bits for status
          name: "CL_STATUS",
          desc: "Contain the current status of the corresponding cache line                [0]: valid, [1]: dirty, [2]: cmpt",
        }
      ]
    },
    { name:     "TAG_143",
      desc:     "Tag Address stored in cache line 143",
      swaccess: "rw",
      hwaccess: "hrw",
      hwext:    "true",
      hwqe:     "true", // enable `qe` latched signal of software write pulse
      hwre:     "true",
      fields: [
        { bits: "5-1:0",
          name: "CL_TAG",
          desc: "Tag Address"
        }
      ]
    },
    {
      name:     "STATUS_144",
      desc:     "Status register of cache line 144",
      swaccess: "rw",
      hwaccess: "hrw",
      hwext:    "true",
      hwqe:     "true", // enable `qe` latched signal of software write pulse
      hwre:     "true",
      fields: [
        {
          bits: "5+3:5", // 2 bits for status
          name: "CL_STATUS",
          desc: "Contain the current status of the corresponding cache line                [0]: valid, [1]: dirty, [2]: cmpt",
        }
      ]
    },
    { name:     "TAG_144",
      desc:     "Tag Address stored in cache line 144",
      swaccess: "rw",
      hwaccess: "hrw",
      hwext:    "true",
      hwqe:     "true", // enable `qe` latched signal of software write pulse
      hwre:     "true",
      fields: [
        { bits: "5-1:0",
          name: "CL_TAG",
          desc: "Tag Address"
        }
      ]
    },
    {
      name:     "STATUS_145",
      desc:     "Status register of cache line 145",
      swaccess: "rw",
      hwaccess: "hrw",
      hwext:    "true",
      hwqe:     "true", // enable `qe` latched signal of software write pulse
      hwre:     "true",
      fields: [
        {
          bits: "5+3:5", // 2 bits for status
          name: "CL_STATUS",
          desc: "Contain the current status of the corresponding cache line                [0]: valid, [1]: dirty, [2]: cmpt",
        }
      ]
    },
    { name:     "TAG_145",
      desc:     "Tag Address stored in cache line 145",
      swaccess: "rw",
      hwaccess: "hrw",
      hwext:    "true",
      hwqe:     "true", // enable `qe` latched signal of software write pulse
      hwre:     "true",
      fields: [
        { bits: "5-1:0",
          name: "CL_TAG",
          desc: "Tag Address"
        }
      ]
    },
    {
      name:     "STATUS_146",
      desc:     "Status register of cache line 146",
      swaccess: "rw",
      hwaccess: "hrw",
      hwext:    "true",
      hwqe:     "true", // enable `qe` latched signal of software write pulse
      hwre:     "true",
      fields: [
        {
          bits: "5+3:5", // 2 bits for status
          name: "CL_STATUS",
          desc: "Contain the current status of the corresponding cache line                [0]: valid, [1]: dirty, [2]: cmpt",
        }
      ]
    },
    { name:     "TAG_146",
      desc:     "Tag Address stored in cache line 146",
      swaccess: "rw",
      hwaccess: "hrw",
      hwext:    "true",
      hwqe:     "true", // enable `qe` latched signal of software write pulse
      hwre:     "true",
      fields: [
        { bits: "5-1:0",
          name: "CL_TAG",
          desc: "Tag Address"
        }
      ]
    },
    {
      name:     "STATUS_147",
      desc:     "Status register of cache line 147",
      swaccess: "rw",
      hwaccess: "hrw",
      hwext:    "true",
      hwqe:     "true", // enable `qe` latched signal of software write pulse
      hwre:     "true",
      fields: [
        {
          bits: "5+3:5", // 2 bits for status
          name: "CL_STATUS",
          desc: "Contain the current status of the corresponding cache line                [0]: valid, [1]: dirty, [2]: cmpt",
        }
      ]
    },
    { name:     "TAG_147",
      desc:     "Tag Address stored in cache line 147",
      swaccess: "rw",
      hwaccess: "hrw",
      hwext:    "true",
      hwqe:     "true", // enable `qe` latched signal of software write pulse
      hwre:     "true",
      fields: [
        { bits: "5-1:0",
          name: "CL_TAG",
          desc: "Tag Address"
        }
      ]
    },
    {
      name:     "STATUS_148",
      desc:     "Status register of cache line 148",
      swaccess: "rw",
      hwaccess: "hrw",
      hwext:    "true",
      hwqe:     "true", // enable `qe` latched signal of software write pulse
      hwre:     "true",
      fields: [
        {
          bits: "5+3:5", // 2 bits for status
          name: "CL_STATUS",
          desc: "Contain the current status of the corresponding cache line                [0]: valid, [1]: dirty, [2]: cmpt",
        }
      ]
    },
    { name:     "TAG_148",
      desc:     "Tag Address stored in cache line 148",
      swaccess: "rw",
      hwaccess: "hrw",
      hwext:    "true",
      hwqe:     "true", // enable `qe` latched signal of software write pulse
      hwre:     "true",
      fields: [
        { bits: "5-1:0",
          name: "CL_TAG",
          desc: "Tag Address"
        }
      ]
    },
    {
      name:     "STATUS_149",
      desc:     "Status register of cache line 149",
      swaccess: "rw",
      hwaccess: "hrw",
      hwext:    "true",
      hwqe:     "true", // enable `qe` latched signal of software write pulse
      hwre:     "true",
      fields: [
        {
          bits: "5+3:5", // 2 bits for status
          name: "CL_STATUS",
          desc: "Contain the current status of the corresponding cache line                [0]: valid, [1]: dirty, [2]: cmpt",
        }
      ]
    },
    { name:     "TAG_149",
      desc:     "Tag Address stored in cache line 149",
      swaccess: "rw",
      hwaccess: "hrw",
      hwext:    "true",
      hwqe:     "true", // enable `qe` latched signal of software write pulse
      hwre:     "true",
      fields: [
        { bits: "5-1:0",
          name: "CL_TAG",
          desc: "Tag Address"
        }
      ]
    },
    {
      name:     "STATUS_150",
      desc:     "Status register of cache line 150",
      swaccess: "rw",
      hwaccess: "hrw",
      hwext:    "true",
      hwqe:     "true", // enable `qe` latched signal of software write pulse
      hwre:     "true",
      fields: [
        {
          bits: "5+3:5", // 2 bits for status
          name: "CL_STATUS",
          desc: "Contain the current status of the corresponding cache line                [0]: valid, [1]: dirty, [2]: cmpt",
        }
      ]
    },
    { name:     "TAG_150",
      desc:     "Tag Address stored in cache line 150",
      swaccess: "rw",
      hwaccess: "hrw",
      hwext:    "true",
      hwqe:     "true", // enable `qe` latched signal of software write pulse
      hwre:     "true",
      fields: [
        { bits: "5-1:0",
          name: "CL_TAG",
          desc: "Tag Address"
        }
      ]
    },
    {
      name:     "STATUS_151",
      desc:     "Status register of cache line 151",
      swaccess: "rw",
      hwaccess: "hrw",
      hwext:    "true",
      hwqe:     "true", // enable `qe` latched signal of software write pulse
      hwre:     "true",
      fields: [
        {
          bits: "5+3:5", // 2 bits for status
          name: "CL_STATUS",
          desc: "Contain the current status of the corresponding cache line                [0]: valid, [1]: dirty, [2]: cmpt",
        }
      ]
    },
    { name:     "TAG_151",
      desc:     "Tag Address stored in cache line 151",
      swaccess: "rw",
      hwaccess: "hrw",
      hwext:    "true",
      hwqe:     "true", // enable `qe` latched signal of software write pulse
      hwre:     "true",
      fields: [
        { bits: "5-1:0",
          name: "CL_TAG",
          desc: "Tag Address"
        }
      ]
    },
    {
      name:     "STATUS_152",
      desc:     "Status register of cache line 152",
      swaccess: "rw",
      hwaccess: "hrw",
      hwext:    "true",
      hwqe:     "true", // enable `qe` latched signal of software write pulse
      hwre:     "true",
      fields: [
        {
          bits: "5+3:5", // 2 bits for status
          name: "CL_STATUS",
          desc: "Contain the current status of the corresponding cache line                [0]: valid, [1]: dirty, [2]: cmpt",
        }
      ]
    },
    { name:     "TAG_152",
      desc:     "Tag Address stored in cache line 152",
      swaccess: "rw",
      hwaccess: "hrw",
      hwext:    "true",
      hwqe:     "true", // enable `qe` latched signal of software write pulse
      hwre:     "true",
      fields: [
        { bits: "5-1:0",
          name: "CL_TAG",
          desc: "Tag Address"
        }
      ]
    },
    {
      name:     "STATUS_153",
      desc:     "Status register of cache line 153",
      swaccess: "rw",
      hwaccess: "hrw",
      hwext:    "true",
      hwqe:     "true", // enable `qe` latched signal of software write pulse
      hwre:     "true",
      fields: [
        {
          bits: "5+3:5", // 2 bits for status
          name: "CL_STATUS",
          desc: "Contain the current status of the corresponding cache line                [0]: valid, [1]: dirty, [2]: cmpt",
        }
      ]
    },
    { name:     "TAG_153",
      desc:     "Tag Address stored in cache line 153",
      swaccess: "rw",
      hwaccess: "hrw",
      hwext:    "true",
      hwqe:     "true", // enable `qe` latched signal of software write pulse
      hwre:     "true",
      fields: [
        { bits: "5-1:0",
          name: "CL_TAG",
          desc: "Tag Address"
        }
      ]
    },
    {
      name:     "STATUS_154",
      desc:     "Status register of cache line 154",
      swaccess: "rw",
      hwaccess: "hrw",
      hwext:    "true",
      hwqe:     "true", // enable `qe` latched signal of software write pulse
      hwre:     "true",
      fields: [
        {
          bits: "5+3:5", // 2 bits for status
          name: "CL_STATUS",
          desc: "Contain the current status of the corresponding cache line                [0]: valid, [1]: dirty, [2]: cmpt",
        }
      ]
    },
    { name:     "TAG_154",
      desc:     "Tag Address stored in cache line 154",
      swaccess: "rw",
      hwaccess: "hrw",
      hwext:    "true",
      hwqe:     "true", // enable `qe` latched signal of software write pulse
      hwre:     "true",
      fields: [
        { bits: "5-1:0",
          name: "CL_TAG",
          desc: "Tag Address"
        }
      ]
    },
    {
      name:     "STATUS_155",
      desc:     "Status register of cache line 155",
      swaccess: "rw",
      hwaccess: "hrw",
      hwext:    "true",
      hwqe:     "true", // enable `qe` latched signal of software write pulse
      hwre:     "true",
      fields: [
        {
          bits: "5+3:5", // 2 bits for status
          name: "CL_STATUS",
          desc: "Contain the current status of the corresponding cache line                [0]: valid, [1]: dirty, [2]: cmpt",
        }
      ]
    },
    { name:     "TAG_155",
      desc:     "Tag Address stored in cache line 155",
      swaccess: "rw",
      hwaccess: "hrw",
      hwext:    "true",
      hwqe:     "true", // enable `qe` latched signal of software write pulse
      hwre:     "true",
      fields: [
        { bits: "5-1:0",
          name: "CL_TAG",
          desc: "Tag Address"
        }
      ]
    },
    {
      name:     "STATUS_156",
      desc:     "Status register of cache line 156",
      swaccess: "rw",
      hwaccess: "hrw",
      hwext:    "true",
      hwqe:     "true", // enable `qe` latched signal of software write pulse
      hwre:     "true",
      fields: [
        {
          bits: "5+3:5", // 2 bits for status
          name: "CL_STATUS",
          desc: "Contain the current status of the corresponding cache line                [0]: valid, [1]: dirty, [2]: cmpt",
        }
      ]
    },
    { name:     "TAG_156",
      desc:     "Tag Address stored in cache line 156",
      swaccess: "rw",
      hwaccess: "hrw",
      hwext:    "true",
      hwqe:     "true", // enable `qe` latched signal of software write pulse
      hwre:     "true",
      fields: [
        { bits: "5-1:0",
          name: "CL_TAG",
          desc: "Tag Address"
        }
      ]
    },
    {
      name:     "STATUS_157",
      desc:     "Status register of cache line 157",
      swaccess: "rw",
      hwaccess: "hrw",
      hwext:    "true",
      hwqe:     "true", // enable `qe` latched signal of software write pulse
      hwre:     "true",
      fields: [
        {
          bits: "5+3:5", // 2 bits for status
          name: "CL_STATUS",
          desc: "Contain the current status of the corresponding cache line                [0]: valid, [1]: dirty, [2]: cmpt",
        }
      ]
    },
    { name:     "TAG_157",
      desc:     "Tag Address stored in cache line 157",
      swaccess: "rw",
      hwaccess: "hrw",
      hwext:    "true",
      hwqe:     "true", // enable `qe` latched signal of software write pulse
      hwre:     "true",
      fields: [
        { bits: "5-1:0",
          name: "CL_TAG",
          desc: "Tag Address"
        }
      ]
    },
    {
      name:     "STATUS_158",
      desc:     "Status register of cache line 158",
      swaccess: "rw",
      hwaccess: "hrw",
      hwext:    "true",
      hwqe:     "true", // enable `qe` latched signal of software write pulse
      hwre:     "true",
      fields: [
        {
          bits: "5+3:5", // 2 bits for status
          name: "CL_STATUS",
          desc: "Contain the current status of the corresponding cache line                [0]: valid, [1]: dirty, [2]: cmpt",
        }
      ]
    },
    { name:     "TAG_158",
      desc:     "Tag Address stored in cache line 158",
      swaccess: "rw",
      hwaccess: "hrw",
      hwext:    "true",
      hwqe:     "true", // enable `qe` latched signal of software write pulse
      hwre:     "true",
      fields: [
        { bits: "5-1:0",
          name: "CL_TAG",
          desc: "Tag Address"
        }
      ]
    },
    {
      name:     "STATUS_159",
      desc:     "Status register of cache line 159",
      swaccess: "rw",
      hwaccess: "hrw",
      hwext:    "true",
      hwqe:     "true", // enable `qe` latched signal of software write pulse
      hwre:     "true",
      fields: [
        {
          bits: "5+3:5", // 2 bits for status
          name: "CL_STATUS",
          desc: "Contain the current status of the corresponding cache line                [0]: valid, [1]: dirty, [2]: cmpt",
        }
      ]
    },
    { name:     "TAG_159",
      desc:     "Tag Address stored in cache line 159",
      swaccess: "rw",
      hwaccess: "hrw",
      hwext:    "true",
      hwqe:     "true", // enable `qe` latched signal of software write pulse
      hwre:     "true",
      fields: [
        { bits: "5-1:0",
          name: "CL_TAG",
          desc: "Tag Address"
        }
      ]
    },
    {
      name:     "STATUS_160",
      desc:     "Status register of cache line 160",
      swaccess: "rw",
      hwaccess: "hrw",
      hwext:    "true",
      hwqe:     "true", // enable `qe` latched signal of software write pulse
      hwre:     "true",
      fields: [
        {
          bits: "5+3:5", // 2 bits for status
          name: "CL_STATUS",
          desc: "Contain the current status of the corresponding cache line                [0]: valid, [1]: dirty, [2]: cmpt",
        }
      ]
    },
    { name:     "TAG_160",
      desc:     "Tag Address stored in cache line 160",
      swaccess: "rw",
      hwaccess: "hrw",
      hwext:    "true",
      hwqe:     "true", // enable `qe` latched signal of software write pulse
      hwre:     "true",
      fields: [
        { bits: "5-1:0",
          name: "CL_TAG",
          desc: "Tag Address"
        }
      ]
    },
    {
      name:     "STATUS_161",
      desc:     "Status register of cache line 161",
      swaccess: "rw",
      hwaccess: "hrw",
      hwext:    "true",
      hwqe:     "true", // enable `qe` latched signal of software write pulse
      hwre:     "true",
      fields: [
        {
          bits: "5+3:5", // 2 bits for status
          name: "CL_STATUS",
          desc: "Contain the current status of the corresponding cache line                [0]: valid, [1]: dirty, [2]: cmpt",
        }
      ]
    },
    { name:     "TAG_161",
      desc:     "Tag Address stored in cache line 161",
      swaccess: "rw",
      hwaccess: "hrw",
      hwext:    "true",
      hwqe:     "true", // enable `qe` latched signal of software write pulse
      hwre:     "true",
      fields: [
        { bits: "5-1:0",
          name: "CL_TAG",
          desc: "Tag Address"
        }
      ]
    },
    {
      name:     "STATUS_162",
      desc:     "Status register of cache line 162",
      swaccess: "rw",
      hwaccess: "hrw",
      hwext:    "true",
      hwqe:     "true", // enable `qe` latched signal of software write pulse
      hwre:     "true",
      fields: [
        {
          bits: "5+3:5", // 2 bits for status
          name: "CL_STATUS",
          desc: "Contain the current status of the corresponding cache line                [0]: valid, [1]: dirty, [2]: cmpt",
        }
      ]
    },
    { name:     "TAG_162",
      desc:     "Tag Address stored in cache line 162",
      swaccess: "rw",
      hwaccess: "hrw",
      hwext:    "true",
      hwqe:     "true", // enable `qe` latched signal of software write pulse
      hwre:     "true",
      fields: [
        { bits: "5-1:0",
          name: "CL_TAG",
          desc: "Tag Address"
        }
      ]
    },
    {
      name:     "STATUS_163",
      desc:     "Status register of cache line 163",
      swaccess: "rw",
      hwaccess: "hrw",
      hwext:    "true",
      hwqe:     "true", // enable `qe` latched signal of software write pulse
      hwre:     "true",
      fields: [
        {
          bits: "5+3:5", // 2 bits for status
          name: "CL_STATUS",
          desc: "Contain the current status of the corresponding cache line                [0]: valid, [1]: dirty, [2]: cmpt",
        }
      ]
    },
    { name:     "TAG_163",
      desc:     "Tag Address stored in cache line 163",
      swaccess: "rw",
      hwaccess: "hrw",
      hwext:    "true",
      hwqe:     "true", // enable `qe` latched signal of software write pulse
      hwre:     "true",
      fields: [
        { bits: "5-1:0",
          name: "CL_TAG",
          desc: "Tag Address"
        }
      ]
    },
    {
      name:     "STATUS_164",
      desc:     "Status register of cache line 164",
      swaccess: "rw",
      hwaccess: "hrw",
      hwext:    "true",
      hwqe:     "true", // enable `qe` latched signal of software write pulse
      hwre:     "true",
      fields: [
        {
          bits: "5+3:5", // 2 bits for status
          name: "CL_STATUS",
          desc: "Contain the current status of the corresponding cache line                [0]: valid, [1]: dirty, [2]: cmpt",
        }
      ]
    },
    { name:     "TAG_164",
      desc:     "Tag Address stored in cache line 164",
      swaccess: "rw",
      hwaccess: "hrw",
      hwext:    "true",
      hwqe:     "true", // enable `qe` latched signal of software write pulse
      hwre:     "true",
      fields: [
        { bits: "5-1:0",
          name: "CL_TAG",
          desc: "Tag Address"
        }
      ]
    },
    {
      name:     "STATUS_165",
      desc:     "Status register of cache line 165",
      swaccess: "rw",
      hwaccess: "hrw",
      hwext:    "true",
      hwqe:     "true", // enable `qe` latched signal of software write pulse
      hwre:     "true",
      fields: [
        {
          bits: "5+3:5", // 2 bits for status
          name: "CL_STATUS",
          desc: "Contain the current status of the corresponding cache line                [0]: valid, [1]: dirty, [2]: cmpt",
        }
      ]
    },
    { name:     "TAG_165",
      desc:     "Tag Address stored in cache line 165",
      swaccess: "rw",
      hwaccess: "hrw",
      hwext:    "true",
      hwqe:     "true", // enable `qe` latched signal of software write pulse
      hwre:     "true",
      fields: [
        { bits: "5-1:0",
          name: "CL_TAG",
          desc: "Tag Address"
        }
      ]
    },
    {
      name:     "STATUS_166",
      desc:     "Status register of cache line 166",
      swaccess: "rw",
      hwaccess: "hrw",
      hwext:    "true",
      hwqe:     "true", // enable `qe` latched signal of software write pulse
      hwre:     "true",
      fields: [
        {
          bits: "5+3:5", // 2 bits for status
          name: "CL_STATUS",
          desc: "Contain the current status of the corresponding cache line                [0]: valid, [1]: dirty, [2]: cmpt",
        }
      ]
    },
    { name:     "TAG_166",
      desc:     "Tag Address stored in cache line 166",
      swaccess: "rw",
      hwaccess: "hrw",
      hwext:    "true",
      hwqe:     "true", // enable `qe` latched signal of software write pulse
      hwre:     "true",
      fields: [
        { bits: "5-1:0",
          name: "CL_TAG",
          desc: "Tag Address"
        }
      ]
    },
    {
      name:     "STATUS_167",
      desc:     "Status register of cache line 167",
      swaccess: "rw",
      hwaccess: "hrw",
      hwext:    "true",
      hwqe:     "true", // enable `qe` latched signal of software write pulse
      hwre:     "true",
      fields: [
        {
          bits: "5+3:5", // 2 bits for status
          name: "CL_STATUS",
          desc: "Contain the current status of the corresponding cache line                [0]: valid, [1]: dirty, [2]: cmpt",
        }
      ]
    },
    { name:     "TAG_167",
      desc:     "Tag Address stored in cache line 167",
      swaccess: "rw",
      hwaccess: "hrw",
      hwext:    "true",
      hwqe:     "true", // enable `qe` latched signal of software write pulse
      hwre:     "true",
      fields: [
        { bits: "5-1:0",
          name: "CL_TAG",
          desc: "Tag Address"
        }
      ]
    },
    {
      name:     "STATUS_168",
      desc:     "Status register of cache line 168",
      swaccess: "rw",
      hwaccess: "hrw",
      hwext:    "true",
      hwqe:     "true", // enable `qe` latched signal of software write pulse
      hwre:     "true",
      fields: [
        {
          bits: "5+3:5", // 2 bits for status
          name: "CL_STATUS",
          desc: "Contain the current status of the corresponding cache line                [0]: valid, [1]: dirty, [2]: cmpt",
        }
      ]
    },
    { name:     "TAG_168",
      desc:     "Tag Address stored in cache line 168",
      swaccess: "rw",
      hwaccess: "hrw",
      hwext:    "true",
      hwqe:     "true", // enable `qe` latched signal of software write pulse
      hwre:     "true",
      fields: [
        { bits: "5-1:0",
          name: "CL_TAG",
          desc: "Tag Address"
        }
      ]
    },
    {
      name:     "STATUS_169",
      desc:     "Status register of cache line 169",
      swaccess: "rw",
      hwaccess: "hrw",
      hwext:    "true",
      hwqe:     "true", // enable `qe` latched signal of software write pulse
      hwre:     "true",
      fields: [
        {
          bits: "5+3:5", // 2 bits for status
          name: "CL_STATUS",
          desc: "Contain the current status of the corresponding cache line                [0]: valid, [1]: dirty, [2]: cmpt",
        }
      ]
    },
    { name:     "TAG_169",
      desc:     "Tag Address stored in cache line 169",
      swaccess: "rw",
      hwaccess: "hrw",
      hwext:    "true",
      hwqe:     "true", // enable `qe` latched signal of software write pulse
      hwre:     "true",
      fields: [
        { bits: "5-1:0",
          name: "CL_TAG",
          desc: "Tag Address"
        }
      ]
    },
    {
      name:     "STATUS_170",
      desc:     "Status register of cache line 170",
      swaccess: "rw",
      hwaccess: "hrw",
      hwext:    "true",
      hwqe:     "true", // enable `qe` latched signal of software write pulse
      hwre:     "true",
      fields: [
        {
          bits: "5+3:5", // 2 bits for status
          name: "CL_STATUS",
          desc: "Contain the current status of the corresponding cache line                [0]: valid, [1]: dirty, [2]: cmpt",
        }
      ]
    },
    { name:     "TAG_170",
      desc:     "Tag Address stored in cache line 170",
      swaccess: "rw",
      hwaccess: "hrw",
      hwext:    "true",
      hwqe:     "true", // enable `qe` latched signal of software write pulse
      hwre:     "true",
      fields: [
        { bits: "5-1:0",
          name: "CL_TAG",
          desc: "Tag Address"
        }
      ]
    },
    {
      name:     "STATUS_171",
      desc:     "Status register of cache line 171",
      swaccess: "rw",
      hwaccess: "hrw",
      hwext:    "true",
      hwqe:     "true", // enable `qe` latched signal of software write pulse
      hwre:     "true",
      fields: [
        {
          bits: "5+3:5", // 2 bits for status
          name: "CL_STATUS",
          desc: "Contain the current status of the corresponding cache line                [0]: valid, [1]: dirty, [2]: cmpt",
        }
      ]
    },
    { name:     "TAG_171",
      desc:     "Tag Address stored in cache line 171",
      swaccess: "rw",
      hwaccess: "hrw",
      hwext:    "true",
      hwqe:     "true", // enable `qe` latched signal of software write pulse
      hwre:     "true",
      fields: [
        { bits: "5-1:0",
          name: "CL_TAG",
          desc: "Tag Address"
        }
      ]
    },
    {
      name:     "STATUS_172",
      desc:     "Status register of cache line 172",
      swaccess: "rw",
      hwaccess: "hrw",
      hwext:    "true",
      hwqe:     "true", // enable `qe` latched signal of software write pulse
      hwre:     "true",
      fields: [
        {
          bits: "5+3:5", // 2 bits for status
          name: "CL_STATUS",
          desc: "Contain the current status of the corresponding cache line                [0]: valid, [1]: dirty, [2]: cmpt",
        }
      ]
    },
    { name:     "TAG_172",
      desc:     "Tag Address stored in cache line 172",
      swaccess: "rw",
      hwaccess: "hrw",
      hwext:    "true",
      hwqe:     "true", // enable `qe` latched signal of software write pulse
      hwre:     "true",
      fields: [
        { bits: "5-1:0",
          name: "CL_TAG",
          desc: "Tag Address"
        }
      ]
    },
    {
      name:     "STATUS_173",
      desc:     "Status register of cache line 173",
      swaccess: "rw",
      hwaccess: "hrw",
      hwext:    "true",
      hwqe:     "true", // enable `qe` latched signal of software write pulse
      hwre:     "true",
      fields: [
        {
          bits: "5+3:5", // 2 bits for status
          name: "CL_STATUS",
          desc: "Contain the current status of the corresponding cache line                [0]: valid, [1]: dirty, [2]: cmpt",
        }
      ]
    },
    { name:     "TAG_173",
      desc:     "Tag Address stored in cache line 173",
      swaccess: "rw",
      hwaccess: "hrw",
      hwext:    "true",
      hwqe:     "true", // enable `qe` latched signal of software write pulse
      hwre:     "true",
      fields: [
        { bits: "5-1:0",
          name: "CL_TAG",
          desc: "Tag Address"
        }
      ]
    },
    {
      name:     "STATUS_174",
      desc:     "Status register of cache line 174",
      swaccess: "rw",
      hwaccess: "hrw",
      hwext:    "true",
      hwqe:     "true", // enable `qe` latched signal of software write pulse
      hwre:     "true",
      fields: [
        {
          bits: "5+3:5", // 2 bits for status
          name: "CL_STATUS",
          desc: "Contain the current status of the corresponding cache line                [0]: valid, [1]: dirty, [2]: cmpt",
        }
      ]
    },
    { name:     "TAG_174",
      desc:     "Tag Address stored in cache line 174",
      swaccess: "rw",
      hwaccess: "hrw",
      hwext:    "true",
      hwqe:     "true", // enable `qe` latched signal of software write pulse
      hwre:     "true",
      fields: [
        { bits: "5-1:0",
          name: "CL_TAG",
          desc: "Tag Address"
        }
      ]
    },
    {
      name:     "STATUS_175",
      desc:     "Status register of cache line 175",
      swaccess: "rw",
      hwaccess: "hrw",
      hwext:    "true",
      hwqe:     "true", // enable `qe` latched signal of software write pulse
      hwre:     "true",
      fields: [
        {
          bits: "5+3:5", // 2 bits for status
          name: "CL_STATUS",
          desc: "Contain the current status of the corresponding cache line                [0]: valid, [1]: dirty, [2]: cmpt",
        }
      ]
    },
    { name:     "TAG_175",
      desc:     "Tag Address stored in cache line 175",
      swaccess: "rw",
      hwaccess: "hrw",
      hwext:    "true",
      hwqe:     "true", // enable `qe` latched signal of software write pulse
      hwre:     "true",
      fields: [
        { bits: "5-1:0",
          name: "CL_TAG",
          desc: "Tag Address"
        }
      ]
    },
    {
      name:     "STATUS_176",
      desc:     "Status register of cache line 176",
      swaccess: "rw",
      hwaccess: "hrw",
      hwext:    "true",
      hwqe:     "true", // enable `qe` latched signal of software write pulse
      hwre:     "true",
      fields: [
        {
          bits: "5+3:5", // 2 bits for status
          name: "CL_STATUS",
          desc: "Contain the current status of the corresponding cache line                [0]: valid, [1]: dirty, [2]: cmpt",
        }
      ]
    },
    { name:     "TAG_176",
      desc:     "Tag Address stored in cache line 176",
      swaccess: "rw",
      hwaccess: "hrw",
      hwext:    "true",
      hwqe:     "true", // enable `qe` latched signal of software write pulse
      hwre:     "true",
      fields: [
        { bits: "5-1:0",
          name: "CL_TAG",
          desc: "Tag Address"
        }
      ]
    },
    {
      name:     "STATUS_177",
      desc:     "Status register of cache line 177",
      swaccess: "rw",
      hwaccess: "hrw",
      hwext:    "true",
      hwqe:     "true", // enable `qe` latched signal of software write pulse
      hwre:     "true",
      fields: [
        {
          bits: "5+3:5", // 2 bits for status
          name: "CL_STATUS",
          desc: "Contain the current status of the corresponding cache line                [0]: valid, [1]: dirty, [2]: cmpt",
        }
      ]
    },
    { name:     "TAG_177",
      desc:     "Tag Address stored in cache line 177",
      swaccess: "rw",
      hwaccess: "hrw",
      hwext:    "true",
      hwqe:     "true", // enable `qe` latched signal of software write pulse
      hwre:     "true",
      fields: [
        { bits: "5-1:0",
          name: "CL_TAG",
          desc: "Tag Address"
        }
      ]
    },
    {
      name:     "STATUS_178",
      desc:     "Status register of cache line 178",
      swaccess: "rw",
      hwaccess: "hrw",
      hwext:    "true",
      hwqe:     "true", // enable `qe` latched signal of software write pulse
      hwre:     "true",
      fields: [
        {
          bits: "5+3:5", // 2 bits for status
          name: "CL_STATUS",
          desc: "Contain the current status of the corresponding cache line                [0]: valid, [1]: dirty, [2]: cmpt",
        }
      ]
    },
    { name:     "TAG_178",
      desc:     "Tag Address stored in cache line 178",
      swaccess: "rw",
      hwaccess: "hrw",
      hwext:    "true",
      hwqe:     "true", // enable `qe` latched signal of software write pulse
      hwre:     "true",
      fields: [
        { bits: "5-1:0",
          name: "CL_TAG",
          desc: "Tag Address"
        }
      ]
    },
    {
      name:     "STATUS_179",
      desc:     "Status register of cache line 179",
      swaccess: "rw",
      hwaccess: "hrw",
      hwext:    "true",
      hwqe:     "true", // enable `qe` latched signal of software write pulse
      hwre:     "true",
      fields: [
        {
          bits: "5+3:5", // 2 bits for status
          name: "CL_STATUS",
          desc: "Contain the current status of the corresponding cache line                [0]: valid, [1]: dirty, [2]: cmpt",
        }
      ]
    },
    { name:     "TAG_179",
      desc:     "Tag Address stored in cache line 179",
      swaccess: "rw",
      hwaccess: "hrw",
      hwext:    "true",
      hwqe:     "true", // enable `qe` latched signal of software write pulse
      hwre:     "true",
      fields: [
        { bits: "5-1:0",
          name: "CL_TAG",
          desc: "Tag Address"
        }
      ]
    },
    {
      name:     "STATUS_180",
      desc:     "Status register of cache line 180",
      swaccess: "rw",
      hwaccess: "hrw",
      hwext:    "true",
      hwqe:     "true", // enable `qe` latched signal of software write pulse
      hwre:     "true",
      fields: [
        {
          bits: "5+3:5", // 2 bits for status
          name: "CL_STATUS",
          desc: "Contain the current status of the corresponding cache line                [0]: valid, [1]: dirty, [2]: cmpt",
        }
      ]
    },
    { name:     "TAG_180",
      desc:     "Tag Address stored in cache line 180",
      swaccess: "rw",
      hwaccess: "hrw",
      hwext:    "true",
      hwqe:     "true", // enable `qe` latched signal of software write pulse
      hwre:     "true",
      fields: [
        { bits: "5-1:0",
          name: "CL_TAG",
          desc: "Tag Address"
        }
      ]
    },
    {
      name:     "STATUS_181",
      desc:     "Status register of cache line 181",
      swaccess: "rw",
      hwaccess: "hrw",
      hwext:    "true",
      hwqe:     "true", // enable `qe` latched signal of software write pulse
      hwre:     "true",
      fields: [
        {
          bits: "5+3:5", // 2 bits for status
          name: "CL_STATUS",
          desc: "Contain the current status of the corresponding cache line                [0]: valid, [1]: dirty, [2]: cmpt",
        }
      ]
    },
    { name:     "TAG_181",
      desc:     "Tag Address stored in cache line 181",
      swaccess: "rw",
      hwaccess: "hrw",
      hwext:    "true",
      hwqe:     "true", // enable `qe` latched signal of software write pulse
      hwre:     "true",
      fields: [
        { bits: "5-1:0",
          name: "CL_TAG",
          desc: "Tag Address"
        }
      ]
    },
    {
      name:     "STATUS_182",
      desc:     "Status register of cache line 182",
      swaccess: "rw",
      hwaccess: "hrw",
      hwext:    "true",
      hwqe:     "true", // enable `qe` latched signal of software write pulse
      hwre:     "true",
      fields: [
        {
          bits: "5+3:5", // 2 bits for status
          name: "CL_STATUS",
          desc: "Contain the current status of the corresponding cache line                [0]: valid, [1]: dirty, [2]: cmpt",
        }
      ]
    },
    { name:     "TAG_182",
      desc:     "Tag Address stored in cache line 182",
      swaccess: "rw",
      hwaccess: "hrw",
      hwext:    "true",
      hwqe:     "true", // enable `qe` latched signal of software write pulse
      hwre:     "true",
      fields: [
        { bits: "5-1:0",
          name: "CL_TAG",
          desc: "Tag Address"
        }
      ]
    },
    {
      name:     "STATUS_183",
      desc:     "Status register of cache line 183",
      swaccess: "rw",
      hwaccess: "hrw",
      hwext:    "true",
      hwqe:     "true", // enable `qe` latched signal of software write pulse
      hwre:     "true",
      fields: [
        {
          bits: "5+3:5", // 2 bits for status
          name: "CL_STATUS",
          desc: "Contain the current status of the corresponding cache line                [0]: valid, [1]: dirty, [2]: cmpt",
        }
      ]
    },
    { name:     "TAG_183",
      desc:     "Tag Address stored in cache line 183",
      swaccess: "rw",
      hwaccess: "hrw",
      hwext:    "true",
      hwqe:     "true", // enable `qe` latched signal of software write pulse
      hwre:     "true",
      fields: [
        { bits: "5-1:0",
          name: "CL_TAG",
          desc: "Tag Address"
        }
      ]
    },
    {
      name:     "STATUS_184",
      desc:     "Status register of cache line 184",
      swaccess: "rw",
      hwaccess: "hrw",
      hwext:    "true",
      hwqe:     "true", // enable `qe` latched signal of software write pulse
      hwre:     "true",
      fields: [
        {
          bits: "5+3:5", // 2 bits for status
          name: "CL_STATUS",
          desc: "Contain the current status of the corresponding cache line                [0]: valid, [1]: dirty, [2]: cmpt",
        }
      ]
    },
    { name:     "TAG_184",
      desc:     "Tag Address stored in cache line 184",
      swaccess: "rw",
      hwaccess: "hrw",
      hwext:    "true",
      hwqe:     "true", // enable `qe` latched signal of software write pulse
      hwre:     "true",
      fields: [
        { bits: "5-1:0",
          name: "CL_TAG",
          desc: "Tag Address"
        }
      ]
    },
    {
      name:     "STATUS_185",
      desc:     "Status register of cache line 185",
      swaccess: "rw",
      hwaccess: "hrw",
      hwext:    "true",
      hwqe:     "true", // enable `qe` latched signal of software write pulse
      hwre:     "true",
      fields: [
        {
          bits: "5+3:5", // 2 bits for status
          name: "CL_STATUS",
          desc: "Contain the current status of the corresponding cache line                [0]: valid, [1]: dirty, [2]: cmpt",
        }
      ]
    },
    { name:     "TAG_185",
      desc:     "Tag Address stored in cache line 185",
      swaccess: "rw",
      hwaccess: "hrw",
      hwext:    "true",
      hwqe:     "true", // enable `qe` latched signal of software write pulse
      hwre:     "true",
      fields: [
        { bits: "5-1:0",
          name: "CL_TAG",
          desc: "Tag Address"
        }
      ]
    },
    {
      name:     "STATUS_186",
      desc:     "Status register of cache line 186",
      swaccess: "rw",
      hwaccess: "hrw",
      hwext:    "true",
      hwqe:     "true", // enable `qe` latched signal of software write pulse
      hwre:     "true",
      fields: [
        {
          bits: "5+3:5", // 2 bits for status
          name: "CL_STATUS",
          desc: "Contain the current status of the corresponding cache line                [0]: valid, [1]: dirty, [2]: cmpt",
        }
      ]
    },
    { name:     "TAG_186",
      desc:     "Tag Address stored in cache line 186",
      swaccess: "rw",
      hwaccess: "hrw",
      hwext:    "true",
      hwqe:     "true", // enable `qe` latched signal of software write pulse
      hwre:     "true",
      fields: [
        { bits: "5-1:0",
          name: "CL_TAG",
          desc: "Tag Address"
        }
      ]
    },
    {
      name:     "STATUS_187",
      desc:     "Status register of cache line 187",
      swaccess: "rw",
      hwaccess: "hrw",
      hwext:    "true",
      hwqe:     "true", // enable `qe` latched signal of software write pulse
      hwre:     "true",
      fields: [
        {
          bits: "5+3:5", // 2 bits for status
          name: "CL_STATUS",
          desc: "Contain the current status of the corresponding cache line                [0]: valid, [1]: dirty, [2]: cmpt",
        }
      ]
    },
    { name:     "TAG_187",
      desc:     "Tag Address stored in cache line 187",
      swaccess: "rw",
      hwaccess: "hrw",
      hwext:    "true",
      hwqe:     "true", // enable `qe` latched signal of software write pulse
      hwre:     "true",
      fields: [
        { bits: "5-1:0",
          name: "CL_TAG",
          desc: "Tag Address"
        }
      ]
    },
    {
      name:     "STATUS_188",
      desc:     "Status register of cache line 188",
      swaccess: "rw",
      hwaccess: "hrw",
      hwext:    "true",
      hwqe:     "true", // enable `qe` latched signal of software write pulse
      hwre:     "true",
      fields: [
        {
          bits: "5+3:5", // 2 bits for status
          name: "CL_STATUS",
          desc: "Contain the current status of the corresponding cache line                [0]: valid, [1]: dirty, [2]: cmpt",
        }
      ]
    },
    { name:     "TAG_188",
      desc:     "Tag Address stored in cache line 188",
      swaccess: "rw",
      hwaccess: "hrw",
      hwext:    "true",
      hwqe:     "true", // enable `qe` latched signal of software write pulse
      hwre:     "true",
      fields: [
        { bits: "5-1:0",
          name: "CL_TAG",
          desc: "Tag Address"
        }
      ]
    },
    {
      name:     "STATUS_189",
      desc:     "Status register of cache line 189",
      swaccess: "rw",
      hwaccess: "hrw",
      hwext:    "true",
      hwqe:     "true", // enable `qe` latched signal of software write pulse
      hwre:     "true",
      fields: [
        {
          bits: "5+3:5", // 2 bits for status
          name: "CL_STATUS",
          desc: "Contain the current status of the corresponding cache line                [0]: valid, [1]: dirty, [2]: cmpt",
        }
      ]
    },
    { name:     "TAG_189",
      desc:     "Tag Address stored in cache line 189",
      swaccess: "rw",
      hwaccess: "hrw",
      hwext:    "true",
      hwqe:     "true", // enable `qe` latched signal of software write pulse
      hwre:     "true",
      fields: [
        { bits: "5-1:0",
          name: "CL_TAG",
          desc: "Tag Address"
        }
      ]
    },
    {
      name:     "STATUS_190",
      desc:     "Status register of cache line 190",
      swaccess: "rw",
      hwaccess: "hrw",
      hwext:    "true",
      hwqe:     "true", // enable `qe` latched signal of software write pulse
      hwre:     "true",
      fields: [
        {
          bits: "5+3:5", // 2 bits for status
          name: "CL_STATUS",
          desc: "Contain the current status of the corresponding cache line                [0]: valid, [1]: dirty, [2]: cmpt",
        }
      ]
    },
    { name:     "TAG_190",
      desc:     "Tag Address stored in cache line 190",
      swaccess: "rw",
      hwaccess: "hrw",
      hwext:    "true",
      hwqe:     "true", // enable `qe` latched signal of software write pulse
      hwre:     "true",
      fields: [
        { bits: "5-1:0",
          name: "CL_TAG",
          desc: "Tag Address"
        }
      ]
    },
    {
      name:     "STATUS_191",
      desc:     "Status register of cache line 191",
      swaccess: "rw",
      hwaccess: "hrw",
      hwext:    "true",
      hwqe:     "true", // enable `qe` latched signal of software write pulse
      hwre:     "true",
      fields: [
        {
          bits: "5+3:5", // 2 bits for status
          name: "CL_STATUS",
          desc: "Contain the current status of the corresponding cache line                [0]: valid, [1]: dirty, [2]: cmpt",
        }
      ]
    },
    { name:     "TAG_191",
      desc:     "Tag Address stored in cache line 191",
      swaccess: "rw",
      hwaccess: "hrw",
      hwext:    "true",
      hwqe:     "true", // enable `qe` latched signal of software write pulse
      hwre:     "true",
      fields: [
        { bits: "5-1:0",
          name: "CL_TAG",
          desc: "Tag Address"
        }
      ]
    },
    {
      name:     "STATUS_192",
      desc:     "Status register of cache line 192",
      swaccess: "rw",
      hwaccess: "hrw",
      hwext:    "true",
      hwqe:     "true", // enable `qe` latched signal of software write pulse
      hwre:     "true",
      fields: [
        {
          bits: "5+3:5", // 2 bits for status
          name: "CL_STATUS",
          desc: "Contain the current status of the corresponding cache line                [0]: valid, [1]: dirty, [2]: cmpt",
        }
      ]
    },
    { name:     "TAG_192",
      desc:     "Tag Address stored in cache line 192",
      swaccess: "rw",
      hwaccess: "hrw",
      hwext:    "true",
      hwqe:     "true", // enable `qe` latched signal of software write pulse
      hwre:     "true",
      fields: [
        { bits: "5-1:0",
          name: "CL_TAG",
          desc: "Tag Address"
        }
      ]
    },
    {
      name:     "STATUS_193",
      desc:     "Status register of cache line 193",
      swaccess: "rw",
      hwaccess: "hrw",
      hwext:    "true",
      hwqe:     "true", // enable `qe` latched signal of software write pulse
      hwre:     "true",
      fields: [
        {
          bits: "5+3:5", // 2 bits for status
          name: "CL_STATUS",
          desc: "Contain the current status of the corresponding cache line                [0]: valid, [1]: dirty, [2]: cmpt",
        }
      ]
    },
    { name:     "TAG_193",
      desc:     "Tag Address stored in cache line 193",
      swaccess: "rw",
      hwaccess: "hrw",
      hwext:    "true",
      hwqe:     "true", // enable `qe` latched signal of software write pulse
      hwre:     "true",
      fields: [
        { bits: "5-1:0",
          name: "CL_TAG",
          desc: "Tag Address"
        }
      ]
    },
    {
      name:     "STATUS_194",
      desc:     "Status register of cache line 194",
      swaccess: "rw",
      hwaccess: "hrw",
      hwext:    "true",
      hwqe:     "true", // enable `qe` latched signal of software write pulse
      hwre:     "true",
      fields: [
        {
          bits: "5+3:5", // 2 bits for status
          name: "CL_STATUS",
          desc: "Contain the current status of the corresponding cache line                [0]: valid, [1]: dirty, [2]: cmpt",
        }
      ]
    },
    { name:     "TAG_194",
      desc:     "Tag Address stored in cache line 194",
      swaccess: "rw",
      hwaccess: "hrw",
      hwext:    "true",
      hwqe:     "true", // enable `qe` latched signal of software write pulse
      hwre:     "true",
      fields: [
        { bits: "5-1:0",
          name: "CL_TAG",
          desc: "Tag Address"
        }
      ]
    },
    {
      name:     "STATUS_195",
      desc:     "Status register of cache line 195",
      swaccess: "rw",
      hwaccess: "hrw",
      hwext:    "true",
      hwqe:     "true", // enable `qe` latched signal of software write pulse
      hwre:     "true",
      fields: [
        {
          bits: "5+3:5", // 2 bits for status
          name: "CL_STATUS",
          desc: "Contain the current status of the corresponding cache line                [0]: valid, [1]: dirty, [2]: cmpt",
        }
      ]
    },
    { name:     "TAG_195",
      desc:     "Tag Address stored in cache line 195",
      swaccess: "rw",
      hwaccess: "hrw",
      hwext:    "true",
      hwqe:     "true", // enable `qe` latched signal of software write pulse
      hwre:     "true",
      fields: [
        { bits: "5-1:0",
          name: "CL_TAG",
          desc: "Tag Address"
        }
      ]
    },
    {
      name:     "STATUS_196",
      desc:     "Status register of cache line 196",
      swaccess: "rw",
      hwaccess: "hrw",
      hwext:    "true",
      hwqe:     "true", // enable `qe` latched signal of software write pulse
      hwre:     "true",
      fields: [
        {
          bits: "5+3:5", // 2 bits for status
          name: "CL_STATUS",
          desc: "Contain the current status of the corresponding cache line                [0]: valid, [1]: dirty, [2]: cmpt",
        }
      ]
    },
    { name:     "TAG_196",
      desc:     "Tag Address stored in cache line 196",
      swaccess: "rw",
      hwaccess: "hrw",
      hwext:    "true",
      hwqe:     "true", // enable `qe` latched signal of software write pulse
      hwre:     "true",
      fields: [
        { bits: "5-1:0",
          name: "CL_TAG",
          desc: "Tag Address"
        }
      ]
    },
    {
      name:     "STATUS_197",
      desc:     "Status register of cache line 197",
      swaccess: "rw",
      hwaccess: "hrw",
      hwext:    "true",
      hwqe:     "true", // enable `qe` latched signal of software write pulse
      hwre:     "true",
      fields: [
        {
          bits: "5+3:5", // 2 bits for status
          name: "CL_STATUS",
          desc: "Contain the current status of the corresponding cache line                [0]: valid, [1]: dirty, [2]: cmpt",
        }
      ]
    },
    { name:     "TAG_197",
      desc:     "Tag Address stored in cache line 197",
      swaccess: "rw",
      hwaccess: "hrw",
      hwext:    "true",
      hwqe:     "true", // enable `qe` latched signal of software write pulse
      hwre:     "true",
      fields: [
        { bits: "5-1:0",
          name: "CL_TAG",
          desc: "Tag Address"
        }
      ]
    },
    {
      name:     "STATUS_198",
      desc:     "Status register of cache line 198",
      swaccess: "rw",
      hwaccess: "hrw",
      hwext:    "true",
      hwqe:     "true", // enable `qe` latched signal of software write pulse
      hwre:     "true",
      fields: [
        {
          bits: "5+3:5", // 2 bits for status
          name: "CL_STATUS",
          desc: "Contain the current status of the corresponding cache line                [0]: valid, [1]: dirty, [2]: cmpt",
        }
      ]
    },
    { name:     "TAG_198",
      desc:     "Tag Address stored in cache line 198",
      swaccess: "rw",
      hwaccess: "hrw",
      hwext:    "true",
      hwqe:     "true", // enable `qe` latched signal of software write pulse
      hwre:     "true",
      fields: [
        { bits: "5-1:0",
          name: "CL_TAG",
          desc: "Tag Address"
        }
      ]
    },
    {
      name:     "STATUS_199",
      desc:     "Status register of cache line 199",
      swaccess: "rw",
      hwaccess: "hrw",
      hwext:    "true",
      hwqe:     "true", // enable `qe` latched signal of software write pulse
      hwre:     "true",
      fields: [
        {
          bits: "5+3:5", // 2 bits for status
          name: "CL_STATUS",
          desc: "Contain the current status of the corresponding cache line                [0]: valid, [1]: dirty, [2]: cmpt",
        }
      ]
    },
    { name:     "TAG_199",
      desc:     "Tag Address stored in cache line 199",
      swaccess: "rw",
      hwaccess: "hrw",
      hwext:    "true",
      hwqe:     "true", // enable `qe` latched signal of software write pulse
      hwre:     "true",
      fields: [
        { bits: "5-1:0",
          name: "CL_TAG",
          desc: "Tag Address"
        }
      ]
    },
    {
      name:     "STATUS_200",
      desc:     "Status register of cache line 200",
      swaccess: "rw",
      hwaccess: "hrw",
      hwext:    "true",
      hwqe:     "true", // enable `qe` latched signal of software write pulse
      hwre:     "true",
      fields: [
        {
          bits: "5+3:5", // 2 bits for status
          name: "CL_STATUS",
          desc: "Contain the current status of the corresponding cache line                [0]: valid, [1]: dirty, [2]: cmpt",
        }
      ]
    },
    { name:     "TAG_200",
      desc:     "Tag Address stored in cache line 200",
      swaccess: "rw",
      hwaccess: "hrw",
      hwext:    "true",
      hwqe:     "true", // enable `qe` latched signal of software write pulse
      hwre:     "true",
      fields: [
        { bits: "5-1:0",
          name: "CL_TAG",
          desc: "Tag Address"
        }
      ]
    },
    {
      name:     "STATUS_201",
      desc:     "Status register of cache line 201",
      swaccess: "rw",
      hwaccess: "hrw",
      hwext:    "true",
      hwqe:     "true", // enable `qe` latched signal of software write pulse
      hwre:     "true",
      fields: [
        {
          bits: "5+3:5", // 2 bits for status
          name: "CL_STATUS",
          desc: "Contain the current status of the corresponding cache line                [0]: valid, [1]: dirty, [2]: cmpt",
        }
      ]
    },
    { name:     "TAG_201",
      desc:     "Tag Address stored in cache line 201",
      swaccess: "rw",
      hwaccess: "hrw",
      hwext:    "true",
      hwqe:     "true", // enable `qe` latched signal of software write pulse
      hwre:     "true",
      fields: [
        { bits: "5-1:0",
          name: "CL_TAG",
          desc: "Tag Address"
        }
      ]
    },
    {
      name:     "STATUS_202",
      desc:     "Status register of cache line 202",
      swaccess: "rw",
      hwaccess: "hrw",
      hwext:    "true",
      hwqe:     "true", // enable `qe` latched signal of software write pulse
      hwre:     "true",
      fields: [
        {
          bits: "5+3:5", // 2 bits for status
          name: "CL_STATUS",
          desc: "Contain the current status of the corresponding cache line                [0]: valid, [1]: dirty, [2]: cmpt",
        }
      ]
    },
    { name:     "TAG_202",
      desc:     "Tag Address stored in cache line 202",
      swaccess: "rw",
      hwaccess: "hrw",
      hwext:    "true",
      hwqe:     "true", // enable `qe` latched signal of software write pulse
      hwre:     "true",
      fields: [
        { bits: "5-1:0",
          name: "CL_TAG",
          desc: "Tag Address"
        }
      ]
    },
    {
      name:     "STATUS_203",
      desc:     "Status register of cache line 203",
      swaccess: "rw",
      hwaccess: "hrw",
      hwext:    "true",
      hwqe:     "true", // enable `qe` latched signal of software write pulse
      hwre:     "true",
      fields: [
        {
          bits: "5+3:5", // 2 bits for status
          name: "CL_STATUS",
          desc: "Contain the current status of the corresponding cache line                [0]: valid, [1]: dirty, [2]: cmpt",
        }
      ]
    },
    { name:     "TAG_203",
      desc:     "Tag Address stored in cache line 203",
      swaccess: "rw",
      hwaccess: "hrw",
      hwext:    "true",
      hwqe:     "true", // enable `qe` latched signal of software write pulse
      hwre:     "true",
      fields: [
        { bits: "5-1:0",
          name: "CL_TAG",
          desc: "Tag Address"
        }
      ]
    },
    {
      name:     "STATUS_204",
      desc:     "Status register of cache line 204",
      swaccess: "rw",
      hwaccess: "hrw",
      hwext:    "true",
      hwqe:     "true", // enable `qe` latched signal of software write pulse
      hwre:     "true",
      fields: [
        {
          bits: "5+3:5", // 2 bits for status
          name: "CL_STATUS",
          desc: "Contain the current status of the corresponding cache line                [0]: valid, [1]: dirty, [2]: cmpt",
        }
      ]
    },
    { name:     "TAG_204",
      desc:     "Tag Address stored in cache line 204",
      swaccess: "rw",
      hwaccess: "hrw",
      hwext:    "true",
      hwqe:     "true", // enable `qe` latched signal of software write pulse
      hwre:     "true",
      fields: [
        { bits: "5-1:0",
          name: "CL_TAG",
          desc: "Tag Address"
        }
      ]
    },
    {
      name:     "STATUS_205",
      desc:     "Status register of cache line 205",
      swaccess: "rw",
      hwaccess: "hrw",
      hwext:    "true",
      hwqe:     "true", // enable `qe` latched signal of software write pulse
      hwre:     "true",
      fields: [
        {
          bits: "5+3:5", // 2 bits for status
          name: "CL_STATUS",
          desc: "Contain the current status of the corresponding cache line                [0]: valid, [1]: dirty, [2]: cmpt",
        }
      ]
    },
    { name:     "TAG_205",
      desc:     "Tag Address stored in cache line 205",
      swaccess: "rw",
      hwaccess: "hrw",
      hwext:    "true",
      hwqe:     "true", // enable `qe` latched signal of software write pulse
      hwre:     "true",
      fields: [
        { bits: "5-1:0",
          name: "CL_TAG",
          desc: "Tag Address"
        }
      ]
    },
    {
      name:     "STATUS_206",
      desc:     "Status register of cache line 206",
      swaccess: "rw",
      hwaccess: "hrw",
      hwext:    "true",
      hwqe:     "true", // enable `qe` latched signal of software write pulse
      hwre:     "true",
      fields: [
        {
          bits: "5+3:5", // 2 bits for status
          name: "CL_STATUS",
          desc: "Contain the current status of the corresponding cache line                [0]: valid, [1]: dirty, [2]: cmpt",
        }
      ]
    },
    { name:     "TAG_206",
      desc:     "Tag Address stored in cache line 206",
      swaccess: "rw",
      hwaccess: "hrw",
      hwext:    "true",
      hwqe:     "true", // enable `qe` latched signal of software write pulse
      hwre:     "true",
      fields: [
        { bits: "5-1:0",
          name: "CL_TAG",
          desc: "Tag Address"
        }
      ]
    },
    {
      name:     "STATUS_207",
      desc:     "Status register of cache line 207",
      swaccess: "rw",
      hwaccess: "hrw",
      hwext:    "true",
      hwqe:     "true", // enable `qe` latched signal of software write pulse
      hwre:     "true",
      fields: [
        {
          bits: "5+3:5", // 2 bits for status
          name: "CL_STATUS",
          desc: "Contain the current status of the corresponding cache line                [0]: valid, [1]: dirty, [2]: cmpt",
        }
      ]
    },
    { name:     "TAG_207",
      desc:     "Tag Address stored in cache line 207",
      swaccess: "rw",
      hwaccess: "hrw",
      hwext:    "true",
      hwqe:     "true", // enable `qe` latched signal of software write pulse
      hwre:     "true",
      fields: [
        { bits: "5-1:0",
          name: "CL_TAG",
          desc: "Tag Address"
        }
      ]
    },
    {
      name:     "STATUS_208",
      desc:     "Status register of cache line 208",
      swaccess: "rw",
      hwaccess: "hrw",
      hwext:    "true",
      hwqe:     "true", // enable `qe` latched signal of software write pulse
      hwre:     "true",
      fields: [
        {
          bits: "5+3:5", // 2 bits for status
          name: "CL_STATUS",
          desc: "Contain the current status of the corresponding cache line                [0]: valid, [1]: dirty, [2]: cmpt",
        }
      ]
    },
    { name:     "TAG_208",
      desc:     "Tag Address stored in cache line 208",
      swaccess: "rw",
      hwaccess: "hrw",
      hwext:    "true",
      hwqe:     "true", // enable `qe` latched signal of software write pulse
      hwre:     "true",
      fields: [
        { bits: "5-1:0",
          name: "CL_TAG",
          desc: "Tag Address"
        }
      ]
    },
    {
      name:     "STATUS_209",
      desc:     "Status register of cache line 209",
      swaccess: "rw",
      hwaccess: "hrw",
      hwext:    "true",
      hwqe:     "true", // enable `qe` latched signal of software write pulse
      hwre:     "true",
      fields: [
        {
          bits: "5+3:5", // 2 bits for status
          name: "CL_STATUS",
          desc: "Contain the current status of the corresponding cache line                [0]: valid, [1]: dirty, [2]: cmpt",
        }
      ]
    },
    { name:     "TAG_209",
      desc:     "Tag Address stored in cache line 209",
      swaccess: "rw",
      hwaccess: "hrw",
      hwext:    "true",
      hwqe:     "true", // enable `qe` latched signal of software write pulse
      hwre:     "true",
      fields: [
        { bits: "5-1:0",
          name: "CL_TAG",
          desc: "Tag Address"
        }
      ]
    },
    {
      name:     "STATUS_210",
      desc:     "Status register of cache line 210",
      swaccess: "rw",
      hwaccess: "hrw",
      hwext:    "true",
      hwqe:     "true", // enable `qe` latched signal of software write pulse
      hwre:     "true",
      fields: [
        {
          bits: "5+3:5", // 2 bits for status
          name: "CL_STATUS",
          desc: "Contain the current status of the corresponding cache line                [0]: valid, [1]: dirty, [2]: cmpt",
        }
      ]
    },
    { name:     "TAG_210",
      desc:     "Tag Address stored in cache line 210",
      swaccess: "rw",
      hwaccess: "hrw",
      hwext:    "true",
      hwqe:     "true", // enable `qe` latched signal of software write pulse
      hwre:     "true",
      fields: [
        { bits: "5-1:0",
          name: "CL_TAG",
          desc: "Tag Address"
        }
      ]
    },
    {
      name:     "STATUS_211",
      desc:     "Status register of cache line 211",
      swaccess: "rw",
      hwaccess: "hrw",
      hwext:    "true",
      hwqe:     "true", // enable `qe` latched signal of software write pulse
      hwre:     "true",
      fields: [
        {
          bits: "5+3:5", // 2 bits for status
          name: "CL_STATUS",
          desc: "Contain the current status of the corresponding cache line                [0]: valid, [1]: dirty, [2]: cmpt",
        }
      ]
    },
    { name:     "TAG_211",
      desc:     "Tag Address stored in cache line 211",
      swaccess: "rw",
      hwaccess: "hrw",
      hwext:    "true",
      hwqe:     "true", // enable `qe` latched signal of software write pulse
      hwre:     "true",
      fields: [
        { bits: "5-1:0",
          name: "CL_TAG",
          desc: "Tag Address"
        }
      ]
    },
    {
      name:     "STATUS_212",
      desc:     "Status register of cache line 212",
      swaccess: "rw",
      hwaccess: "hrw",
      hwext:    "true",
      hwqe:     "true", // enable `qe` latched signal of software write pulse
      hwre:     "true",
      fields: [
        {
          bits: "5+3:5", // 2 bits for status
          name: "CL_STATUS",
          desc: "Contain the current status of the corresponding cache line                [0]: valid, [1]: dirty, [2]: cmpt",
        }
      ]
    },
    { name:     "TAG_212",
      desc:     "Tag Address stored in cache line 212",
      swaccess: "rw",
      hwaccess: "hrw",
      hwext:    "true",
      hwqe:     "true", // enable `qe` latched signal of software write pulse
      hwre:     "true",
      fields: [
        { bits: "5-1:0",
          name: "CL_TAG",
          desc: "Tag Address"
        }
      ]
    },
    {
      name:     "STATUS_213",
      desc:     "Status register of cache line 213",
      swaccess: "rw",
      hwaccess: "hrw",
      hwext:    "true",
      hwqe:     "true", // enable `qe` latched signal of software write pulse
      hwre:     "true",
      fields: [
        {
          bits: "5+3:5", // 2 bits for status
          name: "CL_STATUS",
          desc: "Contain the current status of the corresponding cache line                [0]: valid, [1]: dirty, [2]: cmpt",
        }
      ]
    },
    { name:     "TAG_213",
      desc:     "Tag Address stored in cache line 213",
      swaccess: "rw",
      hwaccess: "hrw",
      hwext:    "true",
      hwqe:     "true", // enable `qe` latched signal of software write pulse
      hwre:     "true",
      fields: [
        { bits: "5-1:0",
          name: "CL_TAG",
          desc: "Tag Address"
        }
      ]
    },
    {
      name:     "STATUS_214",
      desc:     "Status register of cache line 214",
      swaccess: "rw",
      hwaccess: "hrw",
      hwext:    "true",
      hwqe:     "true", // enable `qe` latched signal of software write pulse
      hwre:     "true",
      fields: [
        {
          bits: "5+3:5", // 2 bits for status
          name: "CL_STATUS",
          desc: "Contain the current status of the corresponding cache line                [0]: valid, [1]: dirty, [2]: cmpt",
        }
      ]
    },
    { name:     "TAG_214",
      desc:     "Tag Address stored in cache line 214",
      swaccess: "rw",
      hwaccess: "hrw",
      hwext:    "true",
      hwqe:     "true", // enable `qe` latched signal of software write pulse
      hwre:     "true",
      fields: [
        { bits: "5-1:0",
          name: "CL_TAG",
          desc: "Tag Address"
        }
      ]
    },
    {
      name:     "STATUS_215",
      desc:     "Status register of cache line 215",
      swaccess: "rw",
      hwaccess: "hrw",
      hwext:    "true",
      hwqe:     "true", // enable `qe` latched signal of software write pulse
      hwre:     "true",
      fields: [
        {
          bits: "5+3:5", // 2 bits for status
          name: "CL_STATUS",
          desc: "Contain the current status of the corresponding cache line                [0]: valid, [1]: dirty, [2]: cmpt",
        }
      ]
    },
    { name:     "TAG_215",
      desc:     "Tag Address stored in cache line 215",
      swaccess: "rw",
      hwaccess: "hrw",
      hwext:    "true",
      hwqe:     "true", // enable `qe` latched signal of software write pulse
      hwre:     "true",
      fields: [
        { bits: "5-1:0",
          name: "CL_TAG",
          desc: "Tag Address"
        }
      ]
    },
    {
      name:     "STATUS_216",
      desc:     "Status register of cache line 216",
      swaccess: "rw",
      hwaccess: "hrw",
      hwext:    "true",
      hwqe:     "true", // enable `qe` latched signal of software write pulse
      hwre:     "true",
      fields: [
        {
          bits: "5+3:5", // 2 bits for status
          name: "CL_STATUS",
          desc: "Contain the current status of the corresponding cache line                [0]: valid, [1]: dirty, [2]: cmpt",
        }
      ]
    },
    { name:     "TAG_216",
      desc:     "Tag Address stored in cache line 216",
      swaccess: "rw",
      hwaccess: "hrw",
      hwext:    "true",
      hwqe:     "true", // enable `qe` latched signal of software write pulse
      hwre:     "true",
      fields: [
        { bits: "5-1:0",
          name: "CL_TAG",
          desc: "Tag Address"
        }
      ]
    },
    {
      name:     "STATUS_217",
      desc:     "Status register of cache line 217",
      swaccess: "rw",
      hwaccess: "hrw",
      hwext:    "true",
      hwqe:     "true", // enable `qe` latched signal of software write pulse
      hwre:     "true",
      fields: [
        {
          bits: "5+3:5", // 2 bits for status
          name: "CL_STATUS",
          desc: "Contain the current status of the corresponding cache line                [0]: valid, [1]: dirty, [2]: cmpt",
        }
      ]
    },
    { name:     "TAG_217",
      desc:     "Tag Address stored in cache line 217",
      swaccess: "rw",
      hwaccess: "hrw",
      hwext:    "true",
      hwqe:     "true", // enable `qe` latched signal of software write pulse
      hwre:     "true",
      fields: [
        { bits: "5-1:0",
          name: "CL_TAG",
          desc: "Tag Address"
        }
      ]
    },
    {
      name:     "STATUS_218",
      desc:     "Status register of cache line 218",
      swaccess: "rw",
      hwaccess: "hrw",
      hwext:    "true",
      hwqe:     "true", // enable `qe` latched signal of software write pulse
      hwre:     "true",
      fields: [
        {
          bits: "5+3:5", // 2 bits for status
          name: "CL_STATUS",
          desc: "Contain the current status of the corresponding cache line                [0]: valid, [1]: dirty, [2]: cmpt",
        }
      ]
    },
    { name:     "TAG_218",
      desc:     "Tag Address stored in cache line 218",
      swaccess: "rw",
      hwaccess: "hrw",
      hwext:    "true",
      hwqe:     "true", // enable `qe` latched signal of software write pulse
      hwre:     "true",
      fields: [
        { bits: "5-1:0",
          name: "CL_TAG",
          desc: "Tag Address"
        }
      ]
    },
    {
      name:     "STATUS_219",
      desc:     "Status register of cache line 219",
      swaccess: "rw",
      hwaccess: "hrw",
      hwext:    "true",
      hwqe:     "true", // enable `qe` latched signal of software write pulse
      hwre:     "true",
      fields: [
        {
          bits: "5+3:5", // 2 bits for status
          name: "CL_STATUS",
          desc: "Contain the current status of the corresponding cache line                [0]: valid, [1]: dirty, [2]: cmpt",
        }
      ]
    },
    { name:     "TAG_219",
      desc:     "Tag Address stored in cache line 219",
      swaccess: "rw",
      hwaccess: "hrw",
      hwext:    "true",
      hwqe:     "true", // enable `qe` latched signal of software write pulse
      hwre:     "true",
      fields: [
        { bits: "5-1:0",
          name: "CL_TAG",
          desc: "Tag Address"
        }
      ]
    },
    {
      name:     "STATUS_220",
      desc:     "Status register of cache line 220",
      swaccess: "rw",
      hwaccess: "hrw",
      hwext:    "true",
      hwqe:     "true", // enable `qe` latched signal of software write pulse
      hwre:     "true",
      fields: [
        {
          bits: "5+3:5", // 2 bits for status
          name: "CL_STATUS",
          desc: "Contain the current status of the corresponding cache line                [0]: valid, [1]: dirty, [2]: cmpt",
        }
      ]
    },
    { name:     "TAG_220",
      desc:     "Tag Address stored in cache line 220",
      swaccess: "rw",
      hwaccess: "hrw",
      hwext:    "true",
      hwqe:     "true", // enable `qe` latched signal of software write pulse
      hwre:     "true",
      fields: [
        { bits: "5-1:0",
          name: "CL_TAG",
          desc: "Tag Address"
        }
      ]
    },
    {
      name:     "STATUS_221",
      desc:     "Status register of cache line 221",
      swaccess: "rw",
      hwaccess: "hrw",
      hwext:    "true",
      hwqe:     "true", // enable `qe` latched signal of software write pulse
      hwre:     "true",
      fields: [
        {
          bits: "5+3:5", // 2 bits for status
          name: "CL_STATUS",
          desc: "Contain the current status of the corresponding cache line                [0]: valid, [1]: dirty, [2]: cmpt",
        }
      ]
    },
    { name:     "TAG_221",
      desc:     "Tag Address stored in cache line 221",
      swaccess: "rw",
      hwaccess: "hrw",
      hwext:    "true",
      hwqe:     "true", // enable `qe` latched signal of software write pulse
      hwre:     "true",
      fields: [
        { bits: "5-1:0",
          name: "CL_TAG",
          desc: "Tag Address"
        }
      ]
    },
    {
      name:     "STATUS_222",
      desc:     "Status register of cache line 222",
      swaccess: "rw",
      hwaccess: "hrw",
      hwext:    "true",
      hwqe:     "true", // enable `qe` latched signal of software write pulse
      hwre:     "true",
      fields: [
        {
          bits: "5+3:5", // 2 bits for status
          name: "CL_STATUS",
          desc: "Contain the current status of the corresponding cache line                [0]: valid, [1]: dirty, [2]: cmpt",
        }
      ]
    },
    { name:     "TAG_222",
      desc:     "Tag Address stored in cache line 222",
      swaccess: "rw",
      hwaccess: "hrw",
      hwext:    "true",
      hwqe:     "true", // enable `qe` latched signal of software write pulse
      hwre:     "true",
      fields: [
        { bits: "5-1:0",
          name: "CL_TAG",
          desc: "Tag Address"
        }
      ]
    },
    {
      name:     "STATUS_223",
      desc:     "Status register of cache line 223",
      swaccess: "rw",
      hwaccess: "hrw",
      hwext:    "true",
      hwqe:     "true", // enable `qe` latched signal of software write pulse
      hwre:     "true",
      fields: [
        {
          bits: "5+3:5", // 2 bits for status
          name: "CL_STATUS",
          desc: "Contain the current status of the corresponding cache line                [0]: valid, [1]: dirty, [2]: cmpt",
        }
      ]
    },
    { name:     "TAG_223",
      desc:     "Tag Address stored in cache line 223",
      swaccess: "rw",
      hwaccess: "hrw",
      hwext:    "true",
      hwqe:     "true", // enable `qe` latched signal of software write pulse
      hwre:     "true",
      fields: [
        { bits: "5-1:0",
          name: "CL_TAG",
          desc: "Tag Address"
        }
      ]
    },
    {
      name:     "STATUS_224",
      desc:     "Status register of cache line 224",
      swaccess: "rw",
      hwaccess: "hrw",
      hwext:    "true",
      hwqe:     "true", // enable `qe` latched signal of software write pulse
      hwre:     "true",
      fields: [
        {
          bits: "5+3:5", // 2 bits for status
          name: "CL_STATUS",
          desc: "Contain the current status of the corresponding cache line                [0]: valid, [1]: dirty, [2]: cmpt",
        }
      ]
    },
    { name:     "TAG_224",
      desc:     "Tag Address stored in cache line 224",
      swaccess: "rw",
      hwaccess: "hrw",
      hwext:    "true",
      hwqe:     "true", // enable `qe` latched signal of software write pulse
      hwre:     "true",
      fields: [
        { bits: "5-1:0",
          name: "CL_TAG",
          desc: "Tag Address"
        }
      ]
    },
    {
      name:     "STATUS_225",
      desc:     "Status register of cache line 225",
      swaccess: "rw",
      hwaccess: "hrw",
      hwext:    "true",
      hwqe:     "true", // enable `qe` latched signal of software write pulse
      hwre:     "true",
      fields: [
        {
          bits: "5+3:5", // 2 bits for status
          name: "CL_STATUS",
          desc: "Contain the current status of the corresponding cache line                [0]: valid, [1]: dirty, [2]: cmpt",
        }
      ]
    },
    { name:     "TAG_225",
      desc:     "Tag Address stored in cache line 225",
      swaccess: "rw",
      hwaccess: "hrw",
      hwext:    "true",
      hwqe:     "true", // enable `qe` latched signal of software write pulse
      hwre:     "true",
      fields: [
        { bits: "5-1:0",
          name: "CL_TAG",
          desc: "Tag Address"
        }
      ]
    },
    {
      name:     "STATUS_226",
      desc:     "Status register of cache line 226",
      swaccess: "rw",
      hwaccess: "hrw",
      hwext:    "true",
      hwqe:     "true", // enable `qe` latched signal of software write pulse
      hwre:     "true",
      fields: [
        {
          bits: "5+3:5", // 2 bits for status
          name: "CL_STATUS",
          desc: "Contain the current status of the corresponding cache line                [0]: valid, [1]: dirty, [2]: cmpt",
        }
      ]
    },
    { name:     "TAG_226",
      desc:     "Tag Address stored in cache line 226",
      swaccess: "rw",
      hwaccess: "hrw",
      hwext:    "true",
      hwqe:     "true", // enable `qe` latched signal of software write pulse
      hwre:     "true",
      fields: [
        { bits: "5-1:0",
          name: "CL_TAG",
          desc: "Tag Address"
        }
      ]
    },
    {
      name:     "STATUS_227",
      desc:     "Status register of cache line 227",
      swaccess: "rw",
      hwaccess: "hrw",
      hwext:    "true",
      hwqe:     "true", // enable `qe` latched signal of software write pulse
      hwre:     "true",
      fields: [
        {
          bits: "5+3:5", // 2 bits for status
          name: "CL_STATUS",
          desc: "Contain the current status of the corresponding cache line                [0]: valid, [1]: dirty, [2]: cmpt",
        }
      ]
    },
    { name:     "TAG_227",
      desc:     "Tag Address stored in cache line 227",
      swaccess: "rw",
      hwaccess: "hrw",
      hwext:    "true",
      hwqe:     "true", // enable `qe` latched signal of software write pulse
      hwre:     "true",
      fields: [
        { bits: "5-1:0",
          name: "CL_TAG",
          desc: "Tag Address"
        }
      ]
    },
    {
      name:     "STATUS_228",
      desc:     "Status register of cache line 228",
      swaccess: "rw",
      hwaccess: "hrw",
      hwext:    "true",
      hwqe:     "true", // enable `qe` latched signal of software write pulse
      hwre:     "true",
      fields: [
        {
          bits: "5+3:5", // 2 bits for status
          name: "CL_STATUS",
          desc: "Contain the current status of the corresponding cache line                [0]: valid, [1]: dirty, [2]: cmpt",
        }
      ]
    },
    { name:     "TAG_228",
      desc:     "Tag Address stored in cache line 228",
      swaccess: "rw",
      hwaccess: "hrw",
      hwext:    "true",
      hwqe:     "true", // enable `qe` latched signal of software write pulse
      hwre:     "true",
      fields: [
        { bits: "5-1:0",
          name: "CL_TAG",
          desc: "Tag Address"
        }
      ]
    },
    {
      name:     "STATUS_229",
      desc:     "Status register of cache line 229",
      swaccess: "rw",
      hwaccess: "hrw",
      hwext:    "true",
      hwqe:     "true", // enable `qe` latched signal of software write pulse
      hwre:     "true",
      fields: [
        {
          bits: "5+3:5", // 2 bits for status
          name: "CL_STATUS",
          desc: "Contain the current status of the corresponding cache line                [0]: valid, [1]: dirty, [2]: cmpt",
        }
      ]
    },
    { name:     "TAG_229",
      desc:     "Tag Address stored in cache line 229",
      swaccess: "rw",
      hwaccess: "hrw",
      hwext:    "true",
      hwqe:     "true", // enable `qe` latched signal of software write pulse
      hwre:     "true",
      fields: [
        { bits: "5-1:0",
          name: "CL_TAG",
          desc: "Tag Address"
        }
      ]
    },
    {
      name:     "STATUS_230",
      desc:     "Status register of cache line 230",
      swaccess: "rw",
      hwaccess: "hrw",
      hwext:    "true",
      hwqe:     "true", // enable `qe` latched signal of software write pulse
      hwre:     "true",
      fields: [
        {
          bits: "5+3:5", // 2 bits for status
          name: "CL_STATUS",
          desc: "Contain the current status of the corresponding cache line                [0]: valid, [1]: dirty, [2]: cmpt",
        }
      ]
    },
    { name:     "TAG_230",
      desc:     "Tag Address stored in cache line 230",
      swaccess: "rw",
      hwaccess: "hrw",
      hwext:    "true",
      hwqe:     "true", // enable `qe` latched signal of software write pulse
      hwre:     "true",
      fields: [
        { bits: "5-1:0",
          name: "CL_TAG",
          desc: "Tag Address"
        }
      ]
    },
    {
      name:     "STATUS_231",
      desc:     "Status register of cache line 231",
      swaccess: "rw",
      hwaccess: "hrw",
      hwext:    "true",
      hwqe:     "true", // enable `qe` latched signal of software write pulse
      hwre:     "true",
      fields: [
        {
          bits: "5+3:5", // 2 bits for status
          name: "CL_STATUS",
          desc: "Contain the current status of the corresponding cache line                [0]: valid, [1]: dirty, [2]: cmpt",
        }
      ]
    },
    { name:     "TAG_231",
      desc:     "Tag Address stored in cache line 231",
      swaccess: "rw",
      hwaccess: "hrw",
      hwext:    "true",
      hwqe:     "true", // enable `qe` latched signal of software write pulse
      hwre:     "true",
      fields: [
        { bits: "5-1:0",
          name: "CL_TAG",
          desc: "Tag Address"
        }
      ]
    },
    {
      name:     "STATUS_232",
      desc:     "Status register of cache line 232",
      swaccess: "rw",
      hwaccess: "hrw",
      hwext:    "true",
      hwqe:     "true", // enable `qe` latched signal of software write pulse
      hwre:     "true",
      fields: [
        {
          bits: "5+3:5", // 2 bits for status
          name: "CL_STATUS",
          desc: "Contain the current status of the corresponding cache line                [0]: valid, [1]: dirty, [2]: cmpt",
        }
      ]
    },
    { name:     "TAG_232",
      desc:     "Tag Address stored in cache line 232",
      swaccess: "rw",
      hwaccess: "hrw",
      hwext:    "true",
      hwqe:     "true", // enable `qe` latched signal of software write pulse
      hwre:     "true",
      fields: [
        { bits: "5-1:0",
          name: "CL_TAG",
          desc: "Tag Address"
        }
      ]
    },
    {
      name:     "STATUS_233",
      desc:     "Status register of cache line 233",
      swaccess: "rw",
      hwaccess: "hrw",
      hwext:    "true",
      hwqe:     "true", // enable `qe` latched signal of software write pulse
      hwre:     "true",
      fields: [
        {
          bits: "5+3:5", // 2 bits for status
          name: "CL_STATUS",
          desc: "Contain the current status of the corresponding cache line                [0]: valid, [1]: dirty, [2]: cmpt",
        }
      ]
    },
    { name:     "TAG_233",
      desc:     "Tag Address stored in cache line 233",
      swaccess: "rw",
      hwaccess: "hrw",
      hwext:    "true",
      hwqe:     "true", // enable `qe` latched signal of software write pulse
      hwre:     "true",
      fields: [
        { bits: "5-1:0",
          name: "CL_TAG",
          desc: "Tag Address"
        }
      ]
    },
    {
      name:     "STATUS_234",
      desc:     "Status register of cache line 234",
      swaccess: "rw",
      hwaccess: "hrw",
      hwext:    "true",
      hwqe:     "true", // enable `qe` latched signal of software write pulse
      hwre:     "true",
      fields: [
        {
          bits: "5+3:5", // 2 bits for status
          name: "CL_STATUS",
          desc: "Contain the current status of the corresponding cache line                [0]: valid, [1]: dirty, [2]: cmpt",
        }
      ]
    },
    { name:     "TAG_234",
      desc:     "Tag Address stored in cache line 234",
      swaccess: "rw",
      hwaccess: "hrw",
      hwext:    "true",
      hwqe:     "true", // enable `qe` latched signal of software write pulse
      hwre:     "true",
      fields: [
        { bits: "5-1:0",
          name: "CL_TAG",
          desc: "Tag Address"
        }
      ]
    },
    {
      name:     "STATUS_235",
      desc:     "Status register of cache line 235",
      swaccess: "rw",
      hwaccess: "hrw",
      hwext:    "true",
      hwqe:     "true", // enable `qe` latched signal of software write pulse
      hwre:     "true",
      fields: [
        {
          bits: "5+3:5", // 2 bits for status
          name: "CL_STATUS",
          desc: "Contain the current status of the corresponding cache line                [0]: valid, [1]: dirty, [2]: cmpt",
        }
      ]
    },
    { name:     "TAG_235",
      desc:     "Tag Address stored in cache line 235",
      swaccess: "rw",
      hwaccess: "hrw",
      hwext:    "true",
      hwqe:     "true", // enable `qe` latched signal of software write pulse
      hwre:     "true",
      fields: [
        { bits: "5-1:0",
          name: "CL_TAG",
          desc: "Tag Address"
        }
      ]
    },
    {
      name:     "STATUS_236",
      desc:     "Status register of cache line 236",
      swaccess: "rw",
      hwaccess: "hrw",
      hwext:    "true",
      hwqe:     "true", // enable `qe` latched signal of software write pulse
      hwre:     "true",
      fields: [
        {
          bits: "5+3:5", // 2 bits for status
          name: "CL_STATUS",
          desc: "Contain the current status of the corresponding cache line                [0]: valid, [1]: dirty, [2]: cmpt",
        }
      ]
    },
    { name:     "TAG_236",
      desc:     "Tag Address stored in cache line 236",
      swaccess: "rw",
      hwaccess: "hrw",
      hwext:    "true",
      hwqe:     "true", // enable `qe` latched signal of software write pulse
      hwre:     "true",
      fields: [
        { bits: "5-1:0",
          name: "CL_TAG",
          desc: "Tag Address"
        }
      ]
    },
    {
      name:     "STATUS_237",
      desc:     "Status register of cache line 237",
      swaccess: "rw",
      hwaccess: "hrw",
      hwext:    "true",
      hwqe:     "true", // enable `qe` latched signal of software write pulse
      hwre:     "true",
      fields: [
        {
          bits: "5+3:5", // 2 bits for status
          name: "CL_STATUS",
          desc: "Contain the current status of the corresponding cache line                [0]: valid, [1]: dirty, [2]: cmpt",
        }
      ]
    },
    { name:     "TAG_237",
      desc:     "Tag Address stored in cache line 237",
      swaccess: "rw",
      hwaccess: "hrw",
      hwext:    "true",
      hwqe:     "true", // enable `qe` latched signal of software write pulse
      hwre:     "true",
      fields: [
        { bits: "5-1:0",
          name: "CL_TAG",
          desc: "Tag Address"
        }
      ]
    },
    {
      name:     "STATUS_238",
      desc:     "Status register of cache line 238",
      swaccess: "rw",
      hwaccess: "hrw",
      hwext:    "true",
      hwqe:     "true", // enable `qe` latched signal of software write pulse
      hwre:     "true",
      fields: [
        {
          bits: "5+3:5", // 2 bits for status
          name: "CL_STATUS",
          desc: "Contain the current status of the corresponding cache line                [0]: valid, [1]: dirty, [2]: cmpt",
        }
      ]
    },
    { name:     "TAG_238",
      desc:     "Tag Address stored in cache line 238",
      swaccess: "rw",
      hwaccess: "hrw",
      hwext:    "true",
      hwqe:     "true", // enable `qe` latched signal of software write pulse
      hwre:     "true",
      fields: [
        { bits: "5-1:0",
          name: "CL_TAG",
          desc: "Tag Address"
        }
      ]
    },
    {
      name:     "STATUS_239",
      desc:     "Status register of cache line 239",
      swaccess: "rw",
      hwaccess: "hrw",
      hwext:    "true",
      hwqe:     "true", // enable `qe` latched signal of software write pulse
      hwre:     "true",
      fields: [
        {
          bits: "5+3:5", // 2 bits for status
          name: "CL_STATUS",
          desc: "Contain the current status of the corresponding cache line                [0]: valid, [1]: dirty, [2]: cmpt",
        }
      ]
    },
    { name:     "TAG_239",
      desc:     "Tag Address stored in cache line 239",
      swaccess: "rw",
      hwaccess: "hrw",
      hwext:    "true",
      hwqe:     "true", // enable `qe` latched signal of software write pulse
      hwre:     "true",
      fields: [
        { bits: "5-1:0",
          name: "CL_TAG",
          desc: "Tag Address"
        }
      ]
    },
    {
      name:     "STATUS_240",
      desc:     "Status register of cache line 240",
      swaccess: "rw",
      hwaccess: "hrw",
      hwext:    "true",
      hwqe:     "true", // enable `qe` latched signal of software write pulse
      hwre:     "true",
      fields: [
        {
          bits: "5+3:5", // 2 bits for status
          name: "CL_STATUS",
          desc: "Contain the current status of the corresponding cache line                [0]: valid, [1]: dirty, [2]: cmpt",
        }
      ]
    },
    { name:     "TAG_240",
      desc:     "Tag Address stored in cache line 240",
      swaccess: "rw",
      hwaccess: "hrw",
      hwext:    "true",
      hwqe:     "true", // enable `qe` latched signal of software write pulse
      hwre:     "true",
      fields: [
        { bits: "5-1:0",
          name: "CL_TAG",
          desc: "Tag Address"
        }
      ]
    },
    {
      name:     "STATUS_241",
      desc:     "Status register of cache line 241",
      swaccess: "rw",
      hwaccess: "hrw",
      hwext:    "true",
      hwqe:     "true", // enable `qe` latched signal of software write pulse
      hwre:     "true",
      fields: [
        {
          bits: "5+3:5", // 2 bits for status
          name: "CL_STATUS",
          desc: "Contain the current status of the corresponding cache line                [0]: valid, [1]: dirty, [2]: cmpt",
        }
      ]
    },
    { name:     "TAG_241",
      desc:     "Tag Address stored in cache line 241",
      swaccess: "rw",
      hwaccess: "hrw",
      hwext:    "true",
      hwqe:     "true", // enable `qe` latched signal of software write pulse
      hwre:     "true",
      fields: [
        { bits: "5-1:0",
          name: "CL_TAG",
          desc: "Tag Address"
        }
      ]
    },
    {
      name:     "STATUS_242",
      desc:     "Status register of cache line 242",
      swaccess: "rw",
      hwaccess: "hrw",
      hwext:    "true",
      hwqe:     "true", // enable `qe` latched signal of software write pulse
      hwre:     "true",
      fields: [
        {
          bits: "5+3:5", // 2 bits for status
          name: "CL_STATUS",
          desc: "Contain the current status of the corresponding cache line                [0]: valid, [1]: dirty, [2]: cmpt",
        }
      ]
    },
    { name:     "TAG_242",
      desc:     "Tag Address stored in cache line 242",
      swaccess: "rw",
      hwaccess: "hrw",
      hwext:    "true",
      hwqe:     "true", // enable `qe` latched signal of software write pulse
      hwre:     "true",
      fields: [
        { bits: "5-1:0",
          name: "CL_TAG",
          desc: "Tag Address"
        }
      ]
    },
    {
      name:     "STATUS_243",
      desc:     "Status register of cache line 243",
      swaccess: "rw",
      hwaccess: "hrw",
      hwext:    "true",
      hwqe:     "true", // enable `qe` latched signal of software write pulse
      hwre:     "true",
      fields: [
        {
          bits: "5+3:5", // 2 bits for status
          name: "CL_STATUS",
          desc: "Contain the current status of the corresponding cache line                [0]: valid, [1]: dirty, [2]: cmpt",
        }
      ]
    },
    { name:     "TAG_243",
      desc:     "Tag Address stored in cache line 243",
      swaccess: "rw",
      hwaccess: "hrw",
      hwext:    "true",
      hwqe:     "true", // enable `qe` latched signal of software write pulse
      hwre:     "true",
      fields: [
        { bits: "5-1:0",
          name: "CL_TAG",
          desc: "Tag Address"
        }
      ]
    },
    {
      name:     "STATUS_244",
      desc:     "Status register of cache line 244",
      swaccess: "rw",
      hwaccess: "hrw",
      hwext:    "true",
      hwqe:     "true", // enable `qe` latched signal of software write pulse
      hwre:     "true",
      fields: [
        {
          bits: "5+3:5", // 2 bits for status
          name: "CL_STATUS",
          desc: "Contain the current status of the corresponding cache line                [0]: valid, [1]: dirty, [2]: cmpt",
        }
      ]
    },
    { name:     "TAG_244",
      desc:     "Tag Address stored in cache line 244",
      swaccess: "rw",
      hwaccess: "hrw",
      hwext:    "true",
      hwqe:     "true", // enable `qe` latched signal of software write pulse
      hwre:     "true",
      fields: [
        { bits: "5-1:0",
          name: "CL_TAG",
          desc: "Tag Address"
        }
      ]
    },
    {
      name:     "STATUS_245",
      desc:     "Status register of cache line 245",
      swaccess: "rw",
      hwaccess: "hrw",
      hwext:    "true",
      hwqe:     "true", // enable `qe` latched signal of software write pulse
      hwre:     "true",
      fields: [
        {
          bits: "5+3:5", // 2 bits for status
          name: "CL_STATUS",
          desc: "Contain the current status of the corresponding cache line                [0]: valid, [1]: dirty, [2]: cmpt",
        }
      ]
    },
    { name:     "TAG_245",
      desc:     "Tag Address stored in cache line 245",
      swaccess: "rw",
      hwaccess: "hrw",
      hwext:    "true",
      hwqe:     "true", // enable `qe` latched signal of software write pulse
      hwre:     "true",
      fields: [
        { bits: "5-1:0",
          name: "CL_TAG",
          desc: "Tag Address"
        }
      ]
    },
    {
      name:     "STATUS_246",
      desc:     "Status register of cache line 246",
      swaccess: "rw",
      hwaccess: "hrw",
      hwext:    "true",
      hwqe:     "true", // enable `qe` latched signal of software write pulse
      hwre:     "true",
      fields: [
        {
          bits: "5+3:5", // 2 bits for status
          name: "CL_STATUS",
          desc: "Contain the current status of the corresponding cache line                [0]: valid, [1]: dirty, [2]: cmpt",
        }
      ]
    },
    { name:     "TAG_246",
      desc:     "Tag Address stored in cache line 246",
      swaccess: "rw",
      hwaccess: "hrw",
      hwext:    "true",
      hwqe:     "true", // enable `qe` latched signal of software write pulse
      hwre:     "true",
      fields: [
        { bits: "5-1:0",
          name: "CL_TAG",
          desc: "Tag Address"
        }
      ]
    },
    {
      name:     "STATUS_247",
      desc:     "Status register of cache line 247",
      swaccess: "rw",
      hwaccess: "hrw",
      hwext:    "true",
      hwqe:     "true", // enable `qe` latched signal of software write pulse
      hwre:     "true",
      fields: [
        {
          bits: "5+3:5", // 2 bits for status
          name: "CL_STATUS",
          desc: "Contain the current status of the corresponding cache line                [0]: valid, [1]: dirty, [2]: cmpt",
        }
      ]
    },
    { name:     "TAG_247",
      desc:     "Tag Address stored in cache line 247",
      swaccess: "rw",
      hwaccess: "hrw",
      hwext:    "true",
      hwqe:     "true", // enable `qe` latched signal of software write pulse
      hwre:     "true",
      fields: [
        { bits: "5-1:0",
          name: "CL_TAG",
          desc: "Tag Address"
        }
      ]
    },
    {
      name:     "STATUS_248",
      desc:     "Status register of cache line 248",
      swaccess: "rw",
      hwaccess: "hrw",
      hwext:    "true",
      hwqe:     "true", // enable `qe` latched signal of software write pulse
      hwre:     "true",
      fields: [
        {
          bits: "5+3:5", // 2 bits for status
          name: "CL_STATUS",
          desc: "Contain the current status of the corresponding cache line                [0]: valid, [1]: dirty, [2]: cmpt",
        }
      ]
    },
    { name:     "TAG_248",
      desc:     "Tag Address stored in cache line 248",
      swaccess: "rw",
      hwaccess: "hrw",
      hwext:    "true",
      hwqe:     "true", // enable `qe` latched signal of software write pulse
      hwre:     "true",
      fields: [
        { bits: "5-1:0",
          name: "CL_TAG",
          desc: "Tag Address"
        }
      ]
    },
    {
      name:     "STATUS_249",
      desc:     "Status register of cache line 249",
      swaccess: "rw",
      hwaccess: "hrw",
      hwext:    "true",
      hwqe:     "true", // enable `qe` latched signal of software write pulse
      hwre:     "true",
      fields: [
        {
          bits: "5+3:5", // 2 bits for status
          name: "CL_STATUS",
          desc: "Contain the current status of the corresponding cache line                [0]: valid, [1]: dirty, [2]: cmpt",
        }
      ]
    },
    { name:     "TAG_249",
      desc:     "Tag Address stored in cache line 249",
      swaccess: "rw",
      hwaccess: "hrw",
      hwext:    "true",
      hwqe:     "true", // enable `qe` latched signal of software write pulse
      hwre:     "true",
      fields: [
        { bits: "5-1:0",
          name: "CL_TAG",
          desc: "Tag Address"
        }
      ]
    },
    {
      name:     "STATUS_250",
      desc:     "Status register of cache line 250",
      swaccess: "rw",
      hwaccess: "hrw",
      hwext:    "true",
      hwqe:     "true", // enable `qe` latched signal of software write pulse
      hwre:     "true",
      fields: [
        {
          bits: "5+3:5", // 2 bits for status
          name: "CL_STATUS",
          desc: "Contain the current status of the corresponding cache line                [0]: valid, [1]: dirty, [2]: cmpt",
        }
      ]
    },
    { name:     "TAG_250",
      desc:     "Tag Address stored in cache line 250",
      swaccess: "rw",
      hwaccess: "hrw",
      hwext:    "true",
      hwqe:     "true", // enable `qe` latched signal of software write pulse
      hwre:     "true",
      fields: [
        { bits: "5-1:0",
          name: "CL_TAG",
          desc: "Tag Address"
        }
      ]
    },
    {
      name:     "STATUS_251",
      desc:     "Status register of cache line 251",
      swaccess: "rw",
      hwaccess: "hrw",
      hwext:    "true",
      hwqe:     "true", // enable `qe` latched signal of software write pulse
      hwre:     "true",
      fields: [
        {
          bits: "5+3:5", // 2 bits for status
          name: "CL_STATUS",
          desc: "Contain the current status of the corresponding cache line                [0]: valid, [1]: dirty, [2]: cmpt",
        }
      ]
    },
    { name:     "TAG_251",
      desc:     "Tag Address stored in cache line 251",
      swaccess: "rw",
      hwaccess: "hrw",
      hwext:    "true",
      hwqe:     "true", // enable `qe` latched signal of software write pulse
      hwre:     "true",
      fields: [
        { bits: "5-1:0",
          name: "CL_TAG",
          desc: "Tag Address"
        }
      ]
    },
    {
      name:     "STATUS_252",
      desc:     "Status register of cache line 252",
      swaccess: "rw",
      hwaccess: "hrw",
      hwext:    "true",
      hwqe:     "true", // enable `qe` latched signal of software write pulse
      hwre:     "true",
      fields: [
        {
          bits: "5+3:5", // 2 bits for status
          name: "CL_STATUS",
          desc: "Contain the current status of the corresponding cache line                [0]: valid, [1]: dirty, [2]: cmpt",
        }
      ]
    },
    { name:     "TAG_252",
      desc:     "Tag Address stored in cache line 252",
      swaccess: "rw",
      hwaccess: "hrw",
      hwext:    "true",
      hwqe:     "true", // enable `qe` latched signal of software write pulse
      hwre:     "true",
      fields: [
        { bits: "5-1:0",
          name: "CL_TAG",
          desc: "Tag Address"
        }
      ]
    },
    {
      name:     "STATUS_253",
      desc:     "Status register of cache line 253",
      swaccess: "rw",
      hwaccess: "hrw",
      hwext:    "true",
      hwqe:     "true", // enable `qe` latched signal of software write pulse
      hwre:     "true",
      fields: [
        {
          bits: "5+3:5", // 2 bits for status
          name: "CL_STATUS",
          desc: "Contain the current status of the corresponding cache line                [0]: valid, [1]: dirty, [2]: cmpt",
        }
      ]
    },
    { name:     "TAG_253",
      desc:     "Tag Address stored in cache line 253",
      swaccess: "rw",
      hwaccess: "hrw",
      hwext:    "true",
      hwqe:     "true", // enable `qe` latched signal of software write pulse
      hwre:     "true",
      fields: [
        { bits: "5-1:0",
          name: "CL_TAG",
          desc: "Tag Address"
        }
      ]
    },
    {
      name:     "STATUS_254",
      desc:     "Status register of cache line 254",
      swaccess: "rw",
      hwaccess: "hrw",
      hwext:    "true",
      hwqe:     "true", // enable `qe` latched signal of software write pulse
      hwre:     "true",
      fields: [
        {
          bits: "5+3:5", // 2 bits for status
          name: "CL_STATUS",
          desc: "Contain the current status of the corresponding cache line                [0]: valid, [1]: dirty, [2]: cmpt",
        }
      ]
    },
    { name:     "TAG_254",
      desc:     "Tag Address stored in cache line 254",
      swaccess: "rw",
      hwaccess: "hrw",
      hwext:    "true",
      hwqe:     "true", // enable `qe` latched signal of software write pulse
      hwre:     "true",
      fields: [
        { bits: "5-1:0",
          name: "CL_TAG",
          desc: "Tag Address"
        }
      ]
    },
    {
      name:     "STATUS_255",
      desc:     "Status register of cache line 255",
      swaccess: "rw",
      hwaccess: "hrw",
      hwext:    "true",
      hwqe:     "true", // enable `qe` latched signal of software write pulse
      hwre:     "true",
      fields: [
        {
          bits: "5+3:5", // 2 bits for status
          name: "CL_STATUS",
          desc: "Contain the current status of the corresponding cache line                [0]: valid, [1]: dirty, [2]: cmpt",
        }
      ]
    },
    { name:     "TAG_255",
      desc:     "Tag Address stored in cache line 255",
      swaccess: "rw",
      hwaccess: "hrw",
      hwext:    "true",
      hwqe:     "true", // enable `qe` latched signal of software write pulse
      hwre:     "true",
      fields: [
        { bits: "5-1:0",
          name: "CL_TAG",
          desc: "Tag Address"
        }
      ]
    },
    {
      name:     "STATUS_256",
      desc:     "Status register of cache line 256",
      swaccess: "rw",
      hwaccess: "hrw",
      hwext:    "true",
      hwqe:     "true", // enable `qe` latched signal of software write pulse
      hwre:     "true",
      fields: [
        {
          bits: "5+3:5", // 2 bits for status
          name: "CL_STATUS",
          desc: "Contain the current status of the corresponding cache line                [0]: valid, [1]: dirty, [2]: cmpt",
        }
      ]
    },
    { name:     "TAG_256",
      desc:     "Tag Address stored in cache line 256",
      swaccess: "rw",
      hwaccess: "hrw",
      hwext:    "true",
      hwqe:     "true", // enable `qe` latched signal of software write pulse
      hwre:     "true",
      fields: [
        { bits: "5-1:0",
          name: "CL_TAG",
          desc: "Tag Address"
        }
      ]
    },
    {
      name:     "STATUS_257",
      desc:     "Status register of cache line 257",
      swaccess: "rw",
      hwaccess: "hrw",
      hwext:    "true",
      hwqe:     "true", // enable `qe` latched signal of software write pulse
      hwre:     "true",
      fields: [
        {
          bits: "5+3:5", // 2 bits for status
          name: "CL_STATUS",
          desc: "Contain the current status of the corresponding cache line                [0]: valid, [1]: dirty, [2]: cmpt",
        }
      ]
    },
    { name:     "TAG_257",
      desc:     "Tag Address stored in cache line 257",
      swaccess: "rw",
      hwaccess: "hrw",
      hwext:    "true",
      hwqe:     "true", // enable `qe` latched signal of software write pulse
      hwre:     "true",
      fields: [
        { bits: "5-1:0",
          name: "CL_TAG",
          desc: "Tag Address"
        }
      ]
    },
    {
      name:     "STATUS_258",
      desc:     "Status register of cache line 258",
      swaccess: "rw",
      hwaccess: "hrw",
      hwext:    "true",
      hwqe:     "true", // enable `qe` latched signal of software write pulse
      hwre:     "true",
      fields: [
        {
          bits: "5+3:5", // 2 bits for status
          name: "CL_STATUS",
          desc: "Contain the current status of the corresponding cache line                [0]: valid, [1]: dirty, [2]: cmpt",
        }
      ]
    },
    { name:     "TAG_258",
      desc:     "Tag Address stored in cache line 258",
      swaccess: "rw",
      hwaccess: "hrw",
      hwext:    "true",
      hwqe:     "true", // enable `qe` latched signal of software write pulse
      hwre:     "true",
      fields: [
        { bits: "5-1:0",
          name: "CL_TAG",
          desc: "Tag Address"
        }
      ]
    },
    {
      name:     "STATUS_259",
      desc:     "Status register of cache line 259",
      swaccess: "rw",
      hwaccess: "hrw",
      hwext:    "true",
      hwqe:     "true", // enable `qe` latched signal of software write pulse
      hwre:     "true",
      fields: [
        {
          bits: "5+3:5", // 2 bits for status
          name: "CL_STATUS",
          desc: "Contain the current status of the corresponding cache line                [0]: valid, [1]: dirty, [2]: cmpt",
        }
      ]
    },
    { name:     "TAG_259",
      desc:     "Tag Address stored in cache line 259",
      swaccess: "rw",
      hwaccess: "hrw",
      hwext:    "true",
      hwqe:     "true", // enable `qe` latched signal of software write pulse
      hwre:     "true",
      fields: [
        { bits: "5-1:0",
          name: "CL_TAG",
          desc: "Tag Address"
        }
      ]
    },
    {
      name:     "STATUS_260",
      desc:     "Status register of cache line 260",
      swaccess: "rw",
      hwaccess: "hrw",
      hwext:    "true",
      hwqe:     "true", // enable `qe` latched signal of software write pulse
      hwre:     "true",
      fields: [
        {
          bits: "5+3:5", // 2 bits for status
          name: "CL_STATUS",
          desc: "Contain the current status of the corresponding cache line                [0]: valid, [1]: dirty, [2]: cmpt",
        }
      ]
    },
    { name:     "TAG_260",
      desc:     "Tag Address stored in cache line 260",
      swaccess: "rw",
      hwaccess: "hrw",
      hwext:    "true",
      hwqe:     "true", // enable `qe` latched signal of software write pulse
      hwre:     "true",
      fields: [
        { bits: "5-1:0",
          name: "CL_TAG",
          desc: "Tag Address"
        }
      ]
    },
    {
      name:     "STATUS_261",
      desc:     "Status register of cache line 261",
      swaccess: "rw",
      hwaccess: "hrw",
      hwext:    "true",
      hwqe:     "true", // enable `qe` latched signal of software write pulse
      hwre:     "true",
      fields: [
        {
          bits: "5+3:5", // 2 bits for status
          name: "CL_STATUS",
          desc: "Contain the current status of the corresponding cache line                [0]: valid, [1]: dirty, [2]: cmpt",
        }
      ]
    },
    { name:     "TAG_261",
      desc:     "Tag Address stored in cache line 261",
      swaccess: "rw",
      hwaccess: "hrw",
      hwext:    "true",
      hwqe:     "true", // enable `qe` latched signal of software write pulse
      hwre:     "true",
      fields: [
        { bits: "5-1:0",
          name: "CL_TAG",
          desc: "Tag Address"
        }
      ]
    },
    {
      name:     "STATUS_262",
      desc:     "Status register of cache line 262",
      swaccess: "rw",
      hwaccess: "hrw",
      hwext:    "true",
      hwqe:     "true", // enable `qe` latched signal of software write pulse
      hwre:     "true",
      fields: [
        {
          bits: "5+3:5", // 2 bits for status
          name: "CL_STATUS",
          desc: "Contain the current status of the corresponding cache line                [0]: valid, [1]: dirty, [2]: cmpt",
        }
      ]
    },
    { name:     "TAG_262",
      desc:     "Tag Address stored in cache line 262",
      swaccess: "rw",
      hwaccess: "hrw",
      hwext:    "true",
      hwqe:     "true", // enable `qe` latched signal of software write pulse
      hwre:     "true",
      fields: [
        { bits: "5-1:0",
          name: "CL_TAG",
          desc: "Tag Address"
        }
      ]
    },
    {
      name:     "STATUS_263",
      desc:     "Status register of cache line 263",
      swaccess: "rw",
      hwaccess: "hrw",
      hwext:    "true",
      hwqe:     "true", // enable `qe` latched signal of software write pulse
      hwre:     "true",
      fields: [
        {
          bits: "5+3:5", // 2 bits for status
          name: "CL_STATUS",
          desc: "Contain the current status of the corresponding cache line                [0]: valid, [1]: dirty, [2]: cmpt",
        }
      ]
    },
    { name:     "TAG_263",
      desc:     "Tag Address stored in cache line 263",
      swaccess: "rw",
      hwaccess: "hrw",
      hwext:    "true",
      hwqe:     "true", // enable `qe` latched signal of software write pulse
      hwre:     "true",
      fields: [
        { bits: "5-1:0",
          name: "CL_TAG",
          desc: "Tag Address"
        }
      ]
    },
    {
      name:     "STATUS_264",
      desc:     "Status register of cache line 264",
      swaccess: "rw",
      hwaccess: "hrw",
      hwext:    "true",
      hwqe:     "true", // enable `qe` latched signal of software write pulse
      hwre:     "true",
      fields: [
        {
          bits: "5+3:5", // 2 bits for status
          name: "CL_STATUS",
          desc: "Contain the current status of the corresponding cache line                [0]: valid, [1]: dirty, [2]: cmpt",
        }
      ]
    },
    { name:     "TAG_264",
      desc:     "Tag Address stored in cache line 264",
      swaccess: "rw",
      hwaccess: "hrw",
      hwext:    "true",
      hwqe:     "true", // enable `qe` latched signal of software write pulse
      hwre:     "true",
      fields: [
        { bits: "5-1:0",
          name: "CL_TAG",
          desc: "Tag Address"
        }
      ]
    },
    {
      name:     "STATUS_265",
      desc:     "Status register of cache line 265",
      swaccess: "rw",
      hwaccess: "hrw",
      hwext:    "true",
      hwqe:     "true", // enable `qe` latched signal of software write pulse
      hwre:     "true",
      fields: [
        {
          bits: "5+3:5", // 2 bits for status
          name: "CL_STATUS",
          desc: "Contain the current status of the corresponding cache line                [0]: valid, [1]: dirty, [2]: cmpt",
        }
      ]
    },
    { name:     "TAG_265",
      desc:     "Tag Address stored in cache line 265",
      swaccess: "rw",
      hwaccess: "hrw",
      hwext:    "true",
      hwqe:     "true", // enable `qe` latched signal of software write pulse
      hwre:     "true",
      fields: [
        { bits: "5-1:0",
          name: "CL_TAG",
          desc: "Tag Address"
        }
      ]
    },
    {
      name:     "STATUS_266",
      desc:     "Status register of cache line 266",
      swaccess: "rw",
      hwaccess: "hrw",
      hwext:    "true",
      hwqe:     "true", // enable `qe` latched signal of software write pulse
      hwre:     "true",
      fields: [
        {
          bits: "5+3:5", // 2 bits for status
          name: "CL_STATUS",
          desc: "Contain the current status of the corresponding cache line                [0]: valid, [1]: dirty, [2]: cmpt",
        }
      ]
    },
    { name:     "TAG_266",
      desc:     "Tag Address stored in cache line 266",
      swaccess: "rw",
      hwaccess: "hrw",
      hwext:    "true",
      hwqe:     "true", // enable `qe` latched signal of software write pulse
      hwre:     "true",
      fields: [
        { bits: "5-1:0",
          name: "CL_TAG",
          desc: "Tag Address"
        }
      ]
    },
    {
      name:     "STATUS_267",
      desc:     "Status register of cache line 267",
      swaccess: "rw",
      hwaccess: "hrw",
      hwext:    "true",
      hwqe:     "true", // enable `qe` latched signal of software write pulse
      hwre:     "true",
      fields: [
        {
          bits: "5+3:5", // 2 bits for status
          name: "CL_STATUS",
          desc: "Contain the current status of the corresponding cache line                [0]: valid, [1]: dirty, [2]: cmpt",
        }
      ]
    },
    { name:     "TAG_267",
      desc:     "Tag Address stored in cache line 267",
      swaccess: "rw",
      hwaccess: "hrw",
      hwext:    "true",
      hwqe:     "true", // enable `qe` latched signal of software write pulse
      hwre:     "true",
      fields: [
        { bits: "5-1:0",
          name: "CL_TAG",
          desc: "Tag Address"
        }
      ]
    },
    {
      name:     "STATUS_268",
      desc:     "Status register of cache line 268",
      swaccess: "rw",
      hwaccess: "hrw",
      hwext:    "true",
      hwqe:     "true", // enable `qe` latched signal of software write pulse
      hwre:     "true",
      fields: [
        {
          bits: "5+3:5", // 2 bits for status
          name: "CL_STATUS",
          desc: "Contain the current status of the corresponding cache line                [0]: valid, [1]: dirty, [2]: cmpt",
        }
      ]
    },
    { name:     "TAG_268",
      desc:     "Tag Address stored in cache line 268",
      swaccess: "rw",
      hwaccess: "hrw",
      hwext:    "true",
      hwqe:     "true", // enable `qe` latched signal of software write pulse
      hwre:     "true",
      fields: [
        { bits: "5-1:0",
          name: "CL_TAG",
          desc: "Tag Address"
        }
      ]
    },
    {
      name:     "STATUS_269",
      desc:     "Status register of cache line 269",
      swaccess: "rw",
      hwaccess: "hrw",
      hwext:    "true",
      hwqe:     "true", // enable `qe` latched signal of software write pulse
      hwre:     "true",
      fields: [
        {
          bits: "5+3:5", // 2 bits for status
          name: "CL_STATUS",
          desc: "Contain the current status of the corresponding cache line                [0]: valid, [1]: dirty, [2]: cmpt",
        }
      ]
    },
    { name:     "TAG_269",
      desc:     "Tag Address stored in cache line 269",
      swaccess: "rw",
      hwaccess: "hrw",
      hwext:    "true",
      hwqe:     "true", // enable `qe` latched signal of software write pulse
      hwre:     "true",
      fields: [
        { bits: "5-1:0",
          name: "CL_TAG",
          desc: "Tag Address"
        }
      ]
    },
    {
      name:     "STATUS_270",
      desc:     "Status register of cache line 270",
      swaccess: "rw",
      hwaccess: "hrw",
      hwext:    "true",
      hwqe:     "true", // enable `qe` latched signal of software write pulse
      hwre:     "true",
      fields: [
        {
          bits: "5+3:5", // 2 bits for status
          name: "CL_STATUS",
          desc: "Contain the current status of the corresponding cache line                [0]: valid, [1]: dirty, [2]: cmpt",
        }
      ]
    },
    { name:     "TAG_270",
      desc:     "Tag Address stored in cache line 270",
      swaccess: "rw",
      hwaccess: "hrw",
      hwext:    "true",
      hwqe:     "true", // enable `qe` latched signal of software write pulse
      hwre:     "true",
      fields: [
        { bits: "5-1:0",
          name: "CL_TAG",
          desc: "Tag Address"
        }
      ]
    },
    {
      name:     "STATUS_271",
      desc:     "Status register of cache line 271",
      swaccess: "rw",
      hwaccess: "hrw",
      hwext:    "true",
      hwqe:     "true", // enable `qe` latched signal of software write pulse
      hwre:     "true",
      fields: [
        {
          bits: "5+3:5", // 2 bits for status
          name: "CL_STATUS",
          desc: "Contain the current status of the corresponding cache line                [0]: valid, [1]: dirty, [2]: cmpt",
        }
      ]
    },
    { name:     "TAG_271",
      desc:     "Tag Address stored in cache line 271",
      swaccess: "rw",
      hwaccess: "hrw",
      hwext:    "true",
      hwqe:     "true", // enable `qe` latched signal of software write pulse
      hwre:     "true",
      fields: [
        { bits: "5-1:0",
          name: "CL_TAG",
          desc: "Tag Address"
        }
      ]
    },
    {
      name:     "STATUS_272",
      desc:     "Status register of cache line 272",
      swaccess: "rw",
      hwaccess: "hrw",
      hwext:    "true",
      hwqe:     "true", // enable `qe` latched signal of software write pulse
      hwre:     "true",
      fields: [
        {
          bits: "5+3:5", // 2 bits for status
          name: "CL_STATUS",
          desc: "Contain the current status of the corresponding cache line                [0]: valid, [1]: dirty, [2]: cmpt",
        }
      ]
    },
    { name:     "TAG_272",
      desc:     "Tag Address stored in cache line 272",
      swaccess: "rw",
      hwaccess: "hrw",
      hwext:    "true",
      hwqe:     "true", // enable `qe` latched signal of software write pulse
      hwre:     "true",
      fields: [
        { bits: "5-1:0",
          name: "CL_TAG",
          desc: "Tag Address"
        }
      ]
    },
    {
      name:     "STATUS_273",
      desc:     "Status register of cache line 273",
      swaccess: "rw",
      hwaccess: "hrw",
      hwext:    "true",
      hwqe:     "true", // enable `qe` latched signal of software write pulse
      hwre:     "true",
      fields: [
        {
          bits: "5+3:5", // 2 bits for status
          name: "CL_STATUS",
          desc: "Contain the current status of the corresponding cache line                [0]: valid, [1]: dirty, [2]: cmpt",
        }
      ]
    },
    { name:     "TAG_273",
      desc:     "Tag Address stored in cache line 273",
      swaccess: "rw",
      hwaccess: "hrw",
      hwext:    "true",
      hwqe:     "true", // enable `qe` latched signal of software write pulse
      hwre:     "true",
      fields: [
        { bits: "5-1:0",
          name: "CL_TAG",
          desc: "Tag Address"
        }
      ]
    },
    {
      name:     "STATUS_274",
      desc:     "Status register of cache line 274",
      swaccess: "rw",
      hwaccess: "hrw",
      hwext:    "true",
      hwqe:     "true", // enable `qe` latched signal of software write pulse
      hwre:     "true",
      fields: [
        {
          bits: "5+3:5", // 2 bits for status
          name: "CL_STATUS",
          desc: "Contain the current status of the corresponding cache line                [0]: valid, [1]: dirty, [2]: cmpt",
        }
      ]
    },
    { name:     "TAG_274",
      desc:     "Tag Address stored in cache line 274",
      swaccess: "rw",
      hwaccess: "hrw",
      hwext:    "true",
      hwqe:     "true", // enable `qe` latched signal of software write pulse
      hwre:     "true",
      fields: [
        { bits: "5-1:0",
          name: "CL_TAG",
          desc: "Tag Address"
        }
      ]
    },
    {
      name:     "STATUS_275",
      desc:     "Status register of cache line 275",
      swaccess: "rw",
      hwaccess: "hrw",
      hwext:    "true",
      hwqe:     "true", // enable `qe` latched signal of software write pulse
      hwre:     "true",
      fields: [
        {
          bits: "5+3:5", // 2 bits for status
          name: "CL_STATUS",
          desc: "Contain the current status of the corresponding cache line                [0]: valid, [1]: dirty, [2]: cmpt",
        }
      ]
    },
    { name:     "TAG_275",
      desc:     "Tag Address stored in cache line 275",
      swaccess: "rw",
      hwaccess: "hrw",
      hwext:    "true",
      hwqe:     "true", // enable `qe` latched signal of software write pulse
      hwre:     "true",
      fields: [
        { bits: "5-1:0",
          name: "CL_TAG",
          desc: "Tag Address"
        }
      ]
    },
    {
      name:     "STATUS_276",
      desc:     "Status register of cache line 276",
      swaccess: "rw",
      hwaccess: "hrw",
      hwext:    "true",
      hwqe:     "true", // enable `qe` latched signal of software write pulse
      hwre:     "true",
      fields: [
        {
          bits: "5+3:5", // 2 bits for status
          name: "CL_STATUS",
          desc: "Contain the current status of the corresponding cache line                [0]: valid, [1]: dirty, [2]: cmpt",
        }
      ]
    },
    { name:     "TAG_276",
      desc:     "Tag Address stored in cache line 276",
      swaccess: "rw",
      hwaccess: "hrw",
      hwext:    "true",
      hwqe:     "true", // enable `qe` latched signal of software write pulse
      hwre:     "true",
      fields: [
        { bits: "5-1:0",
          name: "CL_TAG",
          desc: "Tag Address"
        }
      ]
    },
    {
      name:     "STATUS_277",
      desc:     "Status register of cache line 277",
      swaccess: "rw",
      hwaccess: "hrw",
      hwext:    "true",
      hwqe:     "true", // enable `qe` latched signal of software write pulse
      hwre:     "true",
      fields: [
        {
          bits: "5+3:5", // 2 bits for status
          name: "CL_STATUS",
          desc: "Contain the current status of the corresponding cache line                [0]: valid, [1]: dirty, [2]: cmpt",
        }
      ]
    },
    { name:     "TAG_277",
      desc:     "Tag Address stored in cache line 277",
      swaccess: "rw",
      hwaccess: "hrw",
      hwext:    "true",
      hwqe:     "true", // enable `qe` latched signal of software write pulse
      hwre:     "true",
      fields: [
        { bits: "5-1:0",
          name: "CL_TAG",
          desc: "Tag Address"
        }
      ]
    },
    {
      name:     "STATUS_278",
      desc:     "Status register of cache line 278",
      swaccess: "rw",
      hwaccess: "hrw",
      hwext:    "true",
      hwqe:     "true", // enable `qe` latched signal of software write pulse
      hwre:     "true",
      fields: [
        {
          bits: "5+3:5", // 2 bits for status
          name: "CL_STATUS",
          desc: "Contain the current status of the corresponding cache line                [0]: valid, [1]: dirty, [2]: cmpt",
        }
      ]
    },
    { name:     "TAG_278",
      desc:     "Tag Address stored in cache line 278",
      swaccess: "rw",
      hwaccess: "hrw",
      hwext:    "true",
      hwqe:     "true", // enable `qe` latched signal of software write pulse
      hwre:     "true",
      fields: [
        { bits: "5-1:0",
          name: "CL_TAG",
          desc: "Tag Address"
        }
      ]
    },
    {
      name:     "STATUS_279",
      desc:     "Status register of cache line 279",
      swaccess: "rw",
      hwaccess: "hrw",
      hwext:    "true",
      hwqe:     "true", // enable `qe` latched signal of software write pulse
      hwre:     "true",
      fields: [
        {
          bits: "5+3:5", // 2 bits for status
          name: "CL_STATUS",
          desc: "Contain the current status of the corresponding cache line                [0]: valid, [1]: dirty, [2]: cmpt",
        }
      ]
    },
    { name:     "TAG_279",
      desc:     "Tag Address stored in cache line 279",
      swaccess: "rw",
      hwaccess: "hrw",
      hwext:    "true",
      hwqe:     "true", // enable `qe` latched signal of software write pulse
      hwre:     "true",
      fields: [
        { bits: "5-1:0",
          name: "CL_TAG",
          desc: "Tag Address"
        }
      ]
    },
    {
      name:     "STATUS_280",
      desc:     "Status register of cache line 280",
      swaccess: "rw",
      hwaccess: "hrw",
      hwext:    "true",
      hwqe:     "true", // enable `qe` latched signal of software write pulse
      hwre:     "true",
      fields: [
        {
          bits: "5+3:5", // 2 bits for status
          name: "CL_STATUS",
          desc: "Contain the current status of the corresponding cache line                [0]: valid, [1]: dirty, [2]: cmpt",
        }
      ]
    },
    { name:     "TAG_280",
      desc:     "Tag Address stored in cache line 280",
      swaccess: "rw",
      hwaccess: "hrw",
      hwext:    "true",
      hwqe:     "true", // enable `qe` latched signal of software write pulse
      hwre:     "true",
      fields: [
        { bits: "5-1:0",
          name: "CL_TAG",
          desc: "Tag Address"
        }
      ]
    },
    {
      name:     "STATUS_281",
      desc:     "Status register of cache line 281",
      swaccess: "rw",
      hwaccess: "hrw",
      hwext:    "true",
      hwqe:     "true", // enable `qe` latched signal of software write pulse
      hwre:     "true",
      fields: [
        {
          bits: "5+3:5", // 2 bits for status
          name: "CL_STATUS",
          desc: "Contain the current status of the corresponding cache line                [0]: valid, [1]: dirty, [2]: cmpt",
        }
      ]
    },
    { name:     "TAG_281",
      desc:     "Tag Address stored in cache line 281",
      swaccess: "rw",
      hwaccess: "hrw",
      hwext:    "true",
      hwqe:     "true", // enable `qe` latched signal of software write pulse
      hwre:     "true",
      fields: [
        { bits: "5-1:0",
          name: "CL_TAG",
          desc: "Tag Address"
        }
      ]
    },
    {
      name:     "STATUS_282",
      desc:     "Status register of cache line 282",
      swaccess: "rw",
      hwaccess: "hrw",
      hwext:    "true",
      hwqe:     "true", // enable `qe` latched signal of software write pulse
      hwre:     "true",
      fields: [
        {
          bits: "5+3:5", // 2 bits for status
          name: "CL_STATUS",
          desc: "Contain the current status of the corresponding cache line                [0]: valid, [1]: dirty, [2]: cmpt",
        }
      ]
    },
    { name:     "TAG_282",
      desc:     "Tag Address stored in cache line 282",
      swaccess: "rw",
      hwaccess: "hrw",
      hwext:    "true",
      hwqe:     "true", // enable `qe` latched signal of software write pulse
      hwre:     "true",
      fields: [
        { bits: "5-1:0",
          name: "CL_TAG",
          desc: "Tag Address"
        }
      ]
    },
    {
      name:     "STATUS_283",
      desc:     "Status register of cache line 283",
      swaccess: "rw",
      hwaccess: "hrw",
      hwext:    "true",
      hwqe:     "true", // enable `qe` latched signal of software write pulse
      hwre:     "true",
      fields: [
        {
          bits: "5+3:5", // 2 bits for status
          name: "CL_STATUS",
          desc: "Contain the current status of the corresponding cache line                [0]: valid, [1]: dirty, [2]: cmpt",
        }
      ]
    },
    { name:     "TAG_283",
      desc:     "Tag Address stored in cache line 283",
      swaccess: "rw",
      hwaccess: "hrw",
      hwext:    "true",
      hwqe:     "true", // enable `qe` latched signal of software write pulse
      hwre:     "true",
      fields: [
        { bits: "5-1:0",
          name: "CL_TAG",
          desc: "Tag Address"
        }
      ]
    },
    {
      name:     "STATUS_284",
      desc:     "Status register of cache line 284",
      swaccess: "rw",
      hwaccess: "hrw",
      hwext:    "true",
      hwqe:     "true", // enable `qe` latched signal of software write pulse
      hwre:     "true",
      fields: [
        {
          bits: "5+3:5", // 2 bits for status
          name: "CL_STATUS",
          desc: "Contain the current status of the corresponding cache line                [0]: valid, [1]: dirty, [2]: cmpt",
        }
      ]
    },
    { name:     "TAG_284",
      desc:     "Tag Address stored in cache line 284",
      swaccess: "rw",
      hwaccess: "hrw",
      hwext:    "true",
      hwqe:     "true", // enable `qe` latched signal of software write pulse
      hwre:     "true",
      fields: [
        { bits: "5-1:0",
          name: "CL_TAG",
          desc: "Tag Address"
        }
      ]
    },
    {
      name:     "STATUS_285",
      desc:     "Status register of cache line 285",
      swaccess: "rw",
      hwaccess: "hrw",
      hwext:    "true",
      hwqe:     "true", // enable `qe` latched signal of software write pulse
      hwre:     "true",
      fields: [
        {
          bits: "5+3:5", // 2 bits for status
          name: "CL_STATUS",
          desc: "Contain the current status of the corresponding cache line                [0]: valid, [1]: dirty, [2]: cmpt",
        }
      ]
    },
    { name:     "TAG_285",
      desc:     "Tag Address stored in cache line 285",
      swaccess: "rw",
      hwaccess: "hrw",
      hwext:    "true",
      hwqe:     "true", // enable `qe` latched signal of software write pulse
      hwre:     "true",
      fields: [
        { bits: "5-1:0",
          name: "CL_TAG",
          desc: "Tag Address"
        }
      ]
    },
    {
      name:     "STATUS_286",
      desc:     "Status register of cache line 286",
      swaccess: "rw",
      hwaccess: "hrw",
      hwext:    "true",
      hwqe:     "true", // enable `qe` latched signal of software write pulse
      hwre:     "true",
      fields: [
        {
          bits: "5+3:5", // 2 bits for status
          name: "CL_STATUS",
          desc: "Contain the current status of the corresponding cache line                [0]: valid, [1]: dirty, [2]: cmpt",
        }
      ]
    },
    { name:     "TAG_286",
      desc:     "Tag Address stored in cache line 286",
      swaccess: "rw",
      hwaccess: "hrw",
      hwext:    "true",
      hwqe:     "true", // enable `qe` latched signal of software write pulse
      hwre:     "true",
      fields: [
        { bits: "5-1:0",
          name: "CL_TAG",
          desc: "Tag Address"
        }
      ]
    },
    {
      name:     "STATUS_287",
      desc:     "Status register of cache line 287",
      swaccess: "rw",
      hwaccess: "hrw",
      hwext:    "true",
      hwqe:     "true", // enable `qe` latched signal of software write pulse
      hwre:     "true",
      fields: [
        {
          bits: "5+3:5", // 2 bits for status
          name: "CL_STATUS",
          desc: "Contain the current status of the corresponding cache line                [0]: valid, [1]: dirty, [2]: cmpt",
        }
      ]
    },
    { name:     "TAG_287",
      desc:     "Tag Address stored in cache line 287",
      swaccess: "rw",
      hwaccess: "hrw",
      hwext:    "true",
      hwqe:     "true", // enable `qe` latched signal of software write pulse
      hwre:     "true",
      fields: [
        { bits: "5-1:0",
          name: "CL_TAG",
          desc: "Tag Address"
        }
      ]
    },
    {
      name:     "STATUS_288",
      desc:     "Status register of cache line 288",
      swaccess: "rw",
      hwaccess: "hrw",
      hwext:    "true",
      hwqe:     "true", // enable `qe` latched signal of software write pulse
      hwre:     "true",
      fields: [
        {
          bits: "5+3:5", // 2 bits for status
          name: "CL_STATUS",
          desc: "Contain the current status of the corresponding cache line                [0]: valid, [1]: dirty, [2]: cmpt",
        }
      ]
    },
    { name:     "TAG_288",
      desc:     "Tag Address stored in cache line 288",
      swaccess: "rw",
      hwaccess: "hrw",
      hwext:    "true",
      hwqe:     "true", // enable `qe` latched signal of software write pulse
      hwre:     "true",
      fields: [
        { bits: "5-1:0",
          name: "CL_TAG",
          desc: "Tag Address"
        }
      ]
    },
    {
      name:     "STATUS_289",
      desc:     "Status register of cache line 289",
      swaccess: "rw",
      hwaccess: "hrw",
      hwext:    "true",
      hwqe:     "true", // enable `qe` latched signal of software write pulse
      hwre:     "true",
      fields: [
        {
          bits: "5+3:5", // 2 bits for status
          name: "CL_STATUS",
          desc: "Contain the current status of the corresponding cache line                [0]: valid, [1]: dirty, [2]: cmpt",
        }
      ]
    },
    { name:     "TAG_289",
      desc:     "Tag Address stored in cache line 289",
      swaccess: "rw",
      hwaccess: "hrw",
      hwext:    "true",
      hwqe:     "true", // enable `qe` latched signal of software write pulse
      hwre:     "true",
      fields: [
        { bits: "5-1:0",
          name: "CL_TAG",
          desc: "Tag Address"
        }
      ]
    },
    {
      name:     "STATUS_290",
      desc:     "Status register of cache line 290",
      swaccess: "rw",
      hwaccess: "hrw",
      hwext:    "true",
      hwqe:     "true", // enable `qe` latched signal of software write pulse
      hwre:     "true",
      fields: [
        {
          bits: "5+3:5", // 2 bits for status
          name: "CL_STATUS",
          desc: "Contain the current status of the corresponding cache line                [0]: valid, [1]: dirty, [2]: cmpt",
        }
      ]
    },
    { name:     "TAG_290",
      desc:     "Tag Address stored in cache line 290",
      swaccess: "rw",
      hwaccess: "hrw",
      hwext:    "true",
      hwqe:     "true", // enable `qe` latched signal of software write pulse
      hwre:     "true",
      fields: [
        { bits: "5-1:0",
          name: "CL_TAG",
          desc: "Tag Address"
        }
      ]
    },
    {
      name:     "STATUS_291",
      desc:     "Status register of cache line 291",
      swaccess: "rw",
      hwaccess: "hrw",
      hwext:    "true",
      hwqe:     "true", // enable `qe` latched signal of software write pulse
      hwre:     "true",
      fields: [
        {
          bits: "5+3:5", // 2 bits for status
          name: "CL_STATUS",
          desc: "Contain the current status of the corresponding cache line                [0]: valid, [1]: dirty, [2]: cmpt",
        }
      ]
    },
    { name:     "TAG_291",
      desc:     "Tag Address stored in cache line 291",
      swaccess: "rw",
      hwaccess: "hrw",
      hwext:    "true",
      hwqe:     "true", // enable `qe` latched signal of software write pulse
      hwre:     "true",
      fields: [
        { bits: "5-1:0",
          name: "CL_TAG",
          desc: "Tag Address"
        }
      ]
    },
    {
      name:     "STATUS_292",
      desc:     "Status register of cache line 292",
      swaccess: "rw",
      hwaccess: "hrw",
      hwext:    "true",
      hwqe:     "true", // enable `qe` latched signal of software write pulse
      hwre:     "true",
      fields: [
        {
          bits: "5+3:5", // 2 bits for status
          name: "CL_STATUS",
          desc: "Contain the current status of the corresponding cache line                [0]: valid, [1]: dirty, [2]: cmpt",
        }
      ]
    },
    { name:     "TAG_292",
      desc:     "Tag Address stored in cache line 292",
      swaccess: "rw",
      hwaccess: "hrw",
      hwext:    "true",
      hwqe:     "true", // enable `qe` latched signal of software write pulse
      hwre:     "true",
      fields: [
        { bits: "5-1:0",
          name: "CL_TAG",
          desc: "Tag Address"
        }
      ]
    },
    {
      name:     "STATUS_293",
      desc:     "Status register of cache line 293",
      swaccess: "rw",
      hwaccess: "hrw",
      hwext:    "true",
      hwqe:     "true", // enable `qe` latched signal of software write pulse
      hwre:     "true",
      fields: [
        {
          bits: "5+3:5", // 2 bits for status
          name: "CL_STATUS",
          desc: "Contain the current status of the corresponding cache line                [0]: valid, [1]: dirty, [2]: cmpt",
        }
      ]
    },
    { name:     "TAG_293",
      desc:     "Tag Address stored in cache line 293",
      swaccess: "rw",
      hwaccess: "hrw",
      hwext:    "true",
      hwqe:     "true", // enable `qe` latched signal of software write pulse
      hwre:     "true",
      fields: [
        { bits: "5-1:0",
          name: "CL_TAG",
          desc: "Tag Address"
        }
      ]
    },
    {
      name:     "STATUS_294",
      desc:     "Status register of cache line 294",
      swaccess: "rw",
      hwaccess: "hrw",
      hwext:    "true",
      hwqe:     "true", // enable `qe` latched signal of software write pulse
      hwre:     "true",
      fields: [
        {
          bits: "5+3:5", // 2 bits for status
          name: "CL_STATUS",
          desc: "Contain the current status of the corresponding cache line                [0]: valid, [1]: dirty, [2]: cmpt",
        }
      ]
    },
    { name:     "TAG_294",
      desc:     "Tag Address stored in cache line 294",
      swaccess: "rw",
      hwaccess: "hrw",
      hwext:    "true",
      hwqe:     "true", // enable `qe` latched signal of software write pulse
      hwre:     "true",
      fields: [
        { bits: "5-1:0",
          name: "CL_TAG",
          desc: "Tag Address"
        }
      ]
    },
    {
      name:     "STATUS_295",
      desc:     "Status register of cache line 295",
      swaccess: "rw",
      hwaccess: "hrw",
      hwext:    "true",
      hwqe:     "true", // enable `qe` latched signal of software write pulse
      hwre:     "true",
      fields: [
        {
          bits: "5+3:5", // 2 bits for status
          name: "CL_STATUS",
          desc: "Contain the current status of the corresponding cache line                [0]: valid, [1]: dirty, [2]: cmpt",
        }
      ]
    },
    { name:     "TAG_295",
      desc:     "Tag Address stored in cache line 295",
      swaccess: "rw",
      hwaccess: "hrw",
      hwext:    "true",
      hwqe:     "true", // enable `qe` latched signal of software write pulse
      hwre:     "true",
      fields: [
        { bits: "5-1:0",
          name: "CL_TAG",
          desc: "Tag Address"
        }
      ]
    },
    {
      name:     "STATUS_296",
      desc:     "Status register of cache line 296",
      swaccess: "rw",
      hwaccess: "hrw",
      hwext:    "true",
      hwqe:     "true", // enable `qe` latched signal of software write pulse
      hwre:     "true",
      fields: [
        {
          bits: "5+3:5", // 2 bits for status
          name: "CL_STATUS",
          desc: "Contain the current status of the corresponding cache line                [0]: valid, [1]: dirty, [2]: cmpt",
        }
      ]
    },
    { name:     "TAG_296",
      desc:     "Tag Address stored in cache line 296",
      swaccess: "rw",
      hwaccess: "hrw",
      hwext:    "true",
      hwqe:     "true", // enable `qe` latched signal of software write pulse
      hwre:     "true",
      fields: [
        { bits: "5-1:0",
          name: "CL_TAG",
          desc: "Tag Address"
        }
      ]
    },
    {
      name:     "STATUS_297",
      desc:     "Status register of cache line 297",
      swaccess: "rw",
      hwaccess: "hrw",
      hwext:    "true",
      hwqe:     "true", // enable `qe` latched signal of software write pulse
      hwre:     "true",
      fields: [
        {
          bits: "5+3:5", // 2 bits for status
          name: "CL_STATUS",
          desc: "Contain the current status of the corresponding cache line                [0]: valid, [1]: dirty, [2]: cmpt",
        }
      ]
    },
    { name:     "TAG_297",
      desc:     "Tag Address stored in cache line 297",
      swaccess: "rw",
      hwaccess: "hrw",
      hwext:    "true",
      hwqe:     "true", // enable `qe` latched signal of software write pulse
      hwre:     "true",
      fields: [
        { bits: "5-1:0",
          name: "CL_TAG",
          desc: "Tag Address"
        }
      ]
    },
    {
      name:     "STATUS_298",
      desc:     "Status register of cache line 298",
      swaccess: "rw",
      hwaccess: "hrw",
      hwext:    "true",
      hwqe:     "true", // enable `qe` latched signal of software write pulse
      hwre:     "true",
      fields: [
        {
          bits: "5+3:5", // 2 bits for status
          name: "CL_STATUS",
          desc: "Contain the current status of the corresponding cache line                [0]: valid, [1]: dirty, [2]: cmpt",
        }
      ]
    },
    { name:     "TAG_298",
      desc:     "Tag Address stored in cache line 298",
      swaccess: "rw",
      hwaccess: "hrw",
      hwext:    "true",
      hwqe:     "true", // enable `qe` latched signal of software write pulse
      hwre:     "true",
      fields: [
        { bits: "5-1:0",
          name: "CL_TAG",
          desc: "Tag Address"
        }
      ]
    },
    {
      name:     "STATUS_299",
      desc:     "Status register of cache line 299",
      swaccess: "rw",
      hwaccess: "hrw",
      hwext:    "true",
      hwqe:     "true", // enable `qe` latched signal of software write pulse
      hwre:     "true",
      fields: [
        {
          bits: "5+3:5", // 2 bits for status
          name: "CL_STATUS",
          desc: "Contain the current status of the corresponding cache line                [0]: valid, [1]: dirty, [2]: cmpt",
        }
      ]
    },
    { name:     "TAG_299",
      desc:     "Tag Address stored in cache line 299",
      swaccess: "rw",
      hwaccess: "hrw",
      hwext:    "true",
      hwqe:     "true", // enable `qe` latched signal of software write pulse
      hwre:     "true",
      fields: [
        { bits: "5-1:0",
          name: "CL_TAG",
          desc: "Tag Address"
        }
      ]
    },
    {
      name:     "STATUS_300",
      desc:     "Status register of cache line 300",
      swaccess: "rw",
      hwaccess: "hrw",
      hwext:    "true",
      hwqe:     "true", // enable `qe` latched signal of software write pulse
      hwre:     "true",
      fields: [
        {
          bits: "5+3:5", // 2 bits for status
          name: "CL_STATUS",
          desc: "Contain the current status of the corresponding cache line                [0]: valid, [1]: dirty, [2]: cmpt",
        }
      ]
    },
    { name:     "TAG_300",
      desc:     "Tag Address stored in cache line 300",
      swaccess: "rw",
      hwaccess: "hrw",
      hwext:    "true",
      hwqe:     "true", // enable `qe` latched signal of software write pulse
      hwre:     "true",
      fields: [
        { bits: "5-1:0",
          name: "CL_TAG",
          desc: "Tag Address"
        }
      ]
    },
    {
      name:     "STATUS_301",
      desc:     "Status register of cache line 301",
      swaccess: "rw",
      hwaccess: "hrw",
      hwext:    "true",
      hwqe:     "true", // enable `qe` latched signal of software write pulse
      hwre:     "true",
      fields: [
        {
          bits: "5+3:5", // 2 bits for status
          name: "CL_STATUS",
          desc: "Contain the current status of the corresponding cache line                [0]: valid, [1]: dirty, [2]: cmpt",
        }
      ]
    },
    { name:     "TAG_301",
      desc:     "Tag Address stored in cache line 301",
      swaccess: "rw",
      hwaccess: "hrw",
      hwext:    "true",
      hwqe:     "true", // enable `qe` latched signal of software write pulse
      hwre:     "true",
      fields: [
        { bits: "5-1:0",
          name: "CL_TAG",
          desc: "Tag Address"
        }
      ]
    },
    {
      name:     "STATUS_302",
      desc:     "Status register of cache line 302",
      swaccess: "rw",
      hwaccess: "hrw",
      hwext:    "true",
      hwqe:     "true", // enable `qe` latched signal of software write pulse
      hwre:     "true",
      fields: [
        {
          bits: "5+3:5", // 2 bits for status
          name: "CL_STATUS",
          desc: "Contain the current status of the corresponding cache line                [0]: valid, [1]: dirty, [2]: cmpt",
        }
      ]
    },
    { name:     "TAG_302",
      desc:     "Tag Address stored in cache line 302",
      swaccess: "rw",
      hwaccess: "hrw",
      hwext:    "true",
      hwqe:     "true", // enable `qe` latched signal of software write pulse
      hwre:     "true",
      fields: [
        { bits: "5-1:0",
          name: "CL_TAG",
          desc: "Tag Address"
        }
      ]
    },
    {
      name:     "STATUS_303",
      desc:     "Status register of cache line 303",
      swaccess: "rw",
      hwaccess: "hrw",
      hwext:    "true",
      hwqe:     "true", // enable `qe` latched signal of software write pulse
      hwre:     "true",
      fields: [
        {
          bits: "5+3:5", // 2 bits for status
          name: "CL_STATUS",
          desc: "Contain the current status of the corresponding cache line                [0]: valid, [1]: dirty, [2]: cmpt",
        }
      ]
    },
    { name:     "TAG_303",
      desc:     "Tag Address stored in cache line 303",
      swaccess: "rw",
      hwaccess: "hrw",
      hwext:    "true",
      hwqe:     "true", // enable `qe` latched signal of software write pulse
      hwre:     "true",
      fields: [
        { bits: "5-1:0",
          name: "CL_TAG",
          desc: "Tag Address"
        }
      ]
    },
    {
      name:     "STATUS_304",
      desc:     "Status register of cache line 304",
      swaccess: "rw",
      hwaccess: "hrw",
      hwext:    "true",
      hwqe:     "true", // enable `qe` latched signal of software write pulse
      hwre:     "true",
      fields: [
        {
          bits: "5+3:5", // 2 bits for status
          name: "CL_STATUS",
          desc: "Contain the current status of the corresponding cache line                [0]: valid, [1]: dirty, [2]: cmpt",
        }
      ]
    },
    { name:     "TAG_304",
      desc:     "Tag Address stored in cache line 304",
      swaccess: "rw",
      hwaccess: "hrw",
      hwext:    "true",
      hwqe:     "true", // enable `qe` latched signal of software write pulse
      hwre:     "true",
      fields: [
        { bits: "5-1:0",
          name: "CL_TAG",
          desc: "Tag Address"
        }
      ]
    },
    {
      name:     "STATUS_305",
      desc:     "Status register of cache line 305",
      swaccess: "rw",
      hwaccess: "hrw",
      hwext:    "true",
      hwqe:     "true", // enable `qe` latched signal of software write pulse
      hwre:     "true",
      fields: [
        {
          bits: "5+3:5", // 2 bits for status
          name: "CL_STATUS",
          desc: "Contain the current status of the corresponding cache line                [0]: valid, [1]: dirty, [2]: cmpt",
        }
      ]
    },
    { name:     "TAG_305",
      desc:     "Tag Address stored in cache line 305",
      swaccess: "rw",
      hwaccess: "hrw",
      hwext:    "true",
      hwqe:     "true", // enable `qe` latched signal of software write pulse
      hwre:     "true",
      fields: [
        { bits: "5-1:0",
          name: "CL_TAG",
          desc: "Tag Address"
        }
      ]
    },
    {
      name:     "STATUS_306",
      desc:     "Status register of cache line 306",
      swaccess: "rw",
      hwaccess: "hrw",
      hwext:    "true",
      hwqe:     "true", // enable `qe` latched signal of software write pulse
      hwre:     "true",
      fields: [
        {
          bits: "5+3:5", // 2 bits for status
          name: "CL_STATUS",
          desc: "Contain the current status of the corresponding cache line                [0]: valid, [1]: dirty, [2]: cmpt",
        }
      ]
    },
    { name:     "TAG_306",
      desc:     "Tag Address stored in cache line 306",
      swaccess: "rw",
      hwaccess: "hrw",
      hwext:    "true",
      hwqe:     "true", // enable `qe` latched signal of software write pulse
      hwre:     "true",
      fields: [
        { bits: "5-1:0",
          name: "CL_TAG",
          desc: "Tag Address"
        }
      ]
    },
    {
      name:     "STATUS_307",
      desc:     "Status register of cache line 307",
      swaccess: "rw",
      hwaccess: "hrw",
      hwext:    "true",
      hwqe:     "true", // enable `qe` latched signal of software write pulse
      hwre:     "true",
      fields: [
        {
          bits: "5+3:5", // 2 bits for status
          name: "CL_STATUS",
          desc: "Contain the current status of the corresponding cache line                [0]: valid, [1]: dirty, [2]: cmpt",
        }
      ]
    },
    { name:     "TAG_307",
      desc:     "Tag Address stored in cache line 307",
      swaccess: "rw",
      hwaccess: "hrw",
      hwext:    "true",
      hwqe:     "true", // enable `qe` latched signal of software write pulse
      hwre:     "true",
      fields: [
        { bits: "5-1:0",
          name: "CL_TAG",
          desc: "Tag Address"
        }
      ]
    },
    {
      name:     "STATUS_308",
      desc:     "Status register of cache line 308",
      swaccess: "rw",
      hwaccess: "hrw",
      hwext:    "true",
      hwqe:     "true", // enable `qe` latched signal of software write pulse
      hwre:     "true",
      fields: [
        {
          bits: "5+3:5", // 2 bits for status
          name: "CL_STATUS",
          desc: "Contain the current status of the corresponding cache line                [0]: valid, [1]: dirty, [2]: cmpt",
        }
      ]
    },
    { name:     "TAG_308",
      desc:     "Tag Address stored in cache line 308",
      swaccess: "rw",
      hwaccess: "hrw",
      hwext:    "true",
      hwqe:     "true", // enable `qe` latched signal of software write pulse
      hwre:     "true",
      fields: [
        { bits: "5-1:0",
          name: "CL_TAG",
          desc: "Tag Address"
        }
      ]
    },
    {
      name:     "STATUS_309",
      desc:     "Status register of cache line 309",
      swaccess: "rw",
      hwaccess: "hrw",
      hwext:    "true",
      hwqe:     "true", // enable `qe` latched signal of software write pulse
      hwre:     "true",
      fields: [
        {
          bits: "5+3:5", // 2 bits for status
          name: "CL_STATUS",
          desc: "Contain the current status of the corresponding cache line                [0]: valid, [1]: dirty, [2]: cmpt",
        }
      ]
    },
    { name:     "TAG_309",
      desc:     "Tag Address stored in cache line 309",
      swaccess: "rw",
      hwaccess: "hrw",
      hwext:    "true",
      hwqe:     "true", // enable `qe` latched signal of software write pulse
      hwre:     "true",
      fields: [
        { bits: "5-1:0",
          name: "CL_TAG",
          desc: "Tag Address"
        }
      ]
    },
    {
      name:     "STATUS_310",
      desc:     "Status register of cache line 310",
      swaccess: "rw",
      hwaccess: "hrw",
      hwext:    "true",
      hwqe:     "true", // enable `qe` latched signal of software write pulse
      hwre:     "true",
      fields: [
        {
          bits: "5+3:5", // 2 bits for status
          name: "CL_STATUS",
          desc: "Contain the current status of the corresponding cache line                [0]: valid, [1]: dirty, [2]: cmpt",
        }
      ]
    },
    { name:     "TAG_310",
      desc:     "Tag Address stored in cache line 310",
      swaccess: "rw",
      hwaccess: "hrw",
      hwext:    "true",
      hwqe:     "true", // enable `qe` latched signal of software write pulse
      hwre:     "true",
      fields: [
        { bits: "5-1:0",
          name: "CL_TAG",
          desc: "Tag Address"
        }
      ]
    },
    {
      name:     "STATUS_311",
      desc:     "Status register of cache line 311",
      swaccess: "rw",
      hwaccess: "hrw",
      hwext:    "true",
      hwqe:     "true", // enable `qe` latched signal of software write pulse
      hwre:     "true",
      fields: [
        {
          bits: "5+3:5", // 2 bits for status
          name: "CL_STATUS",
          desc: "Contain the current status of the corresponding cache line                [0]: valid, [1]: dirty, [2]: cmpt",
        }
      ]
    },
    { name:     "TAG_311",
      desc:     "Tag Address stored in cache line 311",
      swaccess: "rw",
      hwaccess: "hrw",
      hwext:    "true",
      hwqe:     "true", // enable `qe` latched signal of software write pulse
      hwre:     "true",
      fields: [
        { bits: "5-1:0",
          name: "CL_TAG",
          desc: "Tag Address"
        }
      ]
    },
    {
      name:     "STATUS_312",
      desc:     "Status register of cache line 312",
      swaccess: "rw",
      hwaccess: "hrw",
      hwext:    "true",
      hwqe:     "true", // enable `qe` latched signal of software write pulse
      hwre:     "true",
      fields: [
        {
          bits: "5+3:5", // 2 bits for status
          name: "CL_STATUS",
          desc: "Contain the current status of the corresponding cache line                [0]: valid, [1]: dirty, [2]: cmpt",
        }
      ]
    },
    { name:     "TAG_312",
      desc:     "Tag Address stored in cache line 312",
      swaccess: "rw",
      hwaccess: "hrw",
      hwext:    "true",
      hwqe:     "true", // enable `qe` latched signal of software write pulse
      hwre:     "true",
      fields: [
        { bits: "5-1:0",
          name: "CL_TAG",
          desc: "Tag Address"
        }
      ]
    },
    {
      name:     "STATUS_313",
      desc:     "Status register of cache line 313",
      swaccess: "rw",
      hwaccess: "hrw",
      hwext:    "true",
      hwqe:     "true", // enable `qe` latched signal of software write pulse
      hwre:     "true",
      fields: [
        {
          bits: "5+3:5", // 2 bits for status
          name: "CL_STATUS",
          desc: "Contain the current status of the corresponding cache line                [0]: valid, [1]: dirty, [2]: cmpt",
        }
      ]
    },
    { name:     "TAG_313",
      desc:     "Tag Address stored in cache line 313",
      swaccess: "rw",
      hwaccess: "hrw",
      hwext:    "true",
      hwqe:     "true", // enable `qe` latched signal of software write pulse
      hwre:     "true",
      fields: [
        { bits: "5-1:0",
          name: "CL_TAG",
          desc: "Tag Address"
        }
      ]
    },
    {
      name:     "STATUS_314",
      desc:     "Status register of cache line 314",
      swaccess: "rw",
      hwaccess: "hrw",
      hwext:    "true",
      hwqe:     "true", // enable `qe` latched signal of software write pulse
      hwre:     "true",
      fields: [
        {
          bits: "5+3:5", // 2 bits for status
          name: "CL_STATUS",
          desc: "Contain the current status of the corresponding cache line                [0]: valid, [1]: dirty, [2]: cmpt",
        }
      ]
    },
    { name:     "TAG_314",
      desc:     "Tag Address stored in cache line 314",
      swaccess: "rw",
      hwaccess: "hrw",
      hwext:    "true",
      hwqe:     "true", // enable `qe` latched signal of software write pulse
      hwre:     "true",
      fields: [
        { bits: "5-1:0",
          name: "CL_TAG",
          desc: "Tag Address"
        }
      ]
    },
    {
      name:     "STATUS_315",
      desc:     "Status register of cache line 315",
      swaccess: "rw",
      hwaccess: "hrw",
      hwext:    "true",
      hwqe:     "true", // enable `qe` latched signal of software write pulse
      hwre:     "true",
      fields: [
        {
          bits: "5+3:5", // 2 bits for status
          name: "CL_STATUS",
          desc: "Contain the current status of the corresponding cache line                [0]: valid, [1]: dirty, [2]: cmpt",
        }
      ]
    },
    { name:     "TAG_315",
      desc:     "Tag Address stored in cache line 315",
      swaccess: "rw",
      hwaccess: "hrw",
      hwext:    "true",
      hwqe:     "true", // enable `qe` latched signal of software write pulse
      hwre:     "true",
      fields: [
        { bits: "5-1:0",
          name: "CL_TAG",
          desc: "Tag Address"
        }
      ]
    },
    {
      name:     "STATUS_316",
      desc:     "Status register of cache line 316",
      swaccess: "rw",
      hwaccess: "hrw",
      hwext:    "true",
      hwqe:     "true", // enable `qe` latched signal of software write pulse
      hwre:     "true",
      fields: [
        {
          bits: "5+3:5", // 2 bits for status
          name: "CL_STATUS",
          desc: "Contain the current status of the corresponding cache line                [0]: valid, [1]: dirty, [2]: cmpt",
        }
      ]
    },
    { name:     "TAG_316",
      desc:     "Tag Address stored in cache line 316",
      swaccess: "rw",
      hwaccess: "hrw",
      hwext:    "true",
      hwqe:     "true", // enable `qe` latched signal of software write pulse
      hwre:     "true",
      fields: [
        { bits: "5-1:0",
          name: "CL_TAG",
          desc: "Tag Address"
        }
      ]
    },
    {
      name:     "STATUS_317",
      desc:     "Status register of cache line 317",
      swaccess: "rw",
      hwaccess: "hrw",
      hwext:    "true",
      hwqe:     "true", // enable `qe` latched signal of software write pulse
      hwre:     "true",
      fields: [
        {
          bits: "5+3:5", // 2 bits for status
          name: "CL_STATUS",
          desc: "Contain the current status of the corresponding cache line                [0]: valid, [1]: dirty, [2]: cmpt",
        }
      ]
    },
    { name:     "TAG_317",
      desc:     "Tag Address stored in cache line 317",
      swaccess: "rw",
      hwaccess: "hrw",
      hwext:    "true",
      hwqe:     "true", // enable `qe` latched signal of software write pulse
      hwre:     "true",
      fields: [
        { bits: "5-1:0",
          name: "CL_TAG",
          desc: "Tag Address"
        }
      ]
    },
    {
      name:     "STATUS_318",
      desc:     "Status register of cache line 318",
      swaccess: "rw",
      hwaccess: "hrw",
      hwext:    "true",
      hwqe:     "true", // enable `qe` latched signal of software write pulse
      hwre:     "true",
      fields: [
        {
          bits: "5+3:5", // 2 bits for status
          name: "CL_STATUS",
          desc: "Contain the current status of the corresponding cache line                [0]: valid, [1]: dirty, [2]: cmpt",
        }
      ]
    },
    { name:     "TAG_318",
      desc:     "Tag Address stored in cache line 318",
      swaccess: "rw",
      hwaccess: "hrw",
      hwext:    "true",
      hwqe:     "true", // enable `qe` latched signal of software write pulse
      hwre:     "true",
      fields: [
        { bits: "5-1:0",
          name: "CL_TAG",
          desc: "Tag Address"
        }
      ]
    },
    {
      name:     "STATUS_319",
      desc:     "Status register of cache line 319",
      swaccess: "rw",
      hwaccess: "hrw",
      hwext:    "true",
      hwqe:     "true", // enable `qe` latched signal of software write pulse
      hwre:     "true",
      fields: [
        {
          bits: "5+3:5", // 2 bits for status
          name: "CL_STATUS",
          desc: "Contain the current status of the corresponding cache line                [0]: valid, [1]: dirty, [2]: cmpt",
        }
      ]
    },
    { name:     "TAG_319",
      desc:     "Tag Address stored in cache line 319",
      swaccess: "rw",
      hwaccess: "hrw",
      hwext:    "true",
      hwqe:     "true", // enable `qe` latched signal of software write pulse
      hwre:     "true",
      fields: [
        { bits: "5-1:0",
          name: "CL_TAG",
          desc: "Tag Address"
        }
      ]
    },
    {
      name:     "STATUS_320",
      desc:     "Status register of cache line 320",
      swaccess: "rw",
      hwaccess: "hrw",
      hwext:    "true",
      hwqe:     "true", // enable `qe` latched signal of software write pulse
      hwre:     "true",
      fields: [
        {
          bits: "5+3:5", // 2 bits for status
          name: "CL_STATUS",
          desc: "Contain the current status of the corresponding cache line                [0]: valid, [1]: dirty, [2]: cmpt",
        }
      ]
    },
    { name:     "TAG_320",
      desc:     "Tag Address stored in cache line 320",
      swaccess: "rw",
      hwaccess: "hrw",
      hwext:    "true",
      hwqe:     "true", // enable `qe` latched signal of software write pulse
      hwre:     "true",
      fields: [
        { bits: "5-1:0",
          name: "CL_TAG",
          desc: "Tag Address"
        }
      ]
    },
    {
      name:     "STATUS_321",
      desc:     "Status register of cache line 321",
      swaccess: "rw",
      hwaccess: "hrw",
      hwext:    "true",
      hwqe:     "true", // enable `qe` latched signal of software write pulse
      hwre:     "true",
      fields: [
        {
          bits: "5+3:5", // 2 bits for status
          name: "CL_STATUS",
          desc: "Contain the current status of the corresponding cache line                [0]: valid, [1]: dirty, [2]: cmpt",
        }
      ]
    },
    { name:     "TAG_321",
      desc:     "Tag Address stored in cache line 321",
      swaccess: "rw",
      hwaccess: "hrw",
      hwext:    "true",
      hwqe:     "true", // enable `qe` latched signal of software write pulse
      hwre:     "true",
      fields: [
        { bits: "5-1:0",
          name: "CL_TAG",
          desc: "Tag Address"
        }
      ]
    },
    {
      name:     "STATUS_322",
      desc:     "Status register of cache line 322",
      swaccess: "rw",
      hwaccess: "hrw",
      hwext:    "true",
      hwqe:     "true", // enable `qe` latched signal of software write pulse
      hwre:     "true",
      fields: [
        {
          bits: "5+3:5", // 2 bits for status
          name: "CL_STATUS",
          desc: "Contain the current status of the corresponding cache line                [0]: valid, [1]: dirty, [2]: cmpt",
        }
      ]
    },
    { name:     "TAG_322",
      desc:     "Tag Address stored in cache line 322",
      swaccess: "rw",
      hwaccess: "hrw",
      hwext:    "true",
      hwqe:     "true", // enable `qe` latched signal of software write pulse
      hwre:     "true",
      fields: [
        { bits: "5-1:0",
          name: "CL_TAG",
          desc: "Tag Address"
        }
      ]
    },
    {
      name:     "STATUS_323",
      desc:     "Status register of cache line 323",
      swaccess: "rw",
      hwaccess: "hrw",
      hwext:    "true",
      hwqe:     "true", // enable `qe` latched signal of software write pulse
      hwre:     "true",
      fields: [
        {
          bits: "5+3:5", // 2 bits for status
          name: "CL_STATUS",
          desc: "Contain the current status of the corresponding cache line                [0]: valid, [1]: dirty, [2]: cmpt",
        }
      ]
    },
    { name:     "TAG_323",
      desc:     "Tag Address stored in cache line 323",
      swaccess: "rw",
      hwaccess: "hrw",
      hwext:    "true",
      hwqe:     "true", // enable `qe` latched signal of software write pulse
      hwre:     "true",
      fields: [
        { bits: "5-1:0",
          name: "CL_TAG",
          desc: "Tag Address"
        }
      ]
    },
    {
      name:     "STATUS_324",
      desc:     "Status register of cache line 324",
      swaccess: "rw",
      hwaccess: "hrw",
      hwext:    "true",
      hwqe:     "true", // enable `qe` latched signal of software write pulse
      hwre:     "true",
      fields: [
        {
          bits: "5+3:5", // 2 bits for status
          name: "CL_STATUS",
          desc: "Contain the current status of the corresponding cache line                [0]: valid, [1]: dirty, [2]: cmpt",
        }
      ]
    },
    { name:     "TAG_324",
      desc:     "Tag Address stored in cache line 324",
      swaccess: "rw",
      hwaccess: "hrw",
      hwext:    "true",
      hwqe:     "true", // enable `qe` latched signal of software write pulse
      hwre:     "true",
      fields: [
        { bits: "5-1:0",
          name: "CL_TAG",
          desc: "Tag Address"
        }
      ]
    },
    {
      name:     "STATUS_325",
      desc:     "Status register of cache line 325",
      swaccess: "rw",
      hwaccess: "hrw",
      hwext:    "true",
      hwqe:     "true", // enable `qe` latched signal of software write pulse
      hwre:     "true",
      fields: [
        {
          bits: "5+3:5", // 2 bits for status
          name: "CL_STATUS",
          desc: "Contain the current status of the corresponding cache line                [0]: valid, [1]: dirty, [2]: cmpt",
        }
      ]
    },
    { name:     "TAG_325",
      desc:     "Tag Address stored in cache line 325",
      swaccess: "rw",
      hwaccess: "hrw",
      hwext:    "true",
      hwqe:     "true", // enable `qe` latched signal of software write pulse
      hwre:     "true",
      fields: [
        { bits: "5-1:0",
          name: "CL_TAG",
          desc: "Tag Address"
        }
      ]
    },
    {
      name:     "STATUS_326",
      desc:     "Status register of cache line 326",
      swaccess: "rw",
      hwaccess: "hrw",
      hwext:    "true",
      hwqe:     "true", // enable `qe` latched signal of software write pulse
      hwre:     "true",
      fields: [
        {
          bits: "5+3:5", // 2 bits for status
          name: "CL_STATUS",
          desc: "Contain the current status of the corresponding cache line                [0]: valid, [1]: dirty, [2]: cmpt",
        }
      ]
    },
    { name:     "TAG_326",
      desc:     "Tag Address stored in cache line 326",
      swaccess: "rw",
      hwaccess: "hrw",
      hwext:    "true",
      hwqe:     "true", // enable `qe` latched signal of software write pulse
      hwre:     "true",
      fields: [
        { bits: "5-1:0",
          name: "CL_TAG",
          desc: "Tag Address"
        }
      ]
    },
    {
      name:     "STATUS_327",
      desc:     "Status register of cache line 327",
      swaccess: "rw",
      hwaccess: "hrw",
      hwext:    "true",
      hwqe:     "true", // enable `qe` latched signal of software write pulse
      hwre:     "true",
      fields: [
        {
          bits: "5+3:5", // 2 bits for status
          name: "CL_STATUS",
          desc: "Contain the current status of the corresponding cache line                [0]: valid, [1]: dirty, [2]: cmpt",
        }
      ]
    },
    { name:     "TAG_327",
      desc:     "Tag Address stored in cache line 327",
      swaccess: "rw",
      hwaccess: "hrw",
      hwext:    "true",
      hwqe:     "true", // enable `qe` latched signal of software write pulse
      hwre:     "true",
      fields: [
        { bits: "5-1:0",
          name: "CL_TAG",
          desc: "Tag Address"
        }
      ]
    },
    {
      name:     "STATUS_328",
      desc:     "Status register of cache line 328",
      swaccess: "rw",
      hwaccess: "hrw",
      hwext:    "true",
      hwqe:     "true", // enable `qe` latched signal of software write pulse
      hwre:     "true",
      fields: [
        {
          bits: "5+3:5", // 2 bits for status
          name: "CL_STATUS",
          desc: "Contain the current status of the corresponding cache line                [0]: valid, [1]: dirty, [2]: cmpt",
        }
      ]
    },
    { name:     "TAG_328",
      desc:     "Tag Address stored in cache line 328",
      swaccess: "rw",
      hwaccess: "hrw",
      hwext:    "true",
      hwqe:     "true", // enable `qe` latched signal of software write pulse
      hwre:     "true",
      fields: [
        { bits: "5-1:0",
          name: "CL_TAG",
          desc: "Tag Address"
        }
      ]
    },
    {
      name:     "STATUS_329",
      desc:     "Status register of cache line 329",
      swaccess: "rw",
      hwaccess: "hrw",
      hwext:    "true",
      hwqe:     "true", // enable `qe` latched signal of software write pulse
      hwre:     "true",
      fields: [
        {
          bits: "5+3:5", // 2 bits for status
          name: "CL_STATUS",
          desc: "Contain the current status of the corresponding cache line                [0]: valid, [1]: dirty, [2]: cmpt",
        }
      ]
    },
    { name:     "TAG_329",
      desc:     "Tag Address stored in cache line 329",
      swaccess: "rw",
      hwaccess: "hrw",
      hwext:    "true",
      hwqe:     "true", // enable `qe` latched signal of software write pulse
      hwre:     "true",
      fields: [
        { bits: "5-1:0",
          name: "CL_TAG",
          desc: "Tag Address"
        }
      ]
    },
    {
      name:     "STATUS_330",
      desc:     "Status register of cache line 330",
      swaccess: "rw",
      hwaccess: "hrw",
      hwext:    "true",
      hwqe:     "true", // enable `qe` latched signal of software write pulse
      hwre:     "true",
      fields: [
        {
          bits: "5+3:5", // 2 bits for status
          name: "CL_STATUS",
          desc: "Contain the current status of the corresponding cache line                [0]: valid, [1]: dirty, [2]: cmpt",
        }
      ]
    },
    { name:     "TAG_330",
      desc:     "Tag Address stored in cache line 330",
      swaccess: "rw",
      hwaccess: "hrw",
      hwext:    "true",
      hwqe:     "true", // enable `qe` latched signal of software write pulse
      hwre:     "true",
      fields: [
        { bits: "5-1:0",
          name: "CL_TAG",
          desc: "Tag Address"
        }
      ]
    },
    {
      name:     "STATUS_331",
      desc:     "Status register of cache line 331",
      swaccess: "rw",
      hwaccess: "hrw",
      hwext:    "true",
      hwqe:     "true", // enable `qe` latched signal of software write pulse
      hwre:     "true",
      fields: [
        {
          bits: "5+3:5", // 2 bits for status
          name: "CL_STATUS",
          desc: "Contain the current status of the corresponding cache line                [0]: valid, [1]: dirty, [2]: cmpt",
        }
      ]
    },
    { name:     "TAG_331",
      desc:     "Tag Address stored in cache line 331",
      swaccess: "rw",
      hwaccess: "hrw",
      hwext:    "true",
      hwqe:     "true", // enable `qe` latched signal of software write pulse
      hwre:     "true",
      fields: [
        { bits: "5-1:0",
          name: "CL_TAG",
          desc: "Tag Address"
        }
      ]
    },
    {
      name:     "STATUS_332",
      desc:     "Status register of cache line 332",
      swaccess: "rw",
      hwaccess: "hrw",
      hwext:    "true",
      hwqe:     "true", // enable `qe` latched signal of software write pulse
      hwre:     "true",
      fields: [
        {
          bits: "5+3:5", // 2 bits for status
          name: "CL_STATUS",
          desc: "Contain the current status of the corresponding cache line                [0]: valid, [1]: dirty, [2]: cmpt",
        }
      ]
    },
    { name:     "TAG_332",
      desc:     "Tag Address stored in cache line 332",
      swaccess: "rw",
      hwaccess: "hrw",
      hwext:    "true",
      hwqe:     "true", // enable `qe` latched signal of software write pulse
      hwre:     "true",
      fields: [
        { bits: "5-1:0",
          name: "CL_TAG",
          desc: "Tag Address"
        }
      ]
    },
    {
      name:     "STATUS_333",
      desc:     "Status register of cache line 333",
      swaccess: "rw",
      hwaccess: "hrw",
      hwext:    "true",
      hwqe:     "true", // enable `qe` latched signal of software write pulse
      hwre:     "true",
      fields: [
        {
          bits: "5+3:5", // 2 bits for status
          name: "CL_STATUS",
          desc: "Contain the current status of the corresponding cache line                [0]: valid, [1]: dirty, [2]: cmpt",
        }
      ]
    },
    { name:     "TAG_333",
      desc:     "Tag Address stored in cache line 333",
      swaccess: "rw",
      hwaccess: "hrw",
      hwext:    "true",
      hwqe:     "true", // enable `qe` latched signal of software write pulse
      hwre:     "true",
      fields: [
        { bits: "5-1:0",
          name: "CL_TAG",
          desc: "Tag Address"
        }
      ]
    },
    {
      name:     "STATUS_334",
      desc:     "Status register of cache line 334",
      swaccess: "rw",
      hwaccess: "hrw",
      hwext:    "true",
      hwqe:     "true", // enable `qe` latched signal of software write pulse
      hwre:     "true",
      fields: [
        {
          bits: "5+3:5", // 2 bits for status
          name: "CL_STATUS",
          desc: "Contain the current status of the corresponding cache line                [0]: valid, [1]: dirty, [2]: cmpt",
        }
      ]
    },
    { name:     "TAG_334",
      desc:     "Tag Address stored in cache line 334",
      swaccess: "rw",
      hwaccess: "hrw",
      hwext:    "true",
      hwqe:     "true", // enable `qe` latched signal of software write pulse
      hwre:     "true",
      fields: [
        { bits: "5-1:0",
          name: "CL_TAG",
          desc: "Tag Address"
        }
      ]
    },
    {
      name:     "STATUS_335",
      desc:     "Status register of cache line 335",
      swaccess: "rw",
      hwaccess: "hrw",
      hwext:    "true",
      hwqe:     "true", // enable `qe` latched signal of software write pulse
      hwre:     "true",
      fields: [
        {
          bits: "5+3:5", // 2 bits for status
          name: "CL_STATUS",
          desc: "Contain the current status of the corresponding cache line                [0]: valid, [1]: dirty, [2]: cmpt",
        }
      ]
    },
    { name:     "TAG_335",
      desc:     "Tag Address stored in cache line 335",
      swaccess: "rw",
      hwaccess: "hrw",
      hwext:    "true",
      hwqe:     "true", // enable `qe` latched signal of software write pulse
      hwre:     "true",
      fields: [
        { bits: "5-1:0",
          name: "CL_TAG",
          desc: "Tag Address"
        }
      ]
    },
    {
      name:     "STATUS_336",
      desc:     "Status register of cache line 336",
      swaccess: "rw",
      hwaccess: "hrw",
      hwext:    "true",
      hwqe:     "true", // enable `qe` latched signal of software write pulse
      hwre:     "true",
      fields: [
        {
          bits: "5+3:5", // 2 bits for status
          name: "CL_STATUS",
          desc: "Contain the current status of the corresponding cache line                [0]: valid, [1]: dirty, [2]: cmpt",
        }
      ]
    },
    { name:     "TAG_336",
      desc:     "Tag Address stored in cache line 336",
      swaccess: "rw",
      hwaccess: "hrw",
      hwext:    "true",
      hwqe:     "true", // enable `qe` latched signal of software write pulse
      hwre:     "true",
      fields: [
        { bits: "5-1:0",
          name: "CL_TAG",
          desc: "Tag Address"
        }
      ]
    },
    {
      name:     "STATUS_337",
      desc:     "Status register of cache line 337",
      swaccess: "rw",
      hwaccess: "hrw",
      hwext:    "true",
      hwqe:     "true", // enable `qe` latched signal of software write pulse
      hwre:     "true",
      fields: [
        {
          bits: "5+3:5", // 2 bits for status
          name: "CL_STATUS",
          desc: "Contain the current status of the corresponding cache line                [0]: valid, [1]: dirty, [2]: cmpt",
        }
      ]
    },
    { name:     "TAG_337",
      desc:     "Tag Address stored in cache line 337",
      swaccess: "rw",
      hwaccess: "hrw",
      hwext:    "true",
      hwqe:     "true", // enable `qe` latched signal of software write pulse
      hwre:     "true",
      fields: [
        { bits: "5-1:0",
          name: "CL_TAG",
          desc: "Tag Address"
        }
      ]
    },
    {
      name:     "STATUS_338",
      desc:     "Status register of cache line 338",
      swaccess: "rw",
      hwaccess: "hrw",
      hwext:    "true",
      hwqe:     "true", // enable `qe` latched signal of software write pulse
      hwre:     "true",
      fields: [
        {
          bits: "5+3:5", // 2 bits for status
          name: "CL_STATUS",
          desc: "Contain the current status of the corresponding cache line                [0]: valid, [1]: dirty, [2]: cmpt",
        }
      ]
    },
    { name:     "TAG_338",
      desc:     "Tag Address stored in cache line 338",
      swaccess: "rw",
      hwaccess: "hrw",
      hwext:    "true",
      hwqe:     "true", // enable `qe` latched signal of software write pulse
      hwre:     "true",
      fields: [
        { bits: "5-1:0",
          name: "CL_TAG",
          desc: "Tag Address"
        }
      ]
    },
    {
      name:     "STATUS_339",
      desc:     "Status register of cache line 339",
      swaccess: "rw",
      hwaccess: "hrw",
      hwext:    "true",
      hwqe:     "true", // enable `qe` latched signal of software write pulse
      hwre:     "true",
      fields: [
        {
          bits: "5+3:5", // 2 bits for status
          name: "CL_STATUS",
          desc: "Contain the current status of the corresponding cache line                [0]: valid, [1]: dirty, [2]: cmpt",
        }
      ]
    },
    { name:     "TAG_339",
      desc:     "Tag Address stored in cache line 339",
      swaccess: "rw",
      hwaccess: "hrw",
      hwext:    "true",
      hwqe:     "true", // enable `qe` latched signal of software write pulse
      hwre:     "true",
      fields: [
        { bits: "5-1:0",
          name: "CL_TAG",
          desc: "Tag Address"
        }
      ]
    },
    {
      name:     "STATUS_340",
      desc:     "Status register of cache line 340",
      swaccess: "rw",
      hwaccess: "hrw",
      hwext:    "true",
      hwqe:     "true", // enable `qe` latched signal of software write pulse
      hwre:     "true",
      fields: [
        {
          bits: "5+3:5", // 2 bits for status
          name: "CL_STATUS",
          desc: "Contain the current status of the corresponding cache line                [0]: valid, [1]: dirty, [2]: cmpt",
        }
      ]
    },
    { name:     "TAG_340",
      desc:     "Tag Address stored in cache line 340",
      swaccess: "rw",
      hwaccess: "hrw",
      hwext:    "true",
      hwqe:     "true", // enable `qe` latched signal of software write pulse
      hwre:     "true",
      fields: [
        { bits: "5-1:0",
          name: "CL_TAG",
          desc: "Tag Address"
        }
      ]
    },
    {
      name:     "STATUS_341",
      desc:     "Status register of cache line 341",
      swaccess: "rw",
      hwaccess: "hrw",
      hwext:    "true",
      hwqe:     "true", // enable `qe` latched signal of software write pulse
      hwre:     "true",
      fields: [
        {
          bits: "5+3:5", // 2 bits for status
          name: "CL_STATUS",
          desc: "Contain the current status of the corresponding cache line                [0]: valid, [1]: dirty, [2]: cmpt",
        }
      ]
    },
    { name:     "TAG_341",
      desc:     "Tag Address stored in cache line 341",
      swaccess: "rw",
      hwaccess: "hrw",
      hwext:    "true",
      hwqe:     "true", // enable `qe` latched signal of software write pulse
      hwre:     "true",
      fields: [
        { bits: "5-1:0",
          name: "CL_TAG",
          desc: "Tag Address"
        }
      ]
    },
    {
      name:     "STATUS_342",
      desc:     "Status register of cache line 342",
      swaccess: "rw",
      hwaccess: "hrw",
      hwext:    "true",
      hwqe:     "true", // enable `qe` latched signal of software write pulse
      hwre:     "true",
      fields: [
        {
          bits: "5+3:5", // 2 bits for status
          name: "CL_STATUS",
          desc: "Contain the current status of the corresponding cache line                [0]: valid, [1]: dirty, [2]: cmpt",
        }
      ]
    },
    { name:     "TAG_342",
      desc:     "Tag Address stored in cache line 342",
      swaccess: "rw",
      hwaccess: "hrw",
      hwext:    "true",
      hwqe:     "true", // enable `qe` latched signal of software write pulse
      hwre:     "true",
      fields: [
        { bits: "5-1:0",
          name: "CL_TAG",
          desc: "Tag Address"
        }
      ]
    },
    {
      name:     "STATUS_343",
      desc:     "Status register of cache line 343",
      swaccess: "rw",
      hwaccess: "hrw",
      hwext:    "true",
      hwqe:     "true", // enable `qe` latched signal of software write pulse
      hwre:     "true",
      fields: [
        {
          bits: "5+3:5", // 2 bits for status
          name: "CL_STATUS",
          desc: "Contain the current status of the corresponding cache line                [0]: valid, [1]: dirty, [2]: cmpt",
        }
      ]
    },
    { name:     "TAG_343",
      desc:     "Tag Address stored in cache line 343",
      swaccess: "rw",
      hwaccess: "hrw",
      hwext:    "true",
      hwqe:     "true", // enable `qe` latched signal of software write pulse
      hwre:     "true",
      fields: [
        { bits: "5-1:0",
          name: "CL_TAG",
          desc: "Tag Address"
        }
      ]
    },
    {
      name:     "STATUS_344",
      desc:     "Status register of cache line 344",
      swaccess: "rw",
      hwaccess: "hrw",
      hwext:    "true",
      hwqe:     "true", // enable `qe` latched signal of software write pulse
      hwre:     "true",
      fields: [
        {
          bits: "5+3:5", // 2 bits for status
          name: "CL_STATUS",
          desc: "Contain the current status of the corresponding cache line                [0]: valid, [1]: dirty, [2]: cmpt",
        }
      ]
    },
    { name:     "TAG_344",
      desc:     "Tag Address stored in cache line 344",
      swaccess: "rw",
      hwaccess: "hrw",
      hwext:    "true",
      hwqe:     "true", // enable `qe` latched signal of software write pulse
      hwre:     "true",
      fields: [
        { bits: "5-1:0",
          name: "CL_TAG",
          desc: "Tag Address"
        }
      ]
    },
    {
      name:     "STATUS_345",
      desc:     "Status register of cache line 345",
      swaccess: "rw",
      hwaccess: "hrw",
      hwext:    "true",
      hwqe:     "true", // enable `qe` latched signal of software write pulse
      hwre:     "true",
      fields: [
        {
          bits: "5+3:5", // 2 bits for status
          name: "CL_STATUS",
          desc: "Contain the current status of the corresponding cache line                [0]: valid, [1]: dirty, [2]: cmpt",
        }
      ]
    },
    { name:     "TAG_345",
      desc:     "Tag Address stored in cache line 345",
      swaccess: "rw",
      hwaccess: "hrw",
      hwext:    "true",
      hwqe:     "true", // enable `qe` latched signal of software write pulse
      hwre:     "true",
      fields: [
        { bits: "5-1:0",
          name: "CL_TAG",
          desc: "Tag Address"
        }
      ]
    },
    {
      name:     "STATUS_346",
      desc:     "Status register of cache line 346",
      swaccess: "rw",
      hwaccess: "hrw",
      hwext:    "true",
      hwqe:     "true", // enable `qe` latched signal of software write pulse
      hwre:     "true",
      fields: [
        {
          bits: "5+3:5", // 2 bits for status
          name: "CL_STATUS",
          desc: "Contain the current status of the corresponding cache line                [0]: valid, [1]: dirty, [2]: cmpt",
        }
      ]
    },
    { name:     "TAG_346",
      desc:     "Tag Address stored in cache line 346",
      swaccess: "rw",
      hwaccess: "hrw",
      hwext:    "true",
      hwqe:     "true", // enable `qe` latched signal of software write pulse
      hwre:     "true",
      fields: [
        { bits: "5-1:0",
          name: "CL_TAG",
          desc: "Tag Address"
        }
      ]
    },
    {
      name:     "STATUS_347",
      desc:     "Status register of cache line 347",
      swaccess: "rw",
      hwaccess: "hrw",
      hwext:    "true",
      hwqe:     "true", // enable `qe` latched signal of software write pulse
      hwre:     "true",
      fields: [
        {
          bits: "5+3:5", // 2 bits for status
          name: "CL_STATUS",
          desc: "Contain the current status of the corresponding cache line                [0]: valid, [1]: dirty, [2]: cmpt",
        }
      ]
    },
    { name:     "TAG_347",
      desc:     "Tag Address stored in cache line 347",
      swaccess: "rw",
      hwaccess: "hrw",
      hwext:    "true",
      hwqe:     "true", // enable `qe` latched signal of software write pulse
      hwre:     "true",
      fields: [
        { bits: "5-1:0",
          name: "CL_TAG",
          desc: "Tag Address"
        }
      ]
    },
    {
      name:     "STATUS_348",
      desc:     "Status register of cache line 348",
      swaccess: "rw",
      hwaccess: "hrw",
      hwext:    "true",
      hwqe:     "true", // enable `qe` latched signal of software write pulse
      hwre:     "true",
      fields: [
        {
          bits: "5+3:5", // 2 bits for status
          name: "CL_STATUS",
          desc: "Contain the current status of the corresponding cache line                [0]: valid, [1]: dirty, [2]: cmpt",
        }
      ]
    },
    { name:     "TAG_348",
      desc:     "Tag Address stored in cache line 348",
      swaccess: "rw",
      hwaccess: "hrw",
      hwext:    "true",
      hwqe:     "true", // enable `qe` latched signal of software write pulse
      hwre:     "true",
      fields: [
        { bits: "5-1:0",
          name: "CL_TAG",
          desc: "Tag Address"
        }
      ]
    },
    {
      name:     "STATUS_349",
      desc:     "Status register of cache line 349",
      swaccess: "rw",
      hwaccess: "hrw",
      hwext:    "true",
      hwqe:     "true", // enable `qe` latched signal of software write pulse
      hwre:     "true",
      fields: [
        {
          bits: "5+3:5", // 2 bits for status
          name: "CL_STATUS",
          desc: "Contain the current status of the corresponding cache line                [0]: valid, [1]: dirty, [2]: cmpt",
        }
      ]
    },
    { name:     "TAG_349",
      desc:     "Tag Address stored in cache line 349",
      swaccess: "rw",
      hwaccess: "hrw",
      hwext:    "true",
      hwqe:     "true", // enable `qe` latched signal of software write pulse
      hwre:     "true",
      fields: [
        { bits: "5-1:0",
          name: "CL_TAG",
          desc: "Tag Address"
        }
      ]
    },
    {
      name:     "STATUS_350",
      desc:     "Status register of cache line 350",
      swaccess: "rw",
      hwaccess: "hrw",
      hwext:    "true",
      hwqe:     "true", // enable `qe` latched signal of software write pulse
      hwre:     "true",
      fields: [
        {
          bits: "5+3:5", // 2 bits for status
          name: "CL_STATUS",
          desc: "Contain the current status of the corresponding cache line                [0]: valid, [1]: dirty, [2]: cmpt",
        }
      ]
    },
    { name:     "TAG_350",
      desc:     "Tag Address stored in cache line 350",
      swaccess: "rw",
      hwaccess: "hrw",
      hwext:    "true",
      hwqe:     "true", // enable `qe` latched signal of software write pulse
      hwre:     "true",
      fields: [
        { bits: "5-1:0",
          name: "CL_TAG",
          desc: "Tag Address"
        }
      ]
    },
    {
      name:     "STATUS_351",
      desc:     "Status register of cache line 351",
      swaccess: "rw",
      hwaccess: "hrw",
      hwext:    "true",
      hwqe:     "true", // enable `qe` latched signal of software write pulse
      hwre:     "true",
      fields: [
        {
          bits: "5+3:5", // 2 bits for status
          name: "CL_STATUS",
          desc: "Contain the current status of the corresponding cache line                [0]: valid, [1]: dirty, [2]: cmpt",
        }
      ]
    },
    { name:     "TAG_351",
      desc:     "Tag Address stored in cache line 351",
      swaccess: "rw",
      hwaccess: "hrw",
      hwext:    "true",
      hwqe:     "true", // enable `qe` latched signal of software write pulse
      hwre:     "true",
      fields: [
        { bits: "5-1:0",
          name: "CL_TAG",
          desc: "Tag Address"
        }
      ]
    },
    {
      name:     "STATUS_352",
      desc:     "Status register of cache line 352",
      swaccess: "rw",
      hwaccess: "hrw",
      hwext:    "true",
      hwqe:     "true", // enable `qe` latched signal of software write pulse
      hwre:     "true",
      fields: [
        {
          bits: "5+3:5", // 2 bits for status
          name: "CL_STATUS",
          desc: "Contain the current status of the corresponding cache line                [0]: valid, [1]: dirty, [2]: cmpt",
        }
      ]
    },
    { name:     "TAG_352",
      desc:     "Tag Address stored in cache line 352",
      swaccess: "rw",
      hwaccess: "hrw",
      hwext:    "true",
      hwqe:     "true", // enable `qe` latched signal of software write pulse
      hwre:     "true",
      fields: [
        { bits: "5-1:0",
          name: "CL_TAG",
          desc: "Tag Address"
        }
      ]
    },
    {
      name:     "STATUS_353",
      desc:     "Status register of cache line 353",
      swaccess: "rw",
      hwaccess: "hrw",
      hwext:    "true",
      hwqe:     "true", // enable `qe` latched signal of software write pulse
      hwre:     "true",
      fields: [
        {
          bits: "5+3:5", // 2 bits for status
          name: "CL_STATUS",
          desc: "Contain the current status of the corresponding cache line                [0]: valid, [1]: dirty, [2]: cmpt",
        }
      ]
    },
    { name:     "TAG_353",
      desc:     "Tag Address stored in cache line 353",
      swaccess: "rw",
      hwaccess: "hrw",
      hwext:    "true",
      hwqe:     "true", // enable `qe` latched signal of software write pulse
      hwre:     "true",
      fields: [
        { bits: "5-1:0",
          name: "CL_TAG",
          desc: "Tag Address"
        }
      ]
    },
    {
      name:     "STATUS_354",
      desc:     "Status register of cache line 354",
      swaccess: "rw",
      hwaccess: "hrw",
      hwext:    "true",
      hwqe:     "true", // enable `qe` latched signal of software write pulse
      hwre:     "true",
      fields: [
        {
          bits: "5+3:5", // 2 bits for status
          name: "CL_STATUS",
          desc: "Contain the current status of the corresponding cache line                [0]: valid, [1]: dirty, [2]: cmpt",
        }
      ]
    },
    { name:     "TAG_354",
      desc:     "Tag Address stored in cache line 354",
      swaccess: "rw",
      hwaccess: "hrw",
      hwext:    "true",
      hwqe:     "true", // enable `qe` latched signal of software write pulse
      hwre:     "true",
      fields: [
        { bits: "5-1:0",
          name: "CL_TAG",
          desc: "Tag Address"
        }
      ]
    },
    {
      name:     "STATUS_355",
      desc:     "Status register of cache line 355",
      swaccess: "rw",
      hwaccess: "hrw",
      hwext:    "true",
      hwqe:     "true", // enable `qe` latched signal of software write pulse
      hwre:     "true",
      fields: [
        {
          bits: "5+3:5", // 2 bits for status
          name: "CL_STATUS",
          desc: "Contain the current status of the corresponding cache line                [0]: valid, [1]: dirty, [2]: cmpt",
        }
      ]
    },
    { name:     "TAG_355",
      desc:     "Tag Address stored in cache line 355",
      swaccess: "rw",
      hwaccess: "hrw",
      hwext:    "true",
      hwqe:     "true", // enable `qe` latched signal of software write pulse
      hwre:     "true",
      fields: [
        { bits: "5-1:0",
          name: "CL_TAG",
          desc: "Tag Address"
        }
      ]
    },
    {
      name:     "STATUS_356",
      desc:     "Status register of cache line 356",
      swaccess: "rw",
      hwaccess: "hrw",
      hwext:    "true",
      hwqe:     "true", // enable `qe` latched signal of software write pulse
      hwre:     "true",
      fields: [
        {
          bits: "5+3:5", // 2 bits for status
          name: "CL_STATUS",
          desc: "Contain the current status of the corresponding cache line                [0]: valid, [1]: dirty, [2]: cmpt",
        }
      ]
    },
    { name:     "TAG_356",
      desc:     "Tag Address stored in cache line 356",
      swaccess: "rw",
      hwaccess: "hrw",
      hwext:    "true",
      hwqe:     "true", // enable `qe` latched signal of software write pulse
      hwre:     "true",
      fields: [
        { bits: "5-1:0",
          name: "CL_TAG",
          desc: "Tag Address"
        }
      ]
    },
    {
      name:     "STATUS_357",
      desc:     "Status register of cache line 357",
      swaccess: "rw",
      hwaccess: "hrw",
      hwext:    "true",
      hwqe:     "true", // enable `qe` latched signal of software write pulse
      hwre:     "true",
      fields: [
        {
          bits: "5+3:5", // 2 bits for status
          name: "CL_STATUS",
          desc: "Contain the current status of the corresponding cache line                [0]: valid, [1]: dirty, [2]: cmpt",
        }
      ]
    },
    { name:     "TAG_357",
      desc:     "Tag Address stored in cache line 357",
      swaccess: "rw",
      hwaccess: "hrw",
      hwext:    "true",
      hwqe:     "true", // enable `qe` latched signal of software write pulse
      hwre:     "true",
      fields: [
        { bits: "5-1:0",
          name: "CL_TAG",
          desc: "Tag Address"
        }
      ]
    },
    {
      name:     "STATUS_358",
      desc:     "Status register of cache line 358",
      swaccess: "rw",
      hwaccess: "hrw",
      hwext:    "true",
      hwqe:     "true", // enable `qe` latched signal of software write pulse
      hwre:     "true",
      fields: [
        {
          bits: "5+3:5", // 2 bits for status
          name: "CL_STATUS",
          desc: "Contain the current status of the corresponding cache line                [0]: valid, [1]: dirty, [2]: cmpt",
        }
      ]
    },
    { name:     "TAG_358",
      desc:     "Tag Address stored in cache line 358",
      swaccess: "rw",
      hwaccess: "hrw",
      hwext:    "true",
      hwqe:     "true", // enable `qe` latched signal of software write pulse
      hwre:     "true",
      fields: [
        { bits: "5-1:0",
          name: "CL_TAG",
          desc: "Tag Address"
        }
      ]
    },
    {
      name:     "STATUS_359",
      desc:     "Status register of cache line 359",
      swaccess: "rw",
      hwaccess: "hrw",
      hwext:    "true",
      hwqe:     "true", // enable `qe` latched signal of software write pulse
      hwre:     "true",
      fields: [
        {
          bits: "5+3:5", // 2 bits for status
          name: "CL_STATUS",
          desc: "Contain the current status of the corresponding cache line                [0]: valid, [1]: dirty, [2]: cmpt",
        }
      ]
    },
    { name:     "TAG_359",
      desc:     "Tag Address stored in cache line 359",
      swaccess: "rw",
      hwaccess: "hrw",
      hwext:    "true",
      hwqe:     "true", // enable `qe` latched signal of software write pulse
      hwre:     "true",
      fields: [
        { bits: "5-1:0",
          name: "CL_TAG",
          desc: "Tag Address"
        }
      ]
    },
    {
      name:     "STATUS_360",
      desc:     "Status register of cache line 360",
      swaccess: "rw",
      hwaccess: "hrw",
      hwext:    "true",
      hwqe:     "true", // enable `qe` latched signal of software write pulse
      hwre:     "true",
      fields: [
        {
          bits: "5+3:5", // 2 bits for status
          name: "CL_STATUS",
          desc: "Contain the current status of the corresponding cache line                [0]: valid, [1]: dirty, [2]: cmpt",
        }
      ]
    },
    { name:     "TAG_360",
      desc:     "Tag Address stored in cache line 360",
      swaccess: "rw",
      hwaccess: "hrw",
      hwext:    "true",
      hwqe:     "true", // enable `qe` latched signal of software write pulse
      hwre:     "true",
      fields: [
        { bits: "5-1:0",
          name: "CL_TAG",
          desc: "Tag Address"
        }
      ]
    },
    {
      name:     "STATUS_361",
      desc:     "Status register of cache line 361",
      swaccess: "rw",
      hwaccess: "hrw",
      hwext:    "true",
      hwqe:     "true", // enable `qe` latched signal of software write pulse
      hwre:     "true",
      fields: [
        {
          bits: "5+3:5", // 2 bits for status
          name: "CL_STATUS",
          desc: "Contain the current status of the corresponding cache line                [0]: valid, [1]: dirty, [2]: cmpt",
        }
      ]
    },
    { name:     "TAG_361",
      desc:     "Tag Address stored in cache line 361",
      swaccess: "rw",
      hwaccess: "hrw",
      hwext:    "true",
      hwqe:     "true", // enable `qe` latched signal of software write pulse
      hwre:     "true",
      fields: [
        { bits: "5-1:0",
          name: "CL_TAG",
          desc: "Tag Address"
        }
      ]
    },
    {
      name:     "STATUS_362",
      desc:     "Status register of cache line 362",
      swaccess: "rw",
      hwaccess: "hrw",
      hwext:    "true",
      hwqe:     "true", // enable `qe` latched signal of software write pulse
      hwre:     "true",
      fields: [
        {
          bits: "5+3:5", // 2 bits for status
          name: "CL_STATUS",
          desc: "Contain the current status of the corresponding cache line                [0]: valid, [1]: dirty, [2]: cmpt",
        }
      ]
    },
    { name:     "TAG_362",
      desc:     "Tag Address stored in cache line 362",
      swaccess: "rw",
      hwaccess: "hrw",
      hwext:    "true",
      hwqe:     "true", // enable `qe` latched signal of software write pulse
      hwre:     "true",
      fields: [
        { bits: "5-1:0",
          name: "CL_TAG",
          desc: "Tag Address"
        }
      ]
    },
    {
      name:     "STATUS_363",
      desc:     "Status register of cache line 363",
      swaccess: "rw",
      hwaccess: "hrw",
      hwext:    "true",
      hwqe:     "true", // enable `qe` latched signal of software write pulse
      hwre:     "true",
      fields: [
        {
          bits: "5+3:5", // 2 bits for status
          name: "CL_STATUS",
          desc: "Contain the current status of the corresponding cache line                [0]: valid, [1]: dirty, [2]: cmpt",
        }
      ]
    },
    { name:     "TAG_363",
      desc:     "Tag Address stored in cache line 363",
      swaccess: "rw",
      hwaccess: "hrw",
      hwext:    "true",
      hwqe:     "true", // enable `qe` latched signal of software write pulse
      hwre:     "true",
      fields: [
        { bits: "5-1:0",
          name: "CL_TAG",
          desc: "Tag Address"
        }
      ]
    },
    {
      name:     "STATUS_364",
      desc:     "Status register of cache line 364",
      swaccess: "rw",
      hwaccess: "hrw",
      hwext:    "true",
      hwqe:     "true", // enable `qe` latched signal of software write pulse
      hwre:     "true",
      fields: [
        {
          bits: "5+3:5", // 2 bits for status
          name: "CL_STATUS",
          desc: "Contain the current status of the corresponding cache line                [0]: valid, [1]: dirty, [2]: cmpt",
        }
      ]
    },
    { name:     "TAG_364",
      desc:     "Tag Address stored in cache line 364",
      swaccess: "rw",
      hwaccess: "hrw",
      hwext:    "true",
      hwqe:     "true", // enable `qe` latched signal of software write pulse
      hwre:     "true",
      fields: [
        { bits: "5-1:0",
          name: "CL_TAG",
          desc: "Tag Address"
        }
      ]
    },
    {
      name:     "STATUS_365",
      desc:     "Status register of cache line 365",
      swaccess: "rw",
      hwaccess: "hrw",
      hwext:    "true",
      hwqe:     "true", // enable `qe` latched signal of software write pulse
      hwre:     "true",
      fields: [
        {
          bits: "5+3:5", // 2 bits for status
          name: "CL_STATUS",
          desc: "Contain the current status of the corresponding cache line                [0]: valid, [1]: dirty, [2]: cmpt",
        }
      ]
    },
    { name:     "TAG_365",
      desc:     "Tag Address stored in cache line 365",
      swaccess: "rw",
      hwaccess: "hrw",
      hwext:    "true",
      hwqe:     "true", // enable `qe` latched signal of software write pulse
      hwre:     "true",
      fields: [
        { bits: "5-1:0",
          name: "CL_TAG",
          desc: "Tag Address"
        }
      ]
    },
    {
      name:     "STATUS_366",
      desc:     "Status register of cache line 366",
      swaccess: "rw",
      hwaccess: "hrw",
      hwext:    "true",
      hwqe:     "true", // enable `qe` latched signal of software write pulse
      hwre:     "true",
      fields: [
        {
          bits: "5+3:5", // 2 bits for status
          name: "CL_STATUS",
          desc: "Contain the current status of the corresponding cache line                [0]: valid, [1]: dirty, [2]: cmpt",
        }
      ]
    },
    { name:     "TAG_366",
      desc:     "Tag Address stored in cache line 366",
      swaccess: "rw",
      hwaccess: "hrw",
      hwext:    "true",
      hwqe:     "true", // enable `qe` latched signal of software write pulse
      hwre:     "true",
      fields: [
        { bits: "5-1:0",
          name: "CL_TAG",
          desc: "Tag Address"
        }
      ]
    },
    {
      name:     "STATUS_367",
      desc:     "Status register of cache line 367",
      swaccess: "rw",
      hwaccess: "hrw",
      hwext:    "true",
      hwqe:     "true", // enable `qe` latched signal of software write pulse
      hwre:     "true",
      fields: [
        {
          bits: "5+3:5", // 2 bits for status
          name: "CL_STATUS",
          desc: "Contain the current status of the corresponding cache line                [0]: valid, [1]: dirty, [2]: cmpt",
        }
      ]
    },
    { name:     "TAG_367",
      desc:     "Tag Address stored in cache line 367",
      swaccess: "rw",
      hwaccess: "hrw",
      hwext:    "true",
      hwqe:     "true", // enable `qe` latched signal of software write pulse
      hwre:     "true",
      fields: [
        { bits: "5-1:0",
          name: "CL_TAG",
          desc: "Tag Address"
        }
      ]
    },
    {
      name:     "STATUS_368",
      desc:     "Status register of cache line 368",
      swaccess: "rw",
      hwaccess: "hrw",
      hwext:    "true",
      hwqe:     "true", // enable `qe` latched signal of software write pulse
      hwre:     "true",
      fields: [
        {
          bits: "5+3:5", // 2 bits for status
          name: "CL_STATUS",
          desc: "Contain the current status of the corresponding cache line                [0]: valid, [1]: dirty, [2]: cmpt",
        }
      ]
    },
    { name:     "TAG_368",
      desc:     "Tag Address stored in cache line 368",
      swaccess: "rw",
      hwaccess: "hrw",
      hwext:    "true",
      hwqe:     "true", // enable `qe` latched signal of software write pulse
      hwre:     "true",
      fields: [
        { bits: "5-1:0",
          name: "CL_TAG",
          desc: "Tag Address"
        }
      ]
    },
    {
      name:     "STATUS_369",
      desc:     "Status register of cache line 369",
      swaccess: "rw",
      hwaccess: "hrw",
      hwext:    "true",
      hwqe:     "true", // enable `qe` latched signal of software write pulse
      hwre:     "true",
      fields: [
        {
          bits: "5+3:5", // 2 bits for status
          name: "CL_STATUS",
          desc: "Contain the current status of the corresponding cache line                [0]: valid, [1]: dirty, [2]: cmpt",
        }
      ]
    },
    { name:     "TAG_369",
      desc:     "Tag Address stored in cache line 369",
      swaccess: "rw",
      hwaccess: "hrw",
      hwext:    "true",
      hwqe:     "true", // enable `qe` latched signal of software write pulse
      hwre:     "true",
      fields: [
        { bits: "5-1:0",
          name: "CL_TAG",
          desc: "Tag Address"
        }
      ]
    },
    {
      name:     "STATUS_370",
      desc:     "Status register of cache line 370",
      swaccess: "rw",
      hwaccess: "hrw",
      hwext:    "true",
      hwqe:     "true", // enable `qe` latched signal of software write pulse
      hwre:     "true",
      fields: [
        {
          bits: "5+3:5", // 2 bits for status
          name: "CL_STATUS",
          desc: "Contain the current status of the corresponding cache line                [0]: valid, [1]: dirty, [2]: cmpt",
        }
      ]
    },
    { name:     "TAG_370",
      desc:     "Tag Address stored in cache line 370",
      swaccess: "rw",
      hwaccess: "hrw",
      hwext:    "true",
      hwqe:     "true", // enable `qe` latched signal of software write pulse
      hwre:     "true",
      fields: [
        { bits: "5-1:0",
          name: "CL_TAG",
          desc: "Tag Address"
        }
      ]
    },
    {
      name:     "STATUS_371",
      desc:     "Status register of cache line 371",
      swaccess: "rw",
      hwaccess: "hrw",
      hwext:    "true",
      hwqe:     "true", // enable `qe` latched signal of software write pulse
      hwre:     "true",
      fields: [
        {
          bits: "5+3:5", // 2 bits for status
          name: "CL_STATUS",
          desc: "Contain the current status of the corresponding cache line                [0]: valid, [1]: dirty, [2]: cmpt",
        }
      ]
    },
    { name:     "TAG_371",
      desc:     "Tag Address stored in cache line 371",
      swaccess: "rw",
      hwaccess: "hrw",
      hwext:    "true",
      hwqe:     "true", // enable `qe` latched signal of software write pulse
      hwre:     "true",
      fields: [
        { bits: "5-1:0",
          name: "CL_TAG",
          desc: "Tag Address"
        }
      ]
    },
    {
      name:     "STATUS_372",
      desc:     "Status register of cache line 372",
      swaccess: "rw",
      hwaccess: "hrw",
      hwext:    "true",
      hwqe:     "true", // enable `qe` latched signal of software write pulse
      hwre:     "true",
      fields: [
        {
          bits: "5+3:5", // 2 bits for status
          name: "CL_STATUS",
          desc: "Contain the current status of the corresponding cache line                [0]: valid, [1]: dirty, [2]: cmpt",
        }
      ]
    },
    { name:     "TAG_372",
      desc:     "Tag Address stored in cache line 372",
      swaccess: "rw",
      hwaccess: "hrw",
      hwext:    "true",
      hwqe:     "true", // enable `qe` latched signal of software write pulse
      hwre:     "true",
      fields: [
        { bits: "5-1:0",
          name: "CL_TAG",
          desc: "Tag Address"
        }
      ]
    },
    {
      name:     "STATUS_373",
      desc:     "Status register of cache line 373",
      swaccess: "rw",
      hwaccess: "hrw",
      hwext:    "true",
      hwqe:     "true", // enable `qe` latched signal of software write pulse
      hwre:     "true",
      fields: [
        {
          bits: "5+3:5", // 2 bits for status
          name: "CL_STATUS",
          desc: "Contain the current status of the corresponding cache line                [0]: valid, [1]: dirty, [2]: cmpt",
        }
      ]
    },
    { name:     "TAG_373",
      desc:     "Tag Address stored in cache line 373",
      swaccess: "rw",
      hwaccess: "hrw",
      hwext:    "true",
      hwqe:     "true", // enable `qe` latched signal of software write pulse
      hwre:     "true",
      fields: [
        { bits: "5-1:0",
          name: "CL_TAG",
          desc: "Tag Address"
        }
      ]
    },
    {
      name:     "STATUS_374",
      desc:     "Status register of cache line 374",
      swaccess: "rw",
      hwaccess: "hrw",
      hwext:    "true",
      hwqe:     "true", // enable `qe` latched signal of software write pulse
      hwre:     "true",
      fields: [
        {
          bits: "5+3:5", // 2 bits for status
          name: "CL_STATUS",
          desc: "Contain the current status of the corresponding cache line                [0]: valid, [1]: dirty, [2]: cmpt",
        }
      ]
    },
    { name:     "TAG_374",
      desc:     "Tag Address stored in cache line 374",
      swaccess: "rw",
      hwaccess: "hrw",
      hwext:    "true",
      hwqe:     "true", // enable `qe` latched signal of software write pulse
      hwre:     "true",
      fields: [
        { bits: "5-1:0",
          name: "CL_TAG",
          desc: "Tag Address"
        }
      ]
    },
    {
      name:     "STATUS_375",
      desc:     "Status register of cache line 375",
      swaccess: "rw",
      hwaccess: "hrw",
      hwext:    "true",
      hwqe:     "true", // enable `qe` latched signal of software write pulse
      hwre:     "true",
      fields: [
        {
          bits: "5+3:5", // 2 bits for status
          name: "CL_STATUS",
          desc: "Contain the current status of the corresponding cache line                [0]: valid, [1]: dirty, [2]: cmpt",
        }
      ]
    },
    { name:     "TAG_375",
      desc:     "Tag Address stored in cache line 375",
      swaccess: "rw",
      hwaccess: "hrw",
      hwext:    "true",
      hwqe:     "true", // enable `qe` latched signal of software write pulse
      hwre:     "true",
      fields: [
        { bits: "5-1:0",
          name: "CL_TAG",
          desc: "Tag Address"
        }
      ]
    },
    {
      name:     "STATUS_376",
      desc:     "Status register of cache line 376",
      swaccess: "rw",
      hwaccess: "hrw",
      hwext:    "true",
      hwqe:     "true", // enable `qe` latched signal of software write pulse
      hwre:     "true",
      fields: [
        {
          bits: "5+3:5", // 2 bits for status
          name: "CL_STATUS",
          desc: "Contain the current status of the corresponding cache line                [0]: valid, [1]: dirty, [2]: cmpt",
        }
      ]
    },
    { name:     "TAG_376",
      desc:     "Tag Address stored in cache line 376",
      swaccess: "rw",
      hwaccess: "hrw",
      hwext:    "true",
      hwqe:     "true", // enable `qe` latched signal of software write pulse
      hwre:     "true",
      fields: [
        { bits: "5-1:0",
          name: "CL_TAG",
          desc: "Tag Address"
        }
      ]
    },
    {
      name:     "STATUS_377",
      desc:     "Status register of cache line 377",
      swaccess: "rw",
      hwaccess: "hrw",
      hwext:    "true",
      hwqe:     "true", // enable `qe` latched signal of software write pulse
      hwre:     "true",
      fields: [
        {
          bits: "5+3:5", // 2 bits for status
          name: "CL_STATUS",
          desc: "Contain the current status of the corresponding cache line                [0]: valid, [1]: dirty, [2]: cmpt",
        }
      ]
    },
    { name:     "TAG_377",
      desc:     "Tag Address stored in cache line 377",
      swaccess: "rw",
      hwaccess: "hrw",
      hwext:    "true",
      hwqe:     "true", // enable `qe` latched signal of software write pulse
      hwre:     "true",
      fields: [
        { bits: "5-1:0",
          name: "CL_TAG",
          desc: "Tag Address"
        }
      ]
    },
    {
      name:     "STATUS_378",
      desc:     "Status register of cache line 378",
      swaccess: "rw",
      hwaccess: "hrw",
      hwext:    "true",
      hwqe:     "true", // enable `qe` latched signal of software write pulse
      hwre:     "true",
      fields: [
        {
          bits: "5+3:5", // 2 bits for status
          name: "CL_STATUS",
          desc: "Contain the current status of the corresponding cache line                [0]: valid, [1]: dirty, [2]: cmpt",
        }
      ]
    },
    { name:     "TAG_378",
      desc:     "Tag Address stored in cache line 378",
      swaccess: "rw",
      hwaccess: "hrw",
      hwext:    "true",
      hwqe:     "true", // enable `qe` latched signal of software write pulse
      hwre:     "true",
      fields: [
        { bits: "5-1:0",
          name: "CL_TAG",
          desc: "Tag Address"
        }
      ]
    },
    {
      name:     "STATUS_379",
      desc:     "Status register of cache line 379",
      swaccess: "rw",
      hwaccess: "hrw",
      hwext:    "true",
      hwqe:     "true", // enable `qe` latched signal of software write pulse
      hwre:     "true",
      fields: [
        {
          bits: "5+3:5", // 2 bits for status
          name: "CL_STATUS",
          desc: "Contain the current status of the corresponding cache line                [0]: valid, [1]: dirty, [2]: cmpt",
        }
      ]
    },
    { name:     "TAG_379",
      desc:     "Tag Address stored in cache line 379",
      swaccess: "rw",
      hwaccess: "hrw",
      hwext:    "true",
      hwqe:     "true", // enable `qe` latched signal of software write pulse
      hwre:     "true",
      fields: [
        { bits: "5-1:0",
          name: "CL_TAG",
          desc: "Tag Address"
        }
      ]
    },
    {
      name:     "STATUS_380",
      desc:     "Status register of cache line 380",
      swaccess: "rw",
      hwaccess: "hrw",
      hwext:    "true",
      hwqe:     "true", // enable `qe` latched signal of software write pulse
      hwre:     "true",
      fields: [
        {
          bits: "5+3:5", // 2 bits for status
          name: "CL_STATUS",
          desc: "Contain the current status of the corresponding cache line                [0]: valid, [1]: dirty, [2]: cmpt",
        }
      ]
    },
    { name:     "TAG_380",
      desc:     "Tag Address stored in cache line 380",
      swaccess: "rw",
      hwaccess: "hrw",
      hwext:    "true",
      hwqe:     "true", // enable `qe` latched signal of software write pulse
      hwre:     "true",
      fields: [
        { bits: "5-1:0",
          name: "CL_TAG",
          desc: "Tag Address"
        }
      ]
    },
    {
      name:     "STATUS_381",
      desc:     "Status register of cache line 381",
      swaccess: "rw",
      hwaccess: "hrw",
      hwext:    "true",
      hwqe:     "true", // enable `qe` latched signal of software write pulse
      hwre:     "true",
      fields: [
        {
          bits: "5+3:5", // 2 bits for status
          name: "CL_STATUS",
          desc: "Contain the current status of the corresponding cache line                [0]: valid, [1]: dirty, [2]: cmpt",
        }
      ]
    },
    { name:     "TAG_381",
      desc:     "Tag Address stored in cache line 381",
      swaccess: "rw",
      hwaccess: "hrw",
      hwext:    "true",
      hwqe:     "true", // enable `qe` latched signal of software write pulse
      hwre:     "true",
      fields: [
        { bits: "5-1:0",
          name: "CL_TAG",
          desc: "Tag Address"
        }
      ]
    },
    {
      name:     "STATUS_382",
      desc:     "Status register of cache line 382",
      swaccess: "rw",
      hwaccess: "hrw",
      hwext:    "true",
      hwqe:     "true", // enable `qe` latched signal of software write pulse
      hwre:     "true",
      fields: [
        {
          bits: "5+3:5", // 2 bits for status
          name: "CL_STATUS",
          desc: "Contain the current status of the corresponding cache line                [0]: valid, [1]: dirty, [2]: cmpt",
        }
      ]
    },
    { name:     "TAG_382",
      desc:     "Tag Address stored in cache line 382",
      swaccess: "rw",
      hwaccess: "hrw",
      hwext:    "true",
      hwqe:     "true", // enable `qe` latched signal of software write pulse
      hwre:     "true",
      fields: [
        { bits: "5-1:0",
          name: "CL_TAG",
          desc: "Tag Address"
        }
      ]
    },
    {
      name:     "STATUS_383",
      desc:     "Status register of cache line 383",
      swaccess: "rw",
      hwaccess: "hrw",
      hwext:    "true",
      hwqe:     "true", // enable `qe` latched signal of software write pulse
      hwre:     "true",
      fields: [
        {
          bits: "5+3:5", // 2 bits for status
          name: "CL_STATUS",
          desc: "Contain the current status of the corresponding cache line                [0]: valid, [1]: dirty, [2]: cmpt",
        }
      ]
    },
    { name:     "TAG_383",
      desc:     "Tag Address stored in cache line 383",
      swaccess: "rw",
      hwaccess: "hrw",
      hwext:    "true",
      hwqe:     "true", // enable `qe` latched signal of software write pulse
      hwre:     "true",
      fields: [
        { bits: "5-1:0",
          name: "CL_TAG",
          desc: "Tag Address"
        }
      ]
    },
    {
      name:     "STATUS_384",
      desc:     "Status register of cache line 384",
      swaccess: "rw",
      hwaccess: "hrw",
      hwext:    "true",
      hwqe:     "true", // enable `qe` latched signal of software write pulse
      hwre:     "true",
      fields: [
        {
          bits: "5+3:5", // 2 bits for status
          name: "CL_STATUS",
          desc: "Contain the current status of the corresponding cache line                [0]: valid, [1]: dirty, [2]: cmpt",
        }
      ]
    },
    { name:     "TAG_384",
      desc:     "Tag Address stored in cache line 384",
      swaccess: "rw",
      hwaccess: "hrw",
      hwext:    "true",
      hwqe:     "true", // enable `qe` latched signal of software write pulse
      hwre:     "true",
      fields: [
        { bits: "5-1:0",
          name: "CL_TAG",
          desc: "Tag Address"
        }
      ]
    },
    {
      name:     "STATUS_385",
      desc:     "Status register of cache line 385",
      swaccess: "rw",
      hwaccess: "hrw",
      hwext:    "true",
      hwqe:     "true", // enable `qe` latched signal of software write pulse
      hwre:     "true",
      fields: [
        {
          bits: "5+3:5", // 2 bits for status
          name: "CL_STATUS",
          desc: "Contain the current status of the corresponding cache line                [0]: valid, [1]: dirty, [2]: cmpt",
        }
      ]
    },
    { name:     "TAG_385",
      desc:     "Tag Address stored in cache line 385",
      swaccess: "rw",
      hwaccess: "hrw",
      hwext:    "true",
      hwqe:     "true", // enable `qe` latched signal of software write pulse
      hwre:     "true",
      fields: [
        { bits: "5-1:0",
          name: "CL_TAG",
          desc: "Tag Address"
        }
      ]
    },
    {
      name:     "STATUS_386",
      desc:     "Status register of cache line 386",
      swaccess: "rw",
      hwaccess: "hrw",
      hwext:    "true",
      hwqe:     "true", // enable `qe` latched signal of software write pulse
      hwre:     "true",
      fields: [
        {
          bits: "5+3:5", // 2 bits for status
          name: "CL_STATUS",
          desc: "Contain the current status of the corresponding cache line                [0]: valid, [1]: dirty, [2]: cmpt",
        }
      ]
    },
    { name:     "TAG_386",
      desc:     "Tag Address stored in cache line 386",
      swaccess: "rw",
      hwaccess: "hrw",
      hwext:    "true",
      hwqe:     "true", // enable `qe` latched signal of software write pulse
      hwre:     "true",
      fields: [
        { bits: "5-1:0",
          name: "CL_TAG",
          desc: "Tag Address"
        }
      ]
    },
    {
      name:     "STATUS_387",
      desc:     "Status register of cache line 387",
      swaccess: "rw",
      hwaccess: "hrw",
      hwext:    "true",
      hwqe:     "true", // enable `qe` latched signal of software write pulse
      hwre:     "true",
      fields: [
        {
          bits: "5+3:5", // 2 bits for status
          name: "CL_STATUS",
          desc: "Contain the current status of the corresponding cache line                [0]: valid, [1]: dirty, [2]: cmpt",
        }
      ]
    },
    { name:     "TAG_387",
      desc:     "Tag Address stored in cache line 387",
      swaccess: "rw",
      hwaccess: "hrw",
      hwext:    "true",
      hwqe:     "true", // enable `qe` latched signal of software write pulse
      hwre:     "true",
      fields: [
        { bits: "5-1:0",
          name: "CL_TAG",
          desc: "Tag Address"
        }
      ]
    },
    {
      name:     "STATUS_388",
      desc:     "Status register of cache line 388",
      swaccess: "rw",
      hwaccess: "hrw",
      hwext:    "true",
      hwqe:     "true", // enable `qe` latched signal of software write pulse
      hwre:     "true",
      fields: [
        {
          bits: "5+3:5", // 2 bits for status
          name: "CL_STATUS",
          desc: "Contain the current status of the corresponding cache line                [0]: valid, [1]: dirty, [2]: cmpt",
        }
      ]
    },
    { name:     "TAG_388",
      desc:     "Tag Address stored in cache line 388",
      swaccess: "rw",
      hwaccess: "hrw",
      hwext:    "true",
      hwqe:     "true", // enable `qe` latched signal of software write pulse
      hwre:     "true",
      fields: [
        { bits: "5-1:0",
          name: "CL_TAG",
          desc: "Tag Address"
        }
      ]
    },
    {
      name:     "STATUS_389",
      desc:     "Status register of cache line 389",
      swaccess: "rw",
      hwaccess: "hrw",
      hwext:    "true",
      hwqe:     "true", // enable `qe` latched signal of software write pulse
      hwre:     "true",
      fields: [
        {
          bits: "5+3:5", // 2 bits for status
          name: "CL_STATUS",
          desc: "Contain the current status of the corresponding cache line                [0]: valid, [1]: dirty, [2]: cmpt",
        }
      ]
    },
    { name:     "TAG_389",
      desc:     "Tag Address stored in cache line 389",
      swaccess: "rw",
      hwaccess: "hrw",
      hwext:    "true",
      hwqe:     "true", // enable `qe` latched signal of software write pulse
      hwre:     "true",
      fields: [
        { bits: "5-1:0",
          name: "CL_TAG",
          desc: "Tag Address"
        }
      ]
    },
    {
      name:     "STATUS_390",
      desc:     "Status register of cache line 390",
      swaccess: "rw",
      hwaccess: "hrw",
      hwext:    "true",
      hwqe:     "true", // enable `qe` latched signal of software write pulse
      hwre:     "true",
      fields: [
        {
          bits: "5+3:5", // 2 bits for status
          name: "CL_STATUS",
          desc: "Contain the current status of the corresponding cache line                [0]: valid, [1]: dirty, [2]: cmpt",
        }
      ]
    },
    { name:     "TAG_390",
      desc:     "Tag Address stored in cache line 390",
      swaccess: "rw",
      hwaccess: "hrw",
      hwext:    "true",
      hwqe:     "true", // enable `qe` latched signal of software write pulse
      hwre:     "true",
      fields: [
        { bits: "5-1:0",
          name: "CL_TAG",
          desc: "Tag Address"
        }
      ]
    },
    {
      name:     "STATUS_391",
      desc:     "Status register of cache line 391",
      swaccess: "rw",
      hwaccess: "hrw",
      hwext:    "true",
      hwqe:     "true", // enable `qe` latched signal of software write pulse
      hwre:     "true",
      fields: [
        {
          bits: "5+3:5", // 2 bits for status
          name: "CL_STATUS",
          desc: "Contain the current status of the corresponding cache line                [0]: valid, [1]: dirty, [2]: cmpt",
        }
      ]
    },
    { name:     "TAG_391",
      desc:     "Tag Address stored in cache line 391",
      swaccess: "rw",
      hwaccess: "hrw",
      hwext:    "true",
      hwqe:     "true", // enable `qe` latched signal of software write pulse
      hwre:     "true",
      fields: [
        { bits: "5-1:0",
          name: "CL_TAG",
          desc: "Tag Address"
        }
      ]
    },
    {
      name:     "STATUS_392",
      desc:     "Status register of cache line 392",
      swaccess: "rw",
      hwaccess: "hrw",
      hwext:    "true",
      hwqe:     "true", // enable `qe` latched signal of software write pulse
      hwre:     "true",
      fields: [
        {
          bits: "5+3:5", // 2 bits for status
          name: "CL_STATUS",
          desc: "Contain the current status of the corresponding cache line                [0]: valid, [1]: dirty, [2]: cmpt",
        }
      ]
    },
    { name:     "TAG_392",
      desc:     "Tag Address stored in cache line 392",
      swaccess: "rw",
      hwaccess: "hrw",
      hwext:    "true",
      hwqe:     "true", // enable `qe` latched signal of software write pulse
      hwre:     "true",
      fields: [
        { bits: "5-1:0",
          name: "CL_TAG",
          desc: "Tag Address"
        }
      ]
    },
    {
      name:     "STATUS_393",
      desc:     "Status register of cache line 393",
      swaccess: "rw",
      hwaccess: "hrw",
      hwext:    "true",
      hwqe:     "true", // enable `qe` latched signal of software write pulse
      hwre:     "true",
      fields: [
        {
          bits: "5+3:5", // 2 bits for status
          name: "CL_STATUS",
          desc: "Contain the current status of the corresponding cache line                [0]: valid, [1]: dirty, [2]: cmpt",
        }
      ]
    },
    { name:     "TAG_393",
      desc:     "Tag Address stored in cache line 393",
      swaccess: "rw",
      hwaccess: "hrw",
      hwext:    "true",
      hwqe:     "true", // enable `qe` latched signal of software write pulse
      hwre:     "true",
      fields: [
        { bits: "5-1:0",
          name: "CL_TAG",
          desc: "Tag Address"
        }
      ]
    },
    {
      name:     "STATUS_394",
      desc:     "Status register of cache line 394",
      swaccess: "rw",
      hwaccess: "hrw",
      hwext:    "true",
      hwqe:     "true", // enable `qe` latched signal of software write pulse
      hwre:     "true",
      fields: [
        {
          bits: "5+3:5", // 2 bits for status
          name: "CL_STATUS",
          desc: "Contain the current status of the corresponding cache line                [0]: valid, [1]: dirty, [2]: cmpt",
        }
      ]
    },
    { name:     "TAG_394",
      desc:     "Tag Address stored in cache line 394",
      swaccess: "rw",
      hwaccess: "hrw",
      hwext:    "true",
      hwqe:     "true", // enable `qe` latched signal of software write pulse
      hwre:     "true",
      fields: [
        { bits: "5-1:0",
          name: "CL_TAG",
          desc: "Tag Address"
        }
      ]
    },
    {
      name:     "STATUS_395",
      desc:     "Status register of cache line 395",
      swaccess: "rw",
      hwaccess: "hrw",
      hwext:    "true",
      hwqe:     "true", // enable `qe` latched signal of software write pulse
      hwre:     "true",
      fields: [
        {
          bits: "5+3:5", // 2 bits for status
          name: "CL_STATUS",
          desc: "Contain the current status of the corresponding cache line                [0]: valid, [1]: dirty, [2]: cmpt",
        }
      ]
    },
    { name:     "TAG_395",
      desc:     "Tag Address stored in cache line 395",
      swaccess: "rw",
      hwaccess: "hrw",
      hwext:    "true",
      hwqe:     "true", // enable `qe` latched signal of software write pulse
      hwre:     "true",
      fields: [
        { bits: "5-1:0",
          name: "CL_TAG",
          desc: "Tag Address"
        }
      ]
    },
    {
      name:     "STATUS_396",
      desc:     "Status register of cache line 396",
      swaccess: "rw",
      hwaccess: "hrw",
      hwext:    "true",
      hwqe:     "true", // enable `qe` latched signal of software write pulse
      hwre:     "true",
      fields: [
        {
          bits: "5+3:5", // 2 bits for status
          name: "CL_STATUS",
          desc: "Contain the current status of the corresponding cache line                [0]: valid, [1]: dirty, [2]: cmpt",
        }
      ]
    },
    { name:     "TAG_396",
      desc:     "Tag Address stored in cache line 396",
      swaccess: "rw",
      hwaccess: "hrw",
      hwext:    "true",
      hwqe:     "true", // enable `qe` latched signal of software write pulse
      hwre:     "true",
      fields: [
        { bits: "5-1:0",
          name: "CL_TAG",
          desc: "Tag Address"
        }
      ]
    },
    {
      name:     "STATUS_397",
      desc:     "Status register of cache line 397",
      swaccess: "rw",
      hwaccess: "hrw",
      hwext:    "true",
      hwqe:     "true", // enable `qe` latched signal of software write pulse
      hwre:     "true",
      fields: [
        {
          bits: "5+3:5", // 2 bits for status
          name: "CL_STATUS",
          desc: "Contain the current status of the corresponding cache line                [0]: valid, [1]: dirty, [2]: cmpt",
        }
      ]
    },
    { name:     "TAG_397",
      desc:     "Tag Address stored in cache line 397",
      swaccess: "rw",
      hwaccess: "hrw",
      hwext:    "true",
      hwqe:     "true", // enable `qe` latched signal of software write pulse
      hwre:     "true",
      fields: [
        { bits: "5-1:0",
          name: "CL_TAG",
          desc: "Tag Address"
        }
      ]
    },
    {
      name:     "STATUS_398",
      desc:     "Status register of cache line 398",
      swaccess: "rw",
      hwaccess: "hrw",
      hwext:    "true",
      hwqe:     "true", // enable `qe` latched signal of software write pulse
      hwre:     "true",
      fields: [
        {
          bits: "5+3:5", // 2 bits for status
          name: "CL_STATUS",
          desc: "Contain the current status of the corresponding cache line                [0]: valid, [1]: dirty, [2]: cmpt",
        }
      ]
    },
    { name:     "TAG_398",
      desc:     "Tag Address stored in cache line 398",
      swaccess: "rw",
      hwaccess: "hrw",
      hwext:    "true",
      hwqe:     "true", // enable `qe` latched signal of software write pulse
      hwre:     "true",
      fields: [
        { bits: "5-1:0",
          name: "CL_TAG",
          desc: "Tag Address"
        }
      ]
    },
    {
      name:     "STATUS_399",
      desc:     "Status register of cache line 399",
      swaccess: "rw",
      hwaccess: "hrw",
      hwext:    "true",
      hwqe:     "true", // enable `qe` latched signal of software write pulse
      hwre:     "true",
      fields: [
        {
          bits: "5+3:5", // 2 bits for status
          name: "CL_STATUS",
          desc: "Contain the current status of the corresponding cache line                [0]: valid, [1]: dirty, [2]: cmpt",
        }
      ]
    },
    { name:     "TAG_399",
      desc:     "Tag Address stored in cache line 399",
      swaccess: "rw",
      hwaccess: "hrw",
      hwext:    "true",
      hwqe:     "true", // enable `qe` latched signal of software write pulse
      hwre:     "true",
      fields: [
        { bits: "5-1:0",
          name: "CL_TAG",
          desc: "Tag Address"
        }
      ]
    },
    {
      name:     "STATUS_400",
      desc:     "Status register of cache line 400",
      swaccess: "rw",
      hwaccess: "hrw",
      hwext:    "true",
      hwqe:     "true", // enable `qe` latched signal of software write pulse
      hwre:     "true",
      fields: [
        {
          bits: "5+3:5", // 2 bits for status
          name: "CL_STATUS",
          desc: "Contain the current status of the corresponding cache line                [0]: valid, [1]: dirty, [2]: cmpt",
        }
      ]
    },
    { name:     "TAG_400",
      desc:     "Tag Address stored in cache line 400",
      swaccess: "rw",
      hwaccess: "hrw",
      hwext:    "true",
      hwqe:     "true", // enable `qe` latched signal of software write pulse
      hwre:     "true",
      fields: [
        { bits: "5-1:0",
          name: "CL_TAG",
          desc: "Tag Address"
        }
      ]
    },
    {
      name:     "STATUS_401",
      desc:     "Status register of cache line 401",
      swaccess: "rw",
      hwaccess: "hrw",
      hwext:    "true",
      hwqe:     "true", // enable `qe` latched signal of software write pulse
      hwre:     "true",
      fields: [
        {
          bits: "5+3:5", // 2 bits for status
          name: "CL_STATUS",
          desc: "Contain the current status of the corresponding cache line                [0]: valid, [1]: dirty, [2]: cmpt",
        }
      ]
    },
    { name:     "TAG_401",
      desc:     "Tag Address stored in cache line 401",
      swaccess: "rw",
      hwaccess: "hrw",
      hwext:    "true",
      hwqe:     "true", // enable `qe` latched signal of software write pulse
      hwre:     "true",
      fields: [
        { bits: "5-1:0",
          name: "CL_TAG",
          desc: "Tag Address"
        }
      ]
    },
    {
      name:     "STATUS_402",
      desc:     "Status register of cache line 402",
      swaccess: "rw",
      hwaccess: "hrw",
      hwext:    "true",
      hwqe:     "true", // enable `qe` latched signal of software write pulse
      hwre:     "true",
      fields: [
        {
          bits: "5+3:5", // 2 bits for status
          name: "CL_STATUS",
          desc: "Contain the current status of the corresponding cache line                [0]: valid, [1]: dirty, [2]: cmpt",
        }
      ]
    },
    { name:     "TAG_402",
      desc:     "Tag Address stored in cache line 402",
      swaccess: "rw",
      hwaccess: "hrw",
      hwext:    "true",
      hwqe:     "true", // enable `qe` latched signal of software write pulse
      hwre:     "true",
      fields: [
        { bits: "5-1:0",
          name: "CL_TAG",
          desc: "Tag Address"
        }
      ]
    },
    {
      name:     "STATUS_403",
      desc:     "Status register of cache line 403",
      swaccess: "rw",
      hwaccess: "hrw",
      hwext:    "true",
      hwqe:     "true", // enable `qe` latched signal of software write pulse
      hwre:     "true",
      fields: [
        {
          bits: "5+3:5", // 2 bits for status
          name: "CL_STATUS",
          desc: "Contain the current status of the corresponding cache line                [0]: valid, [1]: dirty, [2]: cmpt",
        }
      ]
    },
    { name:     "TAG_403",
      desc:     "Tag Address stored in cache line 403",
      swaccess: "rw",
      hwaccess: "hrw",
      hwext:    "true",
      hwqe:     "true", // enable `qe` latched signal of software write pulse
      hwre:     "true",
      fields: [
        { bits: "5-1:0",
          name: "CL_TAG",
          desc: "Tag Address"
        }
      ]
    },
    {
      name:     "STATUS_404",
      desc:     "Status register of cache line 404",
      swaccess: "rw",
      hwaccess: "hrw",
      hwext:    "true",
      hwqe:     "true", // enable `qe` latched signal of software write pulse
      hwre:     "true",
      fields: [
        {
          bits: "5+3:5", // 2 bits for status
          name: "CL_STATUS",
          desc: "Contain the current status of the corresponding cache line                [0]: valid, [1]: dirty, [2]: cmpt",
        }
      ]
    },
    { name:     "TAG_404",
      desc:     "Tag Address stored in cache line 404",
      swaccess: "rw",
      hwaccess: "hrw",
      hwext:    "true",
      hwqe:     "true", // enable `qe` latched signal of software write pulse
      hwre:     "true",
      fields: [
        { bits: "5-1:0",
          name: "CL_TAG",
          desc: "Tag Address"
        }
      ]
    },
    {
      name:     "STATUS_405",
      desc:     "Status register of cache line 405",
      swaccess: "rw",
      hwaccess: "hrw",
      hwext:    "true",
      hwqe:     "true", // enable `qe` latched signal of software write pulse
      hwre:     "true",
      fields: [
        {
          bits: "5+3:5", // 2 bits for status
          name: "CL_STATUS",
          desc: "Contain the current status of the corresponding cache line                [0]: valid, [1]: dirty, [2]: cmpt",
        }
      ]
    },
    { name:     "TAG_405",
      desc:     "Tag Address stored in cache line 405",
      swaccess: "rw",
      hwaccess: "hrw",
      hwext:    "true",
      hwqe:     "true", // enable `qe` latched signal of software write pulse
      hwre:     "true",
      fields: [
        { bits: "5-1:0",
          name: "CL_TAG",
          desc: "Tag Address"
        }
      ]
    },
    {
      name:     "STATUS_406",
      desc:     "Status register of cache line 406",
      swaccess: "rw",
      hwaccess: "hrw",
      hwext:    "true",
      hwqe:     "true", // enable `qe` latched signal of software write pulse
      hwre:     "true",
      fields: [
        {
          bits: "5+3:5", // 2 bits for status
          name: "CL_STATUS",
          desc: "Contain the current status of the corresponding cache line                [0]: valid, [1]: dirty, [2]: cmpt",
        }
      ]
    },
    { name:     "TAG_406",
      desc:     "Tag Address stored in cache line 406",
      swaccess: "rw",
      hwaccess: "hrw",
      hwext:    "true",
      hwqe:     "true", // enable `qe` latched signal of software write pulse
      hwre:     "true",
      fields: [
        { bits: "5-1:0",
          name: "CL_TAG",
          desc: "Tag Address"
        }
      ]
    },
    {
      name:     "STATUS_407",
      desc:     "Status register of cache line 407",
      swaccess: "rw",
      hwaccess: "hrw",
      hwext:    "true",
      hwqe:     "true", // enable `qe` latched signal of software write pulse
      hwre:     "true",
      fields: [
        {
          bits: "5+3:5", // 2 bits for status
          name: "CL_STATUS",
          desc: "Contain the current status of the corresponding cache line                [0]: valid, [1]: dirty, [2]: cmpt",
        }
      ]
    },
    { name:     "TAG_407",
      desc:     "Tag Address stored in cache line 407",
      swaccess: "rw",
      hwaccess: "hrw",
      hwext:    "true",
      hwqe:     "true", // enable `qe` latched signal of software write pulse
      hwre:     "true",
      fields: [
        { bits: "5-1:0",
          name: "CL_TAG",
          desc: "Tag Address"
        }
      ]
    },
    {
      name:     "STATUS_408",
      desc:     "Status register of cache line 408",
      swaccess: "rw",
      hwaccess: "hrw",
      hwext:    "true",
      hwqe:     "true", // enable `qe` latched signal of software write pulse
      hwre:     "true",
      fields: [
        {
          bits: "5+3:5", // 2 bits for status
          name: "CL_STATUS",
          desc: "Contain the current status of the corresponding cache line                [0]: valid, [1]: dirty, [2]: cmpt",
        }
      ]
    },
    { name:     "TAG_408",
      desc:     "Tag Address stored in cache line 408",
      swaccess: "rw",
      hwaccess: "hrw",
      hwext:    "true",
      hwqe:     "true", // enable `qe` latched signal of software write pulse
      hwre:     "true",
      fields: [
        { bits: "5-1:0",
          name: "CL_TAG",
          desc: "Tag Address"
        }
      ]
    },
    {
      name:     "STATUS_409",
      desc:     "Status register of cache line 409",
      swaccess: "rw",
      hwaccess: "hrw",
      hwext:    "true",
      hwqe:     "true", // enable `qe` latched signal of software write pulse
      hwre:     "true",
      fields: [
        {
          bits: "5+3:5", // 2 bits for status
          name: "CL_STATUS",
          desc: "Contain the current status of the corresponding cache line                [0]: valid, [1]: dirty, [2]: cmpt",
        }
      ]
    },
    { name:     "TAG_409",
      desc:     "Tag Address stored in cache line 409",
      swaccess: "rw",
      hwaccess: "hrw",
      hwext:    "true",
      hwqe:     "true", // enable `qe` latched signal of software write pulse
      hwre:     "true",
      fields: [
        { bits: "5-1:0",
          name: "CL_TAG",
          desc: "Tag Address"
        }
      ]
    },
    {
      name:     "STATUS_410",
      desc:     "Status register of cache line 410",
      swaccess: "rw",
      hwaccess: "hrw",
      hwext:    "true",
      hwqe:     "true", // enable `qe` latched signal of software write pulse
      hwre:     "true",
      fields: [
        {
          bits: "5+3:5", // 2 bits for status
          name: "CL_STATUS",
          desc: "Contain the current status of the corresponding cache line                [0]: valid, [1]: dirty, [2]: cmpt",
        }
      ]
    },
    { name:     "TAG_410",
      desc:     "Tag Address stored in cache line 410",
      swaccess: "rw",
      hwaccess: "hrw",
      hwext:    "true",
      hwqe:     "true", // enable `qe` latched signal of software write pulse
      hwre:     "true",
      fields: [
        { bits: "5-1:0",
          name: "CL_TAG",
          desc: "Tag Address"
        }
      ]
    },
    {
      name:     "STATUS_411",
      desc:     "Status register of cache line 411",
      swaccess: "rw",
      hwaccess: "hrw",
      hwext:    "true",
      hwqe:     "true", // enable `qe` latched signal of software write pulse
      hwre:     "true",
      fields: [
        {
          bits: "5+3:5", // 2 bits for status
          name: "CL_STATUS",
          desc: "Contain the current status of the corresponding cache line                [0]: valid, [1]: dirty, [2]: cmpt",
        }
      ]
    },
    { name:     "TAG_411",
      desc:     "Tag Address stored in cache line 411",
      swaccess: "rw",
      hwaccess: "hrw",
      hwext:    "true",
      hwqe:     "true", // enable `qe` latched signal of software write pulse
      hwre:     "true",
      fields: [
        { bits: "5-1:0",
          name: "CL_TAG",
          desc: "Tag Address"
        }
      ]
    },
    {
      name:     "STATUS_412",
      desc:     "Status register of cache line 412",
      swaccess: "rw",
      hwaccess: "hrw",
      hwext:    "true",
      hwqe:     "true", // enable `qe` latched signal of software write pulse
      hwre:     "true",
      fields: [
        {
          bits: "5+3:5", // 2 bits for status
          name: "CL_STATUS",
          desc: "Contain the current status of the corresponding cache line                [0]: valid, [1]: dirty, [2]: cmpt",
        }
      ]
    },
    { name:     "TAG_412",
      desc:     "Tag Address stored in cache line 412",
      swaccess: "rw",
      hwaccess: "hrw",
      hwext:    "true",
      hwqe:     "true", // enable `qe` latched signal of software write pulse
      hwre:     "true",
      fields: [
        { bits: "5-1:0",
          name: "CL_TAG",
          desc: "Tag Address"
        }
      ]
    },
    {
      name:     "STATUS_413",
      desc:     "Status register of cache line 413",
      swaccess: "rw",
      hwaccess: "hrw",
      hwext:    "true",
      hwqe:     "true", // enable `qe` latched signal of software write pulse
      hwre:     "true",
      fields: [
        {
          bits: "5+3:5", // 2 bits for status
          name: "CL_STATUS",
          desc: "Contain the current status of the corresponding cache line                [0]: valid, [1]: dirty, [2]: cmpt",
        }
      ]
    },
    { name:     "TAG_413",
      desc:     "Tag Address stored in cache line 413",
      swaccess: "rw",
      hwaccess: "hrw",
      hwext:    "true",
      hwqe:     "true", // enable `qe` latched signal of software write pulse
      hwre:     "true",
      fields: [
        { bits: "5-1:0",
          name: "CL_TAG",
          desc: "Tag Address"
        }
      ]
    },
    {
      name:     "STATUS_414",
      desc:     "Status register of cache line 414",
      swaccess: "rw",
      hwaccess: "hrw",
      hwext:    "true",
      hwqe:     "true", // enable `qe` latched signal of software write pulse
      hwre:     "true",
      fields: [
        {
          bits: "5+3:5", // 2 bits for status
          name: "CL_STATUS",
          desc: "Contain the current status of the corresponding cache line                [0]: valid, [1]: dirty, [2]: cmpt",
        }
      ]
    },
    { name:     "TAG_414",
      desc:     "Tag Address stored in cache line 414",
      swaccess: "rw",
      hwaccess: "hrw",
      hwext:    "true",
      hwqe:     "true", // enable `qe` latched signal of software write pulse
      hwre:     "true",
      fields: [
        { bits: "5-1:0",
          name: "CL_TAG",
          desc: "Tag Address"
        }
      ]
    },
    {
      name:     "STATUS_415",
      desc:     "Status register of cache line 415",
      swaccess: "rw",
      hwaccess: "hrw",
      hwext:    "true",
      hwqe:     "true", // enable `qe` latched signal of software write pulse
      hwre:     "true",
      fields: [
        {
          bits: "5+3:5", // 2 bits for status
          name: "CL_STATUS",
          desc: "Contain the current status of the corresponding cache line                [0]: valid, [1]: dirty, [2]: cmpt",
        }
      ]
    },
    { name:     "TAG_415",
      desc:     "Tag Address stored in cache line 415",
      swaccess: "rw",
      hwaccess: "hrw",
      hwext:    "true",
      hwqe:     "true", // enable `qe` latched signal of software write pulse
      hwre:     "true",
      fields: [
        { bits: "5-1:0",
          name: "CL_TAG",
          desc: "Tag Address"
        }
      ]
    },
    {
      name:     "STATUS_416",
      desc:     "Status register of cache line 416",
      swaccess: "rw",
      hwaccess: "hrw",
      hwext:    "true",
      hwqe:     "true", // enable `qe` latched signal of software write pulse
      hwre:     "true",
      fields: [
        {
          bits: "5+3:5", // 2 bits for status
          name: "CL_STATUS",
          desc: "Contain the current status of the corresponding cache line                [0]: valid, [1]: dirty, [2]: cmpt",
        }
      ]
    },
    { name:     "TAG_416",
      desc:     "Tag Address stored in cache line 416",
      swaccess: "rw",
      hwaccess: "hrw",
      hwext:    "true",
      hwqe:     "true", // enable `qe` latched signal of software write pulse
      hwre:     "true",
      fields: [
        { bits: "5-1:0",
          name: "CL_TAG",
          desc: "Tag Address"
        }
      ]
    },
    {
      name:     "STATUS_417",
      desc:     "Status register of cache line 417",
      swaccess: "rw",
      hwaccess: "hrw",
      hwext:    "true",
      hwqe:     "true", // enable `qe` latched signal of software write pulse
      hwre:     "true",
      fields: [
        {
          bits: "5+3:5", // 2 bits for status
          name: "CL_STATUS",
          desc: "Contain the current status of the corresponding cache line                [0]: valid, [1]: dirty, [2]: cmpt",
        }
      ]
    },
    { name:     "TAG_417",
      desc:     "Tag Address stored in cache line 417",
      swaccess: "rw",
      hwaccess: "hrw",
      hwext:    "true",
      hwqe:     "true", // enable `qe` latched signal of software write pulse
      hwre:     "true",
      fields: [
        { bits: "5-1:0",
          name: "CL_TAG",
          desc: "Tag Address"
        }
      ]
    },
    {
      name:     "STATUS_418",
      desc:     "Status register of cache line 418",
      swaccess: "rw",
      hwaccess: "hrw",
      hwext:    "true",
      hwqe:     "true", // enable `qe` latched signal of software write pulse
      hwre:     "true",
      fields: [
        {
          bits: "5+3:5", // 2 bits for status
          name: "CL_STATUS",
          desc: "Contain the current status of the corresponding cache line                [0]: valid, [1]: dirty, [2]: cmpt",
        }
      ]
    },
    { name:     "TAG_418",
      desc:     "Tag Address stored in cache line 418",
      swaccess: "rw",
      hwaccess: "hrw",
      hwext:    "true",
      hwqe:     "true", // enable `qe` latched signal of software write pulse
      hwre:     "true",
      fields: [
        { bits: "5-1:0",
          name: "CL_TAG",
          desc: "Tag Address"
        }
      ]
    },
    {
      name:     "STATUS_419",
      desc:     "Status register of cache line 419",
      swaccess: "rw",
      hwaccess: "hrw",
      hwext:    "true",
      hwqe:     "true", // enable `qe` latched signal of software write pulse
      hwre:     "true",
      fields: [
        {
          bits: "5+3:5", // 2 bits for status
          name: "CL_STATUS",
          desc: "Contain the current status of the corresponding cache line                [0]: valid, [1]: dirty, [2]: cmpt",
        }
      ]
    },
    { name:     "TAG_419",
      desc:     "Tag Address stored in cache line 419",
      swaccess: "rw",
      hwaccess: "hrw",
      hwext:    "true",
      hwqe:     "true", // enable `qe` latched signal of software write pulse
      hwre:     "true",
      fields: [
        { bits: "5-1:0",
          name: "CL_TAG",
          desc: "Tag Address"
        }
      ]
    },
    {
      name:     "STATUS_420",
      desc:     "Status register of cache line 420",
      swaccess: "rw",
      hwaccess: "hrw",
      hwext:    "true",
      hwqe:     "true", // enable `qe` latched signal of software write pulse
      hwre:     "true",
      fields: [
        {
          bits: "5+3:5", // 2 bits for status
          name: "CL_STATUS",
          desc: "Contain the current status of the corresponding cache line                [0]: valid, [1]: dirty, [2]: cmpt",
        }
      ]
    },
    { name:     "TAG_420",
      desc:     "Tag Address stored in cache line 420",
      swaccess: "rw",
      hwaccess: "hrw",
      hwext:    "true",
      hwqe:     "true", // enable `qe` latched signal of software write pulse
      hwre:     "true",
      fields: [
        { bits: "5-1:0",
          name: "CL_TAG",
          desc: "Tag Address"
        }
      ]
    },
    {
      name:     "STATUS_421",
      desc:     "Status register of cache line 421",
      swaccess: "rw",
      hwaccess: "hrw",
      hwext:    "true",
      hwqe:     "true", // enable `qe` latched signal of software write pulse
      hwre:     "true",
      fields: [
        {
          bits: "5+3:5", // 2 bits for status
          name: "CL_STATUS",
          desc: "Contain the current status of the corresponding cache line                [0]: valid, [1]: dirty, [2]: cmpt",
        }
      ]
    },
    { name:     "TAG_421",
      desc:     "Tag Address stored in cache line 421",
      swaccess: "rw",
      hwaccess: "hrw",
      hwext:    "true",
      hwqe:     "true", // enable `qe` latched signal of software write pulse
      hwre:     "true",
      fields: [
        { bits: "5-1:0",
          name: "CL_TAG",
          desc: "Tag Address"
        }
      ]
    },
    {
      name:     "STATUS_422",
      desc:     "Status register of cache line 422",
      swaccess: "rw",
      hwaccess: "hrw",
      hwext:    "true",
      hwqe:     "true", // enable `qe` latched signal of software write pulse
      hwre:     "true",
      fields: [
        {
          bits: "5+3:5", // 2 bits for status
          name: "CL_STATUS",
          desc: "Contain the current status of the corresponding cache line                [0]: valid, [1]: dirty, [2]: cmpt",
        }
      ]
    },
    { name:     "TAG_422",
      desc:     "Tag Address stored in cache line 422",
      swaccess: "rw",
      hwaccess: "hrw",
      hwext:    "true",
      hwqe:     "true", // enable `qe` latched signal of software write pulse
      hwre:     "true",
      fields: [
        { bits: "5-1:0",
          name: "CL_TAG",
          desc: "Tag Address"
        }
      ]
    },
    {
      name:     "STATUS_423",
      desc:     "Status register of cache line 423",
      swaccess: "rw",
      hwaccess: "hrw",
      hwext:    "true",
      hwqe:     "true", // enable `qe` latched signal of software write pulse
      hwre:     "true",
      fields: [
        {
          bits: "5+3:5", // 2 bits for status
          name: "CL_STATUS",
          desc: "Contain the current status of the corresponding cache line                [0]: valid, [1]: dirty, [2]: cmpt",
        }
      ]
    },
    { name:     "TAG_423",
      desc:     "Tag Address stored in cache line 423",
      swaccess: "rw",
      hwaccess: "hrw",
      hwext:    "true",
      hwqe:     "true", // enable `qe` latched signal of software write pulse
      hwre:     "true",
      fields: [
        { bits: "5-1:0",
          name: "CL_TAG",
          desc: "Tag Address"
        }
      ]
    },
    {
      name:     "STATUS_424",
      desc:     "Status register of cache line 424",
      swaccess: "rw",
      hwaccess: "hrw",
      hwext:    "true",
      hwqe:     "true", // enable `qe` latched signal of software write pulse
      hwre:     "true",
      fields: [
        {
          bits: "5+3:5", // 2 bits for status
          name: "CL_STATUS",
          desc: "Contain the current status of the corresponding cache line                [0]: valid, [1]: dirty, [2]: cmpt",
        }
      ]
    },
    { name:     "TAG_424",
      desc:     "Tag Address stored in cache line 424",
      swaccess: "rw",
      hwaccess: "hrw",
      hwext:    "true",
      hwqe:     "true", // enable `qe` latched signal of software write pulse
      hwre:     "true",
      fields: [
        { bits: "5-1:0",
          name: "CL_TAG",
          desc: "Tag Address"
        }
      ]
    },
    {
      name:     "STATUS_425",
      desc:     "Status register of cache line 425",
      swaccess: "rw",
      hwaccess: "hrw",
      hwext:    "true",
      hwqe:     "true", // enable `qe` latched signal of software write pulse
      hwre:     "true",
      fields: [
        {
          bits: "5+3:5", // 2 bits for status
          name: "CL_STATUS",
          desc: "Contain the current status of the corresponding cache line                [0]: valid, [1]: dirty, [2]: cmpt",
        }
      ]
    },
    { name:     "TAG_425",
      desc:     "Tag Address stored in cache line 425",
      swaccess: "rw",
      hwaccess: "hrw",
      hwext:    "true",
      hwqe:     "true", // enable `qe` latched signal of software write pulse
      hwre:     "true",
      fields: [
        { bits: "5-1:0",
          name: "CL_TAG",
          desc: "Tag Address"
        }
      ]
    },
    {
      name:     "STATUS_426",
      desc:     "Status register of cache line 426",
      swaccess: "rw",
      hwaccess: "hrw",
      hwext:    "true",
      hwqe:     "true", // enable `qe` latched signal of software write pulse
      hwre:     "true",
      fields: [
        {
          bits: "5+3:5", // 2 bits for status
          name: "CL_STATUS",
          desc: "Contain the current status of the corresponding cache line                [0]: valid, [1]: dirty, [2]: cmpt",
        }
      ]
    },
    { name:     "TAG_426",
      desc:     "Tag Address stored in cache line 426",
      swaccess: "rw",
      hwaccess: "hrw",
      hwext:    "true",
      hwqe:     "true", // enable `qe` latched signal of software write pulse
      hwre:     "true",
      fields: [
        { bits: "5-1:0",
          name: "CL_TAG",
          desc: "Tag Address"
        }
      ]
    },
    {
      name:     "STATUS_427",
      desc:     "Status register of cache line 427",
      swaccess: "rw",
      hwaccess: "hrw",
      hwext:    "true",
      hwqe:     "true", // enable `qe` latched signal of software write pulse
      hwre:     "true",
      fields: [
        {
          bits: "5+3:5", // 2 bits for status
          name: "CL_STATUS",
          desc: "Contain the current status of the corresponding cache line                [0]: valid, [1]: dirty, [2]: cmpt",
        }
      ]
    },
    { name:     "TAG_427",
      desc:     "Tag Address stored in cache line 427",
      swaccess: "rw",
      hwaccess: "hrw",
      hwext:    "true",
      hwqe:     "true", // enable `qe` latched signal of software write pulse
      hwre:     "true",
      fields: [
        { bits: "5-1:0",
          name: "CL_TAG",
          desc: "Tag Address"
        }
      ]
    },
    {
      name:     "STATUS_428",
      desc:     "Status register of cache line 428",
      swaccess: "rw",
      hwaccess: "hrw",
      hwext:    "true",
      hwqe:     "true", // enable `qe` latched signal of software write pulse
      hwre:     "true",
      fields: [
        {
          bits: "5+3:5", // 2 bits for status
          name: "CL_STATUS",
          desc: "Contain the current status of the corresponding cache line                [0]: valid, [1]: dirty, [2]: cmpt",
        }
      ]
    },
    { name:     "TAG_428",
      desc:     "Tag Address stored in cache line 428",
      swaccess: "rw",
      hwaccess: "hrw",
      hwext:    "true",
      hwqe:     "true", // enable `qe` latched signal of software write pulse
      hwre:     "true",
      fields: [
        { bits: "5-1:0",
          name: "CL_TAG",
          desc: "Tag Address"
        }
      ]
    },
    {
      name:     "STATUS_429",
      desc:     "Status register of cache line 429",
      swaccess: "rw",
      hwaccess: "hrw",
      hwext:    "true",
      hwqe:     "true", // enable `qe` latched signal of software write pulse
      hwre:     "true",
      fields: [
        {
          bits: "5+3:5", // 2 bits for status
          name: "CL_STATUS",
          desc: "Contain the current status of the corresponding cache line                [0]: valid, [1]: dirty, [2]: cmpt",
        }
      ]
    },
    { name:     "TAG_429",
      desc:     "Tag Address stored in cache line 429",
      swaccess: "rw",
      hwaccess: "hrw",
      hwext:    "true",
      hwqe:     "true", // enable `qe` latched signal of software write pulse
      hwre:     "true",
      fields: [
        { bits: "5-1:0",
          name: "CL_TAG",
          desc: "Tag Address"
        }
      ]
    },
    {
      name:     "STATUS_430",
      desc:     "Status register of cache line 430",
      swaccess: "rw",
      hwaccess: "hrw",
      hwext:    "true",
      hwqe:     "true", // enable `qe` latched signal of software write pulse
      hwre:     "true",
      fields: [
        {
          bits: "5+3:5", // 2 bits for status
          name: "CL_STATUS",
          desc: "Contain the current status of the corresponding cache line                [0]: valid, [1]: dirty, [2]: cmpt",
        }
      ]
    },
    { name:     "TAG_430",
      desc:     "Tag Address stored in cache line 430",
      swaccess: "rw",
      hwaccess: "hrw",
      hwext:    "true",
      hwqe:     "true", // enable `qe` latched signal of software write pulse
      hwre:     "true",
      fields: [
        { bits: "5-1:0",
          name: "CL_TAG",
          desc: "Tag Address"
        }
      ]
    },
    {
      name:     "STATUS_431",
      desc:     "Status register of cache line 431",
      swaccess: "rw",
      hwaccess: "hrw",
      hwext:    "true",
      hwqe:     "true", // enable `qe` latched signal of software write pulse
      hwre:     "true",
      fields: [
        {
          bits: "5+3:5", // 2 bits for status
          name: "CL_STATUS",
          desc: "Contain the current status of the corresponding cache line                [0]: valid, [1]: dirty, [2]: cmpt",
        }
      ]
    },
    { name:     "TAG_431",
      desc:     "Tag Address stored in cache line 431",
      swaccess: "rw",
      hwaccess: "hrw",
      hwext:    "true",
      hwqe:     "true", // enable `qe` latched signal of software write pulse
      hwre:     "true",
      fields: [
        { bits: "5-1:0",
          name: "CL_TAG",
          desc: "Tag Address"
        }
      ]
    },
    {
      name:     "STATUS_432",
      desc:     "Status register of cache line 432",
      swaccess: "rw",
      hwaccess: "hrw",
      hwext:    "true",
      hwqe:     "true", // enable `qe` latched signal of software write pulse
      hwre:     "true",
      fields: [
        {
          bits: "5+3:5", // 2 bits for status
          name: "CL_STATUS",
          desc: "Contain the current status of the corresponding cache line                [0]: valid, [1]: dirty, [2]: cmpt",
        }
      ]
    },
    { name:     "TAG_432",
      desc:     "Tag Address stored in cache line 432",
      swaccess: "rw",
      hwaccess: "hrw",
      hwext:    "true",
      hwqe:     "true", // enable `qe` latched signal of software write pulse
      hwre:     "true",
      fields: [
        { bits: "5-1:0",
          name: "CL_TAG",
          desc: "Tag Address"
        }
      ]
    },
    {
      name:     "STATUS_433",
      desc:     "Status register of cache line 433",
      swaccess: "rw",
      hwaccess: "hrw",
      hwext:    "true",
      hwqe:     "true", // enable `qe` latched signal of software write pulse
      hwre:     "true",
      fields: [
        {
          bits: "5+3:5", // 2 bits for status
          name: "CL_STATUS",
          desc: "Contain the current status of the corresponding cache line                [0]: valid, [1]: dirty, [2]: cmpt",
        }
      ]
    },
    { name:     "TAG_433",
      desc:     "Tag Address stored in cache line 433",
      swaccess: "rw",
      hwaccess: "hrw",
      hwext:    "true",
      hwqe:     "true", // enable `qe` latched signal of software write pulse
      hwre:     "true",
      fields: [
        { bits: "5-1:0",
          name: "CL_TAG",
          desc: "Tag Address"
        }
      ]
    },
    {
      name:     "STATUS_434",
      desc:     "Status register of cache line 434",
      swaccess: "rw",
      hwaccess: "hrw",
      hwext:    "true",
      hwqe:     "true", // enable `qe` latched signal of software write pulse
      hwre:     "true",
      fields: [
        {
          bits: "5+3:5", // 2 bits for status
          name: "CL_STATUS",
          desc: "Contain the current status of the corresponding cache line                [0]: valid, [1]: dirty, [2]: cmpt",
        }
      ]
    },
    { name:     "TAG_434",
      desc:     "Tag Address stored in cache line 434",
      swaccess: "rw",
      hwaccess: "hrw",
      hwext:    "true",
      hwqe:     "true", // enable `qe` latched signal of software write pulse
      hwre:     "true",
      fields: [
        { bits: "5-1:0",
          name: "CL_TAG",
          desc: "Tag Address"
        }
      ]
    },
    {
      name:     "STATUS_435",
      desc:     "Status register of cache line 435",
      swaccess: "rw",
      hwaccess: "hrw",
      hwext:    "true",
      hwqe:     "true", // enable `qe` latched signal of software write pulse
      hwre:     "true",
      fields: [
        {
          bits: "5+3:5", // 2 bits for status
          name: "CL_STATUS",
          desc: "Contain the current status of the corresponding cache line                [0]: valid, [1]: dirty, [2]: cmpt",
        }
      ]
    },
    { name:     "TAG_435",
      desc:     "Tag Address stored in cache line 435",
      swaccess: "rw",
      hwaccess: "hrw",
      hwext:    "true",
      hwqe:     "true", // enable `qe` latched signal of software write pulse
      hwre:     "true",
      fields: [
        { bits: "5-1:0",
          name: "CL_TAG",
          desc: "Tag Address"
        }
      ]
    },
    {
      name:     "STATUS_436",
      desc:     "Status register of cache line 436",
      swaccess: "rw",
      hwaccess: "hrw",
      hwext:    "true",
      hwqe:     "true", // enable `qe` latched signal of software write pulse
      hwre:     "true",
      fields: [
        {
          bits: "5+3:5", // 2 bits for status
          name: "CL_STATUS",
          desc: "Contain the current status of the corresponding cache line                [0]: valid, [1]: dirty, [2]: cmpt",
        }
      ]
    },
    { name:     "TAG_436",
      desc:     "Tag Address stored in cache line 436",
      swaccess: "rw",
      hwaccess: "hrw",
      hwext:    "true",
      hwqe:     "true", // enable `qe` latched signal of software write pulse
      hwre:     "true",
      fields: [
        { bits: "5-1:0",
          name: "CL_TAG",
          desc: "Tag Address"
        }
      ]
    },
    {
      name:     "STATUS_437",
      desc:     "Status register of cache line 437",
      swaccess: "rw",
      hwaccess: "hrw",
      hwext:    "true",
      hwqe:     "true", // enable `qe` latched signal of software write pulse
      hwre:     "true",
      fields: [
        {
          bits: "5+3:5", // 2 bits for status
          name: "CL_STATUS",
          desc: "Contain the current status of the corresponding cache line                [0]: valid, [1]: dirty, [2]: cmpt",
        }
      ]
    },
    { name:     "TAG_437",
      desc:     "Tag Address stored in cache line 437",
      swaccess: "rw",
      hwaccess: "hrw",
      hwext:    "true",
      hwqe:     "true", // enable `qe` latched signal of software write pulse
      hwre:     "true",
      fields: [
        { bits: "5-1:0",
          name: "CL_TAG",
          desc: "Tag Address"
        }
      ]
    },
    {
      name:     "STATUS_438",
      desc:     "Status register of cache line 438",
      swaccess: "rw",
      hwaccess: "hrw",
      hwext:    "true",
      hwqe:     "true", // enable `qe` latched signal of software write pulse
      hwre:     "true",
      fields: [
        {
          bits: "5+3:5", // 2 bits for status
          name: "CL_STATUS",
          desc: "Contain the current status of the corresponding cache line                [0]: valid, [1]: dirty, [2]: cmpt",
        }
      ]
    },
    { name:     "TAG_438",
      desc:     "Tag Address stored in cache line 438",
      swaccess: "rw",
      hwaccess: "hrw",
      hwext:    "true",
      hwqe:     "true", // enable `qe` latched signal of software write pulse
      hwre:     "true",
      fields: [
        { bits: "5-1:0",
          name: "CL_TAG",
          desc: "Tag Address"
        }
      ]
    },
    {
      name:     "STATUS_439",
      desc:     "Status register of cache line 439",
      swaccess: "rw",
      hwaccess: "hrw",
      hwext:    "true",
      hwqe:     "true", // enable `qe` latched signal of software write pulse
      hwre:     "true",
      fields: [
        {
          bits: "5+3:5", // 2 bits for status
          name: "CL_STATUS",
          desc: "Contain the current status of the corresponding cache line                [0]: valid, [1]: dirty, [2]: cmpt",
        }
      ]
    },
    { name:     "TAG_439",
      desc:     "Tag Address stored in cache line 439",
      swaccess: "rw",
      hwaccess: "hrw",
      hwext:    "true",
      hwqe:     "true", // enable `qe` latched signal of software write pulse
      hwre:     "true",
      fields: [
        { bits: "5-1:0",
          name: "CL_TAG",
          desc: "Tag Address"
        }
      ]
    },
    {
      name:     "STATUS_440",
      desc:     "Status register of cache line 440",
      swaccess: "rw",
      hwaccess: "hrw",
      hwext:    "true",
      hwqe:     "true", // enable `qe` latched signal of software write pulse
      hwre:     "true",
      fields: [
        {
          bits: "5+3:5", // 2 bits for status
          name: "CL_STATUS",
          desc: "Contain the current status of the corresponding cache line                [0]: valid, [1]: dirty, [2]: cmpt",
        }
      ]
    },
    { name:     "TAG_440",
      desc:     "Tag Address stored in cache line 440",
      swaccess: "rw",
      hwaccess: "hrw",
      hwext:    "true",
      hwqe:     "true", // enable `qe` latched signal of software write pulse
      hwre:     "true",
      fields: [
        { bits: "5-1:0",
          name: "CL_TAG",
          desc: "Tag Address"
        }
      ]
    },
    {
      name:     "STATUS_441",
      desc:     "Status register of cache line 441",
      swaccess: "rw",
      hwaccess: "hrw",
      hwext:    "true",
      hwqe:     "true", // enable `qe` latched signal of software write pulse
      hwre:     "true",
      fields: [
        {
          bits: "5+3:5", // 2 bits for status
          name: "CL_STATUS",
          desc: "Contain the current status of the corresponding cache line                [0]: valid, [1]: dirty, [2]: cmpt",
        }
      ]
    },
    { name:     "TAG_441",
      desc:     "Tag Address stored in cache line 441",
      swaccess: "rw",
      hwaccess: "hrw",
      hwext:    "true",
      hwqe:     "true", // enable `qe` latched signal of software write pulse
      hwre:     "true",
      fields: [
        { bits: "5-1:0",
          name: "CL_TAG",
          desc: "Tag Address"
        }
      ]
    },
    {
      name:     "STATUS_442",
      desc:     "Status register of cache line 442",
      swaccess: "rw",
      hwaccess: "hrw",
      hwext:    "true",
      hwqe:     "true", // enable `qe` latched signal of software write pulse
      hwre:     "true",
      fields: [
        {
          bits: "5+3:5", // 2 bits for status
          name: "CL_STATUS",
          desc: "Contain the current status of the corresponding cache line                [0]: valid, [1]: dirty, [2]: cmpt",
        }
      ]
    },
    { name:     "TAG_442",
      desc:     "Tag Address stored in cache line 442",
      swaccess: "rw",
      hwaccess: "hrw",
      hwext:    "true",
      hwqe:     "true", // enable `qe` latched signal of software write pulse
      hwre:     "true",
      fields: [
        { bits: "5-1:0",
          name: "CL_TAG",
          desc: "Tag Address"
        }
      ]
    },
    {
      name:     "STATUS_443",
      desc:     "Status register of cache line 443",
      swaccess: "rw",
      hwaccess: "hrw",
      hwext:    "true",
      hwqe:     "true", // enable `qe` latched signal of software write pulse
      hwre:     "true",
      fields: [
        {
          bits: "5+3:5", // 2 bits for status
          name: "CL_STATUS",
          desc: "Contain the current status of the corresponding cache line                [0]: valid, [1]: dirty, [2]: cmpt",
        }
      ]
    },
    { name:     "TAG_443",
      desc:     "Tag Address stored in cache line 443",
      swaccess: "rw",
      hwaccess: "hrw",
      hwext:    "true",
      hwqe:     "true", // enable `qe` latched signal of software write pulse
      hwre:     "true",
      fields: [
        { bits: "5-1:0",
          name: "CL_TAG",
          desc: "Tag Address"
        }
      ]
    },
    {
      name:     "STATUS_444",
      desc:     "Status register of cache line 444",
      swaccess: "rw",
      hwaccess: "hrw",
      hwext:    "true",
      hwqe:     "true", // enable `qe` latched signal of software write pulse
      hwre:     "true",
      fields: [
        {
          bits: "5+3:5", // 2 bits for status
          name: "CL_STATUS",
          desc: "Contain the current status of the corresponding cache line                [0]: valid, [1]: dirty, [2]: cmpt",
        }
      ]
    },
    { name:     "TAG_444",
      desc:     "Tag Address stored in cache line 444",
      swaccess: "rw",
      hwaccess: "hrw",
      hwext:    "true",
      hwqe:     "true", // enable `qe` latched signal of software write pulse
      hwre:     "true",
      fields: [
        { bits: "5-1:0",
          name: "CL_TAG",
          desc: "Tag Address"
        }
      ]
    },
    {
      name:     "STATUS_445",
      desc:     "Status register of cache line 445",
      swaccess: "rw",
      hwaccess: "hrw",
      hwext:    "true",
      hwqe:     "true", // enable `qe` latched signal of software write pulse
      hwre:     "true",
      fields: [
        {
          bits: "5+3:5", // 2 bits for status
          name: "CL_STATUS",
          desc: "Contain the current status of the corresponding cache line                [0]: valid, [1]: dirty, [2]: cmpt",
        }
      ]
    },
    { name:     "TAG_445",
      desc:     "Tag Address stored in cache line 445",
      swaccess: "rw",
      hwaccess: "hrw",
      hwext:    "true",
      hwqe:     "true", // enable `qe` latched signal of software write pulse
      hwre:     "true",
      fields: [
        { bits: "5-1:0",
          name: "CL_TAG",
          desc: "Tag Address"
        }
      ]
    },
    {
      name:     "STATUS_446",
      desc:     "Status register of cache line 446",
      swaccess: "rw",
      hwaccess: "hrw",
      hwext:    "true",
      hwqe:     "true", // enable `qe` latched signal of software write pulse
      hwre:     "true",
      fields: [
        {
          bits: "5+3:5", // 2 bits for status
          name: "CL_STATUS",
          desc: "Contain the current status of the corresponding cache line                [0]: valid, [1]: dirty, [2]: cmpt",
        }
      ]
    },
    { name:     "TAG_446",
      desc:     "Tag Address stored in cache line 446",
      swaccess: "rw",
      hwaccess: "hrw",
      hwext:    "true",
      hwqe:     "true", // enable `qe` latched signal of software write pulse
      hwre:     "true",
      fields: [
        { bits: "5-1:0",
          name: "CL_TAG",
          desc: "Tag Address"
        }
      ]
    },
    {
      name:     "STATUS_447",
      desc:     "Status register of cache line 447",
      swaccess: "rw",
      hwaccess: "hrw",
      hwext:    "true",
      hwqe:     "true", // enable `qe` latched signal of software write pulse
      hwre:     "true",
      fields: [
        {
          bits: "5+3:5", // 2 bits for status
          name: "CL_STATUS",
          desc: "Contain the current status of the corresponding cache line                [0]: valid, [1]: dirty, [2]: cmpt",
        }
      ]
    },
    { name:     "TAG_447",
      desc:     "Tag Address stored in cache line 447",
      swaccess: "rw",
      hwaccess: "hrw",
      hwext:    "true",
      hwqe:     "true", // enable `qe` latched signal of software write pulse
      hwre:     "true",
      fields: [
        { bits: "5-1:0",
          name: "CL_TAG",
          desc: "Tag Address"
        }
      ]
    },
    {
      name:     "STATUS_448",
      desc:     "Status register of cache line 448",
      swaccess: "rw",
      hwaccess: "hrw",
      hwext:    "true",
      hwqe:     "true", // enable `qe` latched signal of software write pulse
      hwre:     "true",
      fields: [
        {
          bits: "5+3:5", // 2 bits for status
          name: "CL_STATUS",
          desc: "Contain the current status of the corresponding cache line                [0]: valid, [1]: dirty, [2]: cmpt",
        }
      ]
    },
    { name:     "TAG_448",
      desc:     "Tag Address stored in cache line 448",
      swaccess: "rw",
      hwaccess: "hrw",
      hwext:    "true",
      hwqe:     "true", // enable `qe` latched signal of software write pulse
      hwre:     "true",
      fields: [
        { bits: "5-1:0",
          name: "CL_TAG",
          desc: "Tag Address"
        }
      ]
    },
    {
      name:     "STATUS_449",
      desc:     "Status register of cache line 449",
      swaccess: "rw",
      hwaccess: "hrw",
      hwext:    "true",
      hwqe:     "true", // enable `qe` latched signal of software write pulse
      hwre:     "true",
      fields: [
        {
          bits: "5+3:5", // 2 bits for status
          name: "CL_STATUS",
          desc: "Contain the current status of the corresponding cache line                [0]: valid, [1]: dirty, [2]: cmpt",
        }
      ]
    },
    { name:     "TAG_449",
      desc:     "Tag Address stored in cache line 449",
      swaccess: "rw",
      hwaccess: "hrw",
      hwext:    "true",
      hwqe:     "true", // enable `qe` latched signal of software write pulse
      hwre:     "true",
      fields: [
        { bits: "5-1:0",
          name: "CL_TAG",
          desc: "Tag Address"
        }
      ]
    },
    {
      name:     "STATUS_450",
      desc:     "Status register of cache line 450",
      swaccess: "rw",
      hwaccess: "hrw",
      hwext:    "true",
      hwqe:     "true", // enable `qe` latched signal of software write pulse
      hwre:     "true",
      fields: [
        {
          bits: "5+3:5", // 2 bits for status
          name: "CL_STATUS",
          desc: "Contain the current status of the corresponding cache line                [0]: valid, [1]: dirty, [2]: cmpt",
        }
      ]
    },
    { name:     "TAG_450",
      desc:     "Tag Address stored in cache line 450",
      swaccess: "rw",
      hwaccess: "hrw",
      hwext:    "true",
      hwqe:     "true", // enable `qe` latched signal of software write pulse
      hwre:     "true",
      fields: [
        { bits: "5-1:0",
          name: "CL_TAG",
          desc: "Tag Address"
        }
      ]
    },
    {
      name:     "STATUS_451",
      desc:     "Status register of cache line 451",
      swaccess: "rw",
      hwaccess: "hrw",
      hwext:    "true",
      hwqe:     "true", // enable `qe` latched signal of software write pulse
      hwre:     "true",
      fields: [
        {
          bits: "5+3:5", // 2 bits for status
          name: "CL_STATUS",
          desc: "Contain the current status of the corresponding cache line                [0]: valid, [1]: dirty, [2]: cmpt",
        }
      ]
    },
    { name:     "TAG_451",
      desc:     "Tag Address stored in cache line 451",
      swaccess: "rw",
      hwaccess: "hrw",
      hwext:    "true",
      hwqe:     "true", // enable `qe` latched signal of software write pulse
      hwre:     "true",
      fields: [
        { bits: "5-1:0",
          name: "CL_TAG",
          desc: "Tag Address"
        }
      ]
    },
    {
      name:     "STATUS_452",
      desc:     "Status register of cache line 452",
      swaccess: "rw",
      hwaccess: "hrw",
      hwext:    "true",
      hwqe:     "true", // enable `qe` latched signal of software write pulse
      hwre:     "true",
      fields: [
        {
          bits: "5+3:5", // 2 bits for status
          name: "CL_STATUS",
          desc: "Contain the current status of the corresponding cache line                [0]: valid, [1]: dirty, [2]: cmpt",
        }
      ]
    },
    { name:     "TAG_452",
      desc:     "Tag Address stored in cache line 452",
      swaccess: "rw",
      hwaccess: "hrw",
      hwext:    "true",
      hwqe:     "true", // enable `qe` latched signal of software write pulse
      hwre:     "true",
      fields: [
        { bits: "5-1:0",
          name: "CL_TAG",
          desc: "Tag Address"
        }
      ]
    },
    {
      name:     "STATUS_453",
      desc:     "Status register of cache line 453",
      swaccess: "rw",
      hwaccess: "hrw",
      hwext:    "true",
      hwqe:     "true", // enable `qe` latched signal of software write pulse
      hwre:     "true",
      fields: [
        {
          bits: "5+3:5", // 2 bits for status
          name: "CL_STATUS",
          desc: "Contain the current status of the corresponding cache line                [0]: valid, [1]: dirty, [2]: cmpt",
        }
      ]
    },
    { name:     "TAG_453",
      desc:     "Tag Address stored in cache line 453",
      swaccess: "rw",
      hwaccess: "hrw",
      hwext:    "true",
      hwqe:     "true", // enable `qe` latched signal of software write pulse
      hwre:     "true",
      fields: [
        { bits: "5-1:0",
          name: "CL_TAG",
          desc: "Tag Address"
        }
      ]
    },
    {
      name:     "STATUS_454",
      desc:     "Status register of cache line 454",
      swaccess: "rw",
      hwaccess: "hrw",
      hwext:    "true",
      hwqe:     "true", // enable `qe` latched signal of software write pulse
      hwre:     "true",
      fields: [
        {
          bits: "5+3:5", // 2 bits for status
          name: "CL_STATUS",
          desc: "Contain the current status of the corresponding cache line                [0]: valid, [1]: dirty, [2]: cmpt",
        }
      ]
    },
    { name:     "TAG_454",
      desc:     "Tag Address stored in cache line 454",
      swaccess: "rw",
      hwaccess: "hrw",
      hwext:    "true",
      hwqe:     "true", // enable `qe` latched signal of software write pulse
      hwre:     "true",
      fields: [
        { bits: "5-1:0",
          name: "CL_TAG",
          desc: "Tag Address"
        }
      ]
    },
    {
      name:     "STATUS_455",
      desc:     "Status register of cache line 455",
      swaccess: "rw",
      hwaccess: "hrw",
      hwext:    "true",
      hwqe:     "true", // enable `qe` latched signal of software write pulse
      hwre:     "true",
      fields: [
        {
          bits: "5+3:5", // 2 bits for status
          name: "CL_STATUS",
          desc: "Contain the current status of the corresponding cache line                [0]: valid, [1]: dirty, [2]: cmpt",
        }
      ]
    },
    { name:     "TAG_455",
      desc:     "Tag Address stored in cache line 455",
      swaccess: "rw",
      hwaccess: "hrw",
      hwext:    "true",
      hwqe:     "true", // enable `qe` latched signal of software write pulse
      hwre:     "true",
      fields: [
        { bits: "5-1:0",
          name: "CL_TAG",
          desc: "Tag Address"
        }
      ]
    },
    {
      name:     "STATUS_456",
      desc:     "Status register of cache line 456",
      swaccess: "rw",
      hwaccess: "hrw",
      hwext:    "true",
      hwqe:     "true", // enable `qe` latched signal of software write pulse
      hwre:     "true",
      fields: [
        {
          bits: "5+3:5", // 2 bits for status
          name: "CL_STATUS",
          desc: "Contain the current status of the corresponding cache line                [0]: valid, [1]: dirty, [2]: cmpt",
        }
      ]
    },
    { name:     "TAG_456",
      desc:     "Tag Address stored in cache line 456",
      swaccess: "rw",
      hwaccess: "hrw",
      hwext:    "true",
      hwqe:     "true", // enable `qe` latched signal of software write pulse
      hwre:     "true",
      fields: [
        { bits: "5-1:0",
          name: "CL_TAG",
          desc: "Tag Address"
        }
      ]
    },
    {
      name:     "STATUS_457",
      desc:     "Status register of cache line 457",
      swaccess: "rw",
      hwaccess: "hrw",
      hwext:    "true",
      hwqe:     "true", // enable `qe` latched signal of software write pulse
      hwre:     "true",
      fields: [
        {
          bits: "5+3:5", // 2 bits for status
          name: "CL_STATUS",
          desc: "Contain the current status of the corresponding cache line                [0]: valid, [1]: dirty, [2]: cmpt",
        }
      ]
    },
    { name:     "TAG_457",
      desc:     "Tag Address stored in cache line 457",
      swaccess: "rw",
      hwaccess: "hrw",
      hwext:    "true",
      hwqe:     "true", // enable `qe` latched signal of software write pulse
      hwre:     "true",
      fields: [
        { bits: "5-1:0",
          name: "CL_TAG",
          desc: "Tag Address"
        }
      ]
    },
    {
      name:     "STATUS_458",
      desc:     "Status register of cache line 458",
      swaccess: "rw",
      hwaccess: "hrw",
      hwext:    "true",
      hwqe:     "true", // enable `qe` latched signal of software write pulse
      hwre:     "true",
      fields: [
        {
          bits: "5+3:5", // 2 bits for status
          name: "CL_STATUS",
          desc: "Contain the current status of the corresponding cache line                [0]: valid, [1]: dirty, [2]: cmpt",
        }
      ]
    },
    { name:     "TAG_458",
      desc:     "Tag Address stored in cache line 458",
      swaccess: "rw",
      hwaccess: "hrw",
      hwext:    "true",
      hwqe:     "true", // enable `qe` latched signal of software write pulse
      hwre:     "true",
      fields: [
        { bits: "5-1:0",
          name: "CL_TAG",
          desc: "Tag Address"
        }
      ]
    },
    {
      name:     "STATUS_459",
      desc:     "Status register of cache line 459",
      swaccess: "rw",
      hwaccess: "hrw",
      hwext:    "true",
      hwqe:     "true", // enable `qe` latched signal of software write pulse
      hwre:     "true",
      fields: [
        {
          bits: "5+3:5", // 2 bits for status
          name: "CL_STATUS",
          desc: "Contain the current status of the corresponding cache line                [0]: valid, [1]: dirty, [2]: cmpt",
        }
      ]
    },
    { name:     "TAG_459",
      desc:     "Tag Address stored in cache line 459",
      swaccess: "rw",
      hwaccess: "hrw",
      hwext:    "true",
      hwqe:     "true", // enable `qe` latched signal of software write pulse
      hwre:     "true",
      fields: [
        { bits: "5-1:0",
          name: "CL_TAG",
          desc: "Tag Address"
        }
      ]
    },
    {
      name:     "STATUS_460",
      desc:     "Status register of cache line 460",
      swaccess: "rw",
      hwaccess: "hrw",
      hwext:    "true",
      hwqe:     "true", // enable `qe` latched signal of software write pulse
      hwre:     "true",
      fields: [
        {
          bits: "5+3:5", // 2 bits for status
          name: "CL_STATUS",
          desc: "Contain the current status of the corresponding cache line                [0]: valid, [1]: dirty, [2]: cmpt",
        }
      ]
    },
    { name:     "TAG_460",
      desc:     "Tag Address stored in cache line 460",
      swaccess: "rw",
      hwaccess: "hrw",
      hwext:    "true",
      hwqe:     "true", // enable `qe` latched signal of software write pulse
      hwre:     "true",
      fields: [
        { bits: "5-1:0",
          name: "CL_TAG",
          desc: "Tag Address"
        }
      ]
    },
    {
      name:     "STATUS_461",
      desc:     "Status register of cache line 461",
      swaccess: "rw",
      hwaccess: "hrw",
      hwext:    "true",
      hwqe:     "true", // enable `qe` latched signal of software write pulse
      hwre:     "true",
      fields: [
        {
          bits: "5+3:5", // 2 bits for status
          name: "CL_STATUS",
          desc: "Contain the current status of the corresponding cache line                [0]: valid, [1]: dirty, [2]: cmpt",
        }
      ]
    },
    { name:     "TAG_461",
      desc:     "Tag Address stored in cache line 461",
      swaccess: "rw",
      hwaccess: "hrw",
      hwext:    "true",
      hwqe:     "true", // enable `qe` latched signal of software write pulse
      hwre:     "true",
      fields: [
        { bits: "5-1:0",
          name: "CL_TAG",
          desc: "Tag Address"
        }
      ]
    },
    {
      name:     "STATUS_462",
      desc:     "Status register of cache line 462",
      swaccess: "rw",
      hwaccess: "hrw",
      hwext:    "true",
      hwqe:     "true", // enable `qe` latched signal of software write pulse
      hwre:     "true",
      fields: [
        {
          bits: "5+3:5", // 2 bits for status
          name: "CL_STATUS",
          desc: "Contain the current status of the corresponding cache line                [0]: valid, [1]: dirty, [2]: cmpt",
        }
      ]
    },
    { name:     "TAG_462",
      desc:     "Tag Address stored in cache line 462",
      swaccess: "rw",
      hwaccess: "hrw",
      hwext:    "true",
      hwqe:     "true", // enable `qe` latched signal of software write pulse
      hwre:     "true",
      fields: [
        { bits: "5-1:0",
          name: "CL_TAG",
          desc: "Tag Address"
        }
      ]
    },
    {
      name:     "STATUS_463",
      desc:     "Status register of cache line 463",
      swaccess: "rw",
      hwaccess: "hrw",
      hwext:    "true",
      hwqe:     "true", // enable `qe` latched signal of software write pulse
      hwre:     "true",
      fields: [
        {
          bits: "5+3:5", // 2 bits for status
          name: "CL_STATUS",
          desc: "Contain the current status of the corresponding cache line                [0]: valid, [1]: dirty, [2]: cmpt",
        }
      ]
    },
    { name:     "TAG_463",
      desc:     "Tag Address stored in cache line 463",
      swaccess: "rw",
      hwaccess: "hrw",
      hwext:    "true",
      hwqe:     "true", // enable `qe` latched signal of software write pulse
      hwre:     "true",
      fields: [
        { bits: "5-1:0",
          name: "CL_TAG",
          desc: "Tag Address"
        }
      ]
    },
    {
      name:     "STATUS_464",
      desc:     "Status register of cache line 464",
      swaccess: "rw",
      hwaccess: "hrw",
      hwext:    "true",
      hwqe:     "true", // enable `qe` latched signal of software write pulse
      hwre:     "true",
      fields: [
        {
          bits: "5+3:5", // 2 bits for status
          name: "CL_STATUS",
          desc: "Contain the current status of the corresponding cache line                [0]: valid, [1]: dirty, [2]: cmpt",
        }
      ]
    },
    { name:     "TAG_464",
      desc:     "Tag Address stored in cache line 464",
      swaccess: "rw",
      hwaccess: "hrw",
      hwext:    "true",
      hwqe:     "true", // enable `qe` latched signal of software write pulse
      hwre:     "true",
      fields: [
        { bits: "5-1:0",
          name: "CL_TAG",
          desc: "Tag Address"
        }
      ]
    },
    {
      name:     "STATUS_465",
      desc:     "Status register of cache line 465",
      swaccess: "rw",
      hwaccess: "hrw",
      hwext:    "true",
      hwqe:     "true", // enable `qe` latched signal of software write pulse
      hwre:     "true",
      fields: [
        {
          bits: "5+3:5", // 2 bits for status
          name: "CL_STATUS",
          desc: "Contain the current status of the corresponding cache line                [0]: valid, [1]: dirty, [2]: cmpt",
        }
      ]
    },
    { name:     "TAG_465",
      desc:     "Tag Address stored in cache line 465",
      swaccess: "rw",
      hwaccess: "hrw",
      hwext:    "true",
      hwqe:     "true", // enable `qe` latched signal of software write pulse
      hwre:     "true",
      fields: [
        { bits: "5-1:0",
          name: "CL_TAG",
          desc: "Tag Address"
        }
      ]
    },
    {
      name:     "STATUS_466",
      desc:     "Status register of cache line 466",
      swaccess: "rw",
      hwaccess: "hrw",
      hwext:    "true",
      hwqe:     "true", // enable `qe` latched signal of software write pulse
      hwre:     "true",
      fields: [
        {
          bits: "5+3:5", // 2 bits for status
          name: "CL_STATUS",
          desc: "Contain the current status of the corresponding cache line                [0]: valid, [1]: dirty, [2]: cmpt",
        }
      ]
    },
    { name:     "TAG_466",
      desc:     "Tag Address stored in cache line 466",
      swaccess: "rw",
      hwaccess: "hrw",
      hwext:    "true",
      hwqe:     "true", // enable `qe` latched signal of software write pulse
      hwre:     "true",
      fields: [
        { bits: "5-1:0",
          name: "CL_TAG",
          desc: "Tag Address"
        }
      ]
    },
    {
      name:     "STATUS_467",
      desc:     "Status register of cache line 467",
      swaccess: "rw",
      hwaccess: "hrw",
      hwext:    "true",
      hwqe:     "true", // enable `qe` latched signal of software write pulse
      hwre:     "true",
      fields: [
        {
          bits: "5+3:5", // 2 bits for status
          name: "CL_STATUS",
          desc: "Contain the current status of the corresponding cache line                [0]: valid, [1]: dirty, [2]: cmpt",
        }
      ]
    },
    { name:     "TAG_467",
      desc:     "Tag Address stored in cache line 467",
      swaccess: "rw",
      hwaccess: "hrw",
      hwext:    "true",
      hwqe:     "true", // enable `qe` latched signal of software write pulse
      hwre:     "true",
      fields: [
        { bits: "5-1:0",
          name: "CL_TAG",
          desc: "Tag Address"
        }
      ]
    },
    {
      name:     "STATUS_468",
      desc:     "Status register of cache line 468",
      swaccess: "rw",
      hwaccess: "hrw",
      hwext:    "true",
      hwqe:     "true", // enable `qe` latched signal of software write pulse
      hwre:     "true",
      fields: [
        {
          bits: "5+3:5", // 2 bits for status
          name: "CL_STATUS",
          desc: "Contain the current status of the corresponding cache line                [0]: valid, [1]: dirty, [2]: cmpt",
        }
      ]
    },
    { name:     "TAG_468",
      desc:     "Tag Address stored in cache line 468",
      swaccess: "rw",
      hwaccess: "hrw",
      hwext:    "true",
      hwqe:     "true", // enable `qe` latched signal of software write pulse
      hwre:     "true",
      fields: [
        { bits: "5-1:0",
          name: "CL_TAG",
          desc: "Tag Address"
        }
      ]
    },
    {
      name:     "STATUS_469",
      desc:     "Status register of cache line 469",
      swaccess: "rw",
      hwaccess: "hrw",
      hwext:    "true",
      hwqe:     "true", // enable `qe` latched signal of software write pulse
      hwre:     "true",
      fields: [
        {
          bits: "5+3:5", // 2 bits for status
          name: "CL_STATUS",
          desc: "Contain the current status of the corresponding cache line                [0]: valid, [1]: dirty, [2]: cmpt",
        }
      ]
    },
    { name:     "TAG_469",
      desc:     "Tag Address stored in cache line 469",
      swaccess: "rw",
      hwaccess: "hrw",
      hwext:    "true",
      hwqe:     "true", // enable `qe` latched signal of software write pulse
      hwre:     "true",
      fields: [
        { bits: "5-1:0",
          name: "CL_TAG",
          desc: "Tag Address"
        }
      ]
    },
    {
      name:     "STATUS_470",
      desc:     "Status register of cache line 470",
      swaccess: "rw",
      hwaccess: "hrw",
      hwext:    "true",
      hwqe:     "true", // enable `qe` latched signal of software write pulse
      hwre:     "true",
      fields: [
        {
          bits: "5+3:5", // 2 bits for status
          name: "CL_STATUS",
          desc: "Contain the current status of the corresponding cache line                [0]: valid, [1]: dirty, [2]: cmpt",
        }
      ]
    },
    { name:     "TAG_470",
      desc:     "Tag Address stored in cache line 470",
      swaccess: "rw",
      hwaccess: "hrw",
      hwext:    "true",
      hwqe:     "true", // enable `qe` latched signal of software write pulse
      hwre:     "true",
      fields: [
        { bits: "5-1:0",
          name: "CL_TAG",
          desc: "Tag Address"
        }
      ]
    },
    {
      name:     "STATUS_471",
      desc:     "Status register of cache line 471",
      swaccess: "rw",
      hwaccess: "hrw",
      hwext:    "true",
      hwqe:     "true", // enable `qe` latched signal of software write pulse
      hwre:     "true",
      fields: [
        {
          bits: "5+3:5", // 2 bits for status
          name: "CL_STATUS",
          desc: "Contain the current status of the corresponding cache line                [0]: valid, [1]: dirty, [2]: cmpt",
        }
      ]
    },
    { name:     "TAG_471",
      desc:     "Tag Address stored in cache line 471",
      swaccess: "rw",
      hwaccess: "hrw",
      hwext:    "true",
      hwqe:     "true", // enable `qe` latched signal of software write pulse
      hwre:     "true",
      fields: [
        { bits: "5-1:0",
          name: "CL_TAG",
          desc: "Tag Address"
        }
      ]
    },
    {
      name:     "STATUS_472",
      desc:     "Status register of cache line 472",
      swaccess: "rw",
      hwaccess: "hrw",
      hwext:    "true",
      hwqe:     "true", // enable `qe` latched signal of software write pulse
      hwre:     "true",
      fields: [
        {
          bits: "5+3:5", // 2 bits for status
          name: "CL_STATUS",
          desc: "Contain the current status of the corresponding cache line                [0]: valid, [1]: dirty, [2]: cmpt",
        }
      ]
    },
    { name:     "TAG_472",
      desc:     "Tag Address stored in cache line 472",
      swaccess: "rw",
      hwaccess: "hrw",
      hwext:    "true",
      hwqe:     "true", // enable `qe` latched signal of software write pulse
      hwre:     "true",
      fields: [
        { bits: "5-1:0",
          name: "CL_TAG",
          desc: "Tag Address"
        }
      ]
    },
    {
      name:     "STATUS_473",
      desc:     "Status register of cache line 473",
      swaccess: "rw",
      hwaccess: "hrw",
      hwext:    "true",
      hwqe:     "true", // enable `qe` latched signal of software write pulse
      hwre:     "true",
      fields: [
        {
          bits: "5+3:5", // 2 bits for status
          name: "CL_STATUS",
          desc: "Contain the current status of the corresponding cache line                [0]: valid, [1]: dirty, [2]: cmpt",
        }
      ]
    },
    { name:     "TAG_473",
      desc:     "Tag Address stored in cache line 473",
      swaccess: "rw",
      hwaccess: "hrw",
      hwext:    "true",
      hwqe:     "true", // enable `qe` latched signal of software write pulse
      hwre:     "true",
      fields: [
        { bits: "5-1:0",
          name: "CL_TAG",
          desc: "Tag Address"
        }
      ]
    },
    {
      name:     "STATUS_474",
      desc:     "Status register of cache line 474",
      swaccess: "rw",
      hwaccess: "hrw",
      hwext:    "true",
      hwqe:     "true", // enable `qe` latched signal of software write pulse
      hwre:     "true",
      fields: [
        {
          bits: "5+3:5", // 2 bits for status
          name: "CL_STATUS",
          desc: "Contain the current status of the corresponding cache line                [0]: valid, [1]: dirty, [2]: cmpt",
        }
      ]
    },
    { name:     "TAG_474",
      desc:     "Tag Address stored in cache line 474",
      swaccess: "rw",
      hwaccess: "hrw",
      hwext:    "true",
      hwqe:     "true", // enable `qe` latched signal of software write pulse
      hwre:     "true",
      fields: [
        { bits: "5-1:0",
          name: "CL_TAG",
          desc: "Tag Address"
        }
      ]
    },
    {
      name:     "STATUS_475",
      desc:     "Status register of cache line 475",
      swaccess: "rw",
      hwaccess: "hrw",
      hwext:    "true",
      hwqe:     "true", // enable `qe` latched signal of software write pulse
      hwre:     "true",
      fields: [
        {
          bits: "5+3:5", // 2 bits for status
          name: "CL_STATUS",
          desc: "Contain the current status of the corresponding cache line                [0]: valid, [1]: dirty, [2]: cmpt",
        }
      ]
    },
    { name:     "TAG_475",
      desc:     "Tag Address stored in cache line 475",
      swaccess: "rw",
      hwaccess: "hrw",
      hwext:    "true",
      hwqe:     "true", // enable `qe` latched signal of software write pulse
      hwre:     "true",
      fields: [
        { bits: "5-1:0",
          name: "CL_TAG",
          desc: "Tag Address"
        }
      ]
    },
    {
      name:     "STATUS_476",
      desc:     "Status register of cache line 476",
      swaccess: "rw",
      hwaccess: "hrw",
      hwext:    "true",
      hwqe:     "true", // enable `qe` latched signal of software write pulse
      hwre:     "true",
      fields: [
        {
          bits: "5+3:5", // 2 bits for status
          name: "CL_STATUS",
          desc: "Contain the current status of the corresponding cache line                [0]: valid, [1]: dirty, [2]: cmpt",
        }
      ]
    },
    { name:     "TAG_476",
      desc:     "Tag Address stored in cache line 476",
      swaccess: "rw",
      hwaccess: "hrw",
      hwext:    "true",
      hwqe:     "true", // enable `qe` latched signal of software write pulse
      hwre:     "true",
      fields: [
        { bits: "5-1:0",
          name: "CL_TAG",
          desc: "Tag Address"
        }
      ]
    },
    {
      name:     "STATUS_477",
      desc:     "Status register of cache line 477",
      swaccess: "rw",
      hwaccess: "hrw",
      hwext:    "true",
      hwqe:     "true", // enable `qe` latched signal of software write pulse
      hwre:     "true",
      fields: [
        {
          bits: "5+3:5", // 2 bits for status
          name: "CL_STATUS",
          desc: "Contain the current status of the corresponding cache line                [0]: valid, [1]: dirty, [2]: cmpt",
        }
      ]
    },
    { name:     "TAG_477",
      desc:     "Tag Address stored in cache line 477",
      swaccess: "rw",
      hwaccess: "hrw",
      hwext:    "true",
      hwqe:     "true", // enable `qe` latched signal of software write pulse
      hwre:     "true",
      fields: [
        { bits: "5-1:0",
          name: "CL_TAG",
          desc: "Tag Address"
        }
      ]
    },
    {
      name:     "STATUS_478",
      desc:     "Status register of cache line 478",
      swaccess: "rw",
      hwaccess: "hrw",
      hwext:    "true",
      hwqe:     "true", // enable `qe` latched signal of software write pulse
      hwre:     "true",
      fields: [
        {
          bits: "5+3:5", // 2 bits for status
          name: "CL_STATUS",
          desc: "Contain the current status of the corresponding cache line                [0]: valid, [1]: dirty, [2]: cmpt",
        }
      ]
    },
    { name:     "TAG_478",
      desc:     "Tag Address stored in cache line 478",
      swaccess: "rw",
      hwaccess: "hrw",
      hwext:    "true",
      hwqe:     "true", // enable `qe` latched signal of software write pulse
      hwre:     "true",
      fields: [
        { bits: "5-1:0",
          name: "CL_TAG",
          desc: "Tag Address"
        }
      ]
    },
    {
      name:     "STATUS_479",
      desc:     "Status register of cache line 479",
      swaccess: "rw",
      hwaccess: "hrw",
      hwext:    "true",
      hwqe:     "true", // enable `qe` latched signal of software write pulse
      hwre:     "true",
      fields: [
        {
          bits: "5+3:5", // 2 bits for status
          name: "CL_STATUS",
          desc: "Contain the current status of the corresponding cache line                [0]: valid, [1]: dirty, [2]: cmpt",
        }
      ]
    },
    { name:     "TAG_479",
      desc:     "Tag Address stored in cache line 479",
      swaccess: "rw",
      hwaccess: "hrw",
      hwext:    "true",
      hwqe:     "true", // enable `qe` latched signal of software write pulse
      hwre:     "true",
      fields: [
        { bits: "5-1:0",
          name: "CL_TAG",
          desc: "Tag Address"
        }
      ]
    },
    {
      name:     "STATUS_480",
      desc:     "Status register of cache line 480",
      swaccess: "rw",
      hwaccess: "hrw",
      hwext:    "true",
      hwqe:     "true", // enable `qe` latched signal of software write pulse
      hwre:     "true",
      fields: [
        {
          bits: "5+3:5", // 2 bits for status
          name: "CL_STATUS",
          desc: "Contain the current status of the corresponding cache line                [0]: valid, [1]: dirty, [2]: cmpt",
        }
      ]
    },
    { name:     "TAG_480",
      desc:     "Tag Address stored in cache line 480",
      swaccess: "rw",
      hwaccess: "hrw",
      hwext:    "true",
      hwqe:     "true", // enable `qe` latched signal of software write pulse
      hwre:     "true",
      fields: [
        { bits: "5-1:0",
          name: "CL_TAG",
          desc: "Tag Address"
        }
      ]
    },
    {
      name:     "STATUS_481",
      desc:     "Status register of cache line 481",
      swaccess: "rw",
      hwaccess: "hrw",
      hwext:    "true",
      hwqe:     "true", // enable `qe` latched signal of software write pulse
      hwre:     "true",
      fields: [
        {
          bits: "5+3:5", // 2 bits for status
          name: "CL_STATUS",
          desc: "Contain the current status of the corresponding cache line                [0]: valid, [1]: dirty, [2]: cmpt",
        }
      ]
    },
    { name:     "TAG_481",
      desc:     "Tag Address stored in cache line 481",
      swaccess: "rw",
      hwaccess: "hrw",
      hwext:    "true",
      hwqe:     "true", // enable `qe` latched signal of software write pulse
      hwre:     "true",
      fields: [
        { bits: "5-1:0",
          name: "CL_TAG",
          desc: "Tag Address"
        }
      ]
    },
    {
      name:     "STATUS_482",
      desc:     "Status register of cache line 482",
      swaccess: "rw",
      hwaccess: "hrw",
      hwext:    "true",
      hwqe:     "true", // enable `qe` latched signal of software write pulse
      hwre:     "true",
      fields: [
        {
          bits: "5+3:5", // 2 bits for status
          name: "CL_STATUS",
          desc: "Contain the current status of the corresponding cache line                [0]: valid, [1]: dirty, [2]: cmpt",
        }
      ]
    },
    { name:     "TAG_482",
      desc:     "Tag Address stored in cache line 482",
      swaccess: "rw",
      hwaccess: "hrw",
      hwext:    "true",
      hwqe:     "true", // enable `qe` latched signal of software write pulse
      hwre:     "true",
      fields: [
        { bits: "5-1:0",
          name: "CL_TAG",
          desc: "Tag Address"
        }
      ]
    },
    {
      name:     "STATUS_483",
      desc:     "Status register of cache line 483",
      swaccess: "rw",
      hwaccess: "hrw",
      hwext:    "true",
      hwqe:     "true", // enable `qe` latched signal of software write pulse
      hwre:     "true",
      fields: [
        {
          bits: "5+3:5", // 2 bits for status
          name: "CL_STATUS",
          desc: "Contain the current status of the corresponding cache line                [0]: valid, [1]: dirty, [2]: cmpt",
        }
      ]
    },
    { name:     "TAG_483",
      desc:     "Tag Address stored in cache line 483",
      swaccess: "rw",
      hwaccess: "hrw",
      hwext:    "true",
      hwqe:     "true", // enable `qe` latched signal of software write pulse
      hwre:     "true",
      fields: [
        { bits: "5-1:0",
          name: "CL_TAG",
          desc: "Tag Address"
        }
      ]
    },
    {
      name:     "STATUS_484",
      desc:     "Status register of cache line 484",
      swaccess: "rw",
      hwaccess: "hrw",
      hwext:    "true",
      hwqe:     "true", // enable `qe` latched signal of software write pulse
      hwre:     "true",
      fields: [
        {
          bits: "5+3:5", // 2 bits for status
          name: "CL_STATUS",
          desc: "Contain the current status of the corresponding cache line                [0]: valid, [1]: dirty, [2]: cmpt",
        }
      ]
    },
    { name:     "TAG_484",
      desc:     "Tag Address stored in cache line 484",
      swaccess: "rw",
      hwaccess: "hrw",
      hwext:    "true",
      hwqe:     "true", // enable `qe` latched signal of software write pulse
      hwre:     "true",
      fields: [
        { bits: "5-1:0",
          name: "CL_TAG",
          desc: "Tag Address"
        }
      ]
    },
    {
      name:     "STATUS_485",
      desc:     "Status register of cache line 485",
      swaccess: "rw",
      hwaccess: "hrw",
      hwext:    "true",
      hwqe:     "true", // enable `qe` latched signal of software write pulse
      hwre:     "true",
      fields: [
        {
          bits: "5+3:5", // 2 bits for status
          name: "CL_STATUS",
          desc: "Contain the current status of the corresponding cache line                [0]: valid, [1]: dirty, [2]: cmpt",
        }
      ]
    },
    { name:     "TAG_485",
      desc:     "Tag Address stored in cache line 485",
      swaccess: "rw",
      hwaccess: "hrw",
      hwext:    "true",
      hwqe:     "true", // enable `qe` latched signal of software write pulse
      hwre:     "true",
      fields: [
        { bits: "5-1:0",
          name: "CL_TAG",
          desc: "Tag Address"
        }
      ]
    },
    {
      name:     "STATUS_486",
      desc:     "Status register of cache line 486",
      swaccess: "rw",
      hwaccess: "hrw",
      hwext:    "true",
      hwqe:     "true", // enable `qe` latched signal of software write pulse
      hwre:     "true",
      fields: [
        {
          bits: "5+3:5", // 2 bits for status
          name: "CL_STATUS",
          desc: "Contain the current status of the corresponding cache line                [0]: valid, [1]: dirty, [2]: cmpt",
        }
      ]
    },
    { name:     "TAG_486",
      desc:     "Tag Address stored in cache line 486",
      swaccess: "rw",
      hwaccess: "hrw",
      hwext:    "true",
      hwqe:     "true", // enable `qe` latched signal of software write pulse
      hwre:     "true",
      fields: [
        { bits: "5-1:0",
          name: "CL_TAG",
          desc: "Tag Address"
        }
      ]
    },
    {
      name:     "STATUS_487",
      desc:     "Status register of cache line 487",
      swaccess: "rw",
      hwaccess: "hrw",
      hwext:    "true",
      hwqe:     "true", // enable `qe` latched signal of software write pulse
      hwre:     "true",
      fields: [
        {
          bits: "5+3:5", // 2 bits for status
          name: "CL_STATUS",
          desc: "Contain the current status of the corresponding cache line                [0]: valid, [1]: dirty, [2]: cmpt",
        }
      ]
    },
    { name:     "TAG_487",
      desc:     "Tag Address stored in cache line 487",
      swaccess: "rw",
      hwaccess: "hrw",
      hwext:    "true",
      hwqe:     "true", // enable `qe` latched signal of software write pulse
      hwre:     "true",
      fields: [
        { bits: "5-1:0",
          name: "CL_TAG",
          desc: "Tag Address"
        }
      ]
    },
    {
      name:     "STATUS_488",
      desc:     "Status register of cache line 488",
      swaccess: "rw",
      hwaccess: "hrw",
      hwext:    "true",
      hwqe:     "true", // enable `qe` latched signal of software write pulse
      hwre:     "true",
      fields: [
        {
          bits: "5+3:5", // 2 bits for status
          name: "CL_STATUS",
          desc: "Contain the current status of the corresponding cache line                [0]: valid, [1]: dirty, [2]: cmpt",
        }
      ]
    },
    { name:     "TAG_488",
      desc:     "Tag Address stored in cache line 488",
      swaccess: "rw",
      hwaccess: "hrw",
      hwext:    "true",
      hwqe:     "true", // enable `qe` latched signal of software write pulse
      hwre:     "true",
      fields: [
        { bits: "5-1:0",
          name: "CL_TAG",
          desc: "Tag Address"
        }
      ]
    },
    {
      name:     "STATUS_489",
      desc:     "Status register of cache line 489",
      swaccess: "rw",
      hwaccess: "hrw",
      hwext:    "true",
      hwqe:     "true", // enable `qe` latched signal of software write pulse
      hwre:     "true",
      fields: [
        {
          bits: "5+3:5", // 2 bits for status
          name: "CL_STATUS",
          desc: "Contain the current status of the corresponding cache line                [0]: valid, [1]: dirty, [2]: cmpt",
        }
      ]
    },
    { name:     "TAG_489",
      desc:     "Tag Address stored in cache line 489",
      swaccess: "rw",
      hwaccess: "hrw",
      hwext:    "true",
      hwqe:     "true", // enable `qe` latched signal of software write pulse
      hwre:     "true",
      fields: [
        { bits: "5-1:0",
          name: "CL_TAG",
          desc: "Tag Address"
        }
      ]
    },
    {
      name:     "STATUS_490",
      desc:     "Status register of cache line 490",
      swaccess: "rw",
      hwaccess: "hrw",
      hwext:    "true",
      hwqe:     "true", // enable `qe` latched signal of software write pulse
      hwre:     "true",
      fields: [
        {
          bits: "5+3:5", // 2 bits for status
          name: "CL_STATUS",
          desc: "Contain the current status of the corresponding cache line                [0]: valid, [1]: dirty, [2]: cmpt",
        }
      ]
    },
    { name:     "TAG_490",
      desc:     "Tag Address stored in cache line 490",
      swaccess: "rw",
      hwaccess: "hrw",
      hwext:    "true",
      hwqe:     "true", // enable `qe` latched signal of software write pulse
      hwre:     "true",
      fields: [
        { bits: "5-1:0",
          name: "CL_TAG",
          desc: "Tag Address"
        }
      ]
    },
    {
      name:     "STATUS_491",
      desc:     "Status register of cache line 491",
      swaccess: "rw",
      hwaccess: "hrw",
      hwext:    "true",
      hwqe:     "true", // enable `qe` latched signal of software write pulse
      hwre:     "true",
      fields: [
        {
          bits: "5+3:5", // 2 bits for status
          name: "CL_STATUS",
          desc: "Contain the current status of the corresponding cache line                [0]: valid, [1]: dirty, [2]: cmpt",
        }
      ]
    },
    { name:     "TAG_491",
      desc:     "Tag Address stored in cache line 491",
      swaccess: "rw",
      hwaccess: "hrw",
      hwext:    "true",
      hwqe:     "true", // enable `qe` latched signal of software write pulse
      hwre:     "true",
      fields: [
        { bits: "5-1:0",
          name: "CL_TAG",
          desc: "Tag Address"
        }
      ]
    },
    {
      name:     "STATUS_492",
      desc:     "Status register of cache line 492",
      swaccess: "rw",
      hwaccess: "hrw",
      hwext:    "true",
      hwqe:     "true", // enable `qe` latched signal of software write pulse
      hwre:     "true",
      fields: [
        {
          bits: "5+3:5", // 2 bits for status
          name: "CL_STATUS",
          desc: "Contain the current status of the corresponding cache line                [0]: valid, [1]: dirty, [2]: cmpt",
        }
      ]
    },
    { name:     "TAG_492",
      desc:     "Tag Address stored in cache line 492",
      swaccess: "rw",
      hwaccess: "hrw",
      hwext:    "true",
      hwqe:     "true", // enable `qe` latched signal of software write pulse
      hwre:     "true",
      fields: [
        { bits: "5-1:0",
          name: "CL_TAG",
          desc: "Tag Address"
        }
      ]
    },
    {
      name:     "STATUS_493",
      desc:     "Status register of cache line 493",
      swaccess: "rw",
      hwaccess: "hrw",
      hwext:    "true",
      hwqe:     "true", // enable `qe` latched signal of software write pulse
      hwre:     "true",
      fields: [
        {
          bits: "5+3:5", // 2 bits for status
          name: "CL_STATUS",
          desc: "Contain the current status of the corresponding cache line                [0]: valid, [1]: dirty, [2]: cmpt",
        }
      ]
    },
    { name:     "TAG_493",
      desc:     "Tag Address stored in cache line 493",
      swaccess: "rw",
      hwaccess: "hrw",
      hwext:    "true",
      hwqe:     "true", // enable `qe` latched signal of software write pulse
      hwre:     "true",
      fields: [
        { bits: "5-1:0",
          name: "CL_TAG",
          desc: "Tag Address"
        }
      ]
    },
    {
      name:     "STATUS_494",
      desc:     "Status register of cache line 494",
      swaccess: "rw",
      hwaccess: "hrw",
      hwext:    "true",
      hwqe:     "true", // enable `qe` latched signal of software write pulse
      hwre:     "true",
      fields: [
        {
          bits: "5+3:5", // 2 bits for status
          name: "CL_STATUS",
          desc: "Contain the current status of the corresponding cache line                [0]: valid, [1]: dirty, [2]: cmpt",
        }
      ]
    },
    { name:     "TAG_494",
      desc:     "Tag Address stored in cache line 494",
      swaccess: "rw",
      hwaccess: "hrw",
      hwext:    "true",
      hwqe:     "true", // enable `qe` latched signal of software write pulse
      hwre:     "true",
      fields: [
        { bits: "5-1:0",
          name: "CL_TAG",
          desc: "Tag Address"
        }
      ]
    },
    {
      name:     "STATUS_495",
      desc:     "Status register of cache line 495",
      swaccess: "rw",
      hwaccess: "hrw",
      hwext:    "true",
      hwqe:     "true", // enable `qe` latched signal of software write pulse
      hwre:     "true",
      fields: [
        {
          bits: "5+3:5", // 2 bits for status
          name: "CL_STATUS",
          desc: "Contain the current status of the corresponding cache line                [0]: valid, [1]: dirty, [2]: cmpt",
        }
      ]
    },
    { name:     "TAG_495",
      desc:     "Tag Address stored in cache line 495",
      swaccess: "rw",
      hwaccess: "hrw",
      hwext:    "true",
      hwqe:     "true", // enable `qe` latched signal of software write pulse
      hwre:     "true",
      fields: [
        { bits: "5-1:0",
          name: "CL_TAG",
          desc: "Tag Address"
        }
      ]
    },
    {
      name:     "STATUS_496",
      desc:     "Status register of cache line 496",
      swaccess: "rw",
      hwaccess: "hrw",
      hwext:    "true",
      hwqe:     "true", // enable `qe` latched signal of software write pulse
      hwre:     "true",
      fields: [
        {
          bits: "5+3:5", // 2 bits for status
          name: "CL_STATUS",
          desc: "Contain the current status of the corresponding cache line                [0]: valid, [1]: dirty, [2]: cmpt",
        }
      ]
    },
    { name:     "TAG_496",
      desc:     "Tag Address stored in cache line 496",
      swaccess: "rw",
      hwaccess: "hrw",
      hwext:    "true",
      hwqe:     "true", // enable `qe` latched signal of software write pulse
      hwre:     "true",
      fields: [
        { bits: "5-1:0",
          name: "CL_TAG",
          desc: "Tag Address"
        }
      ]
    },
    {
      name:     "STATUS_497",
      desc:     "Status register of cache line 497",
      swaccess: "rw",
      hwaccess: "hrw",
      hwext:    "true",
      hwqe:     "true", // enable `qe` latched signal of software write pulse
      hwre:     "true",
      fields: [
        {
          bits: "5+3:5", // 2 bits for status
          name: "CL_STATUS",
          desc: "Contain the current status of the corresponding cache line                [0]: valid, [1]: dirty, [2]: cmpt",
        }
      ]
    },
    { name:     "TAG_497",
      desc:     "Tag Address stored in cache line 497",
      swaccess: "rw",
      hwaccess: "hrw",
      hwext:    "true",
      hwqe:     "true", // enable `qe` latched signal of software write pulse
      hwre:     "true",
      fields: [
        { bits: "5-1:0",
          name: "CL_TAG",
          desc: "Tag Address"
        }
      ]
    },
    {
      name:     "STATUS_498",
      desc:     "Status register of cache line 498",
      swaccess: "rw",
      hwaccess: "hrw",
      hwext:    "true",
      hwqe:     "true", // enable `qe` latched signal of software write pulse
      hwre:     "true",
      fields: [
        {
          bits: "5+3:5", // 2 bits for status
          name: "CL_STATUS",
          desc: "Contain the current status of the corresponding cache line                [0]: valid, [1]: dirty, [2]: cmpt",
        }
      ]
    },
    { name:     "TAG_498",
      desc:     "Tag Address stored in cache line 498",
      swaccess: "rw",
      hwaccess: "hrw",
      hwext:    "true",
      hwqe:     "true", // enable `qe` latched signal of software write pulse
      hwre:     "true",
      fields: [
        { bits: "5-1:0",
          name: "CL_TAG",
          desc: "Tag Address"
        }
      ]
    },
    {
      name:     "STATUS_499",
      desc:     "Status register of cache line 499",
      swaccess: "rw",
      hwaccess: "hrw",
      hwext:    "true",
      hwqe:     "true", // enable `qe` latched signal of software write pulse
      hwre:     "true",
      fields: [
        {
          bits: "5+3:5", // 2 bits for status
          name: "CL_STATUS",
          desc: "Contain the current status of the corresponding cache line                [0]: valid, [1]: dirty, [2]: cmpt",
        }
      ]
    },
    { name:     "TAG_499",
      desc:     "Tag Address stored in cache line 499",
      swaccess: "rw",
      hwaccess: "hrw",
      hwext:    "true",
      hwqe:     "true", // enable `qe` latched signal of software write pulse
      hwre:     "true",
      fields: [
        { bits: "5-1:0",
          name: "CL_TAG",
          desc: "Tag Address"
        }
      ]
    },
    {
      name:     "STATUS_500",
      desc:     "Status register of cache line 500",
      swaccess: "rw",
      hwaccess: "hrw",
      hwext:    "true",
      hwqe:     "true", // enable `qe` latched signal of software write pulse
      hwre:     "true",
      fields: [
        {
          bits: "5+3:5", // 2 bits for status
          name: "CL_STATUS",
          desc: "Contain the current status of the corresponding cache line                [0]: valid, [1]: dirty, [2]: cmpt",
        }
      ]
    },
    { name:     "TAG_500",
      desc:     "Tag Address stored in cache line 500",
      swaccess: "rw",
      hwaccess: "hrw",
      hwext:    "true",
      hwqe:     "true", // enable `qe` latched signal of software write pulse
      hwre:     "true",
      fields: [
        { bits: "5-1:0",
          name: "CL_TAG",
          desc: "Tag Address"
        }
      ]
    },
    {
      name:     "STATUS_501",
      desc:     "Status register of cache line 501",
      swaccess: "rw",
      hwaccess: "hrw",
      hwext:    "true",
      hwqe:     "true", // enable `qe` latched signal of software write pulse
      hwre:     "true",
      fields: [
        {
          bits: "5+3:5", // 2 bits for status
          name: "CL_STATUS",
          desc: "Contain the current status of the corresponding cache line                [0]: valid, [1]: dirty, [2]: cmpt",
        }
      ]
    },
    { name:     "TAG_501",
      desc:     "Tag Address stored in cache line 501",
      swaccess: "rw",
      hwaccess: "hrw",
      hwext:    "true",
      hwqe:     "true", // enable `qe` latched signal of software write pulse
      hwre:     "true",
      fields: [
        { bits: "5-1:0",
          name: "CL_TAG",
          desc: "Tag Address"
        }
      ]
    },
    {
      name:     "STATUS_502",
      desc:     "Status register of cache line 502",
      swaccess: "rw",
      hwaccess: "hrw",
      hwext:    "true",
      hwqe:     "true", // enable `qe` latched signal of software write pulse
      hwre:     "true",
      fields: [
        {
          bits: "5+3:5", // 2 bits for status
          name: "CL_STATUS",
          desc: "Contain the current status of the corresponding cache line                [0]: valid, [1]: dirty, [2]: cmpt",
        }
      ]
    },
    { name:     "TAG_502",
      desc:     "Tag Address stored in cache line 502",
      swaccess: "rw",
      hwaccess: "hrw",
      hwext:    "true",
      hwqe:     "true", // enable `qe` latched signal of software write pulse
      hwre:     "true",
      fields: [
        { bits: "5-1:0",
          name: "CL_TAG",
          desc: "Tag Address"
        }
      ]
    },
    {
      name:     "STATUS_503",
      desc:     "Status register of cache line 503",
      swaccess: "rw",
      hwaccess: "hrw",
      hwext:    "true",
      hwqe:     "true", // enable `qe` latched signal of software write pulse
      hwre:     "true",
      fields: [
        {
          bits: "5+3:5", // 2 bits for status
          name: "CL_STATUS",
          desc: "Contain the current status of the corresponding cache line                [0]: valid, [1]: dirty, [2]: cmpt",
        }
      ]
    },
    { name:     "TAG_503",
      desc:     "Tag Address stored in cache line 503",
      swaccess: "rw",
      hwaccess: "hrw",
      hwext:    "true",
      hwqe:     "true", // enable `qe` latched signal of software write pulse
      hwre:     "true",
      fields: [
        { bits: "5-1:0",
          name: "CL_TAG",
          desc: "Tag Address"
        }
      ]
    },
    {
      name:     "STATUS_504",
      desc:     "Status register of cache line 504",
      swaccess: "rw",
      hwaccess: "hrw",
      hwext:    "true",
      hwqe:     "true", // enable `qe` latched signal of software write pulse
      hwre:     "true",
      fields: [
        {
          bits: "5+3:5", // 2 bits for status
          name: "CL_STATUS",
          desc: "Contain the current status of the corresponding cache line                [0]: valid, [1]: dirty, [2]: cmpt",
        }
      ]
    },
    { name:     "TAG_504",
      desc:     "Tag Address stored in cache line 504",
      swaccess: "rw",
      hwaccess: "hrw",
      hwext:    "true",
      hwqe:     "true", // enable `qe` latched signal of software write pulse
      hwre:     "true",
      fields: [
        { bits: "5-1:0",
          name: "CL_TAG",
          desc: "Tag Address"
        }
      ]
    },
    {
      name:     "STATUS_505",
      desc:     "Status register of cache line 505",
      swaccess: "rw",
      hwaccess: "hrw",
      hwext:    "true",
      hwqe:     "true", // enable `qe` latched signal of software write pulse
      hwre:     "true",
      fields: [
        {
          bits: "5+3:5", // 2 bits for status
          name: "CL_STATUS",
          desc: "Contain the current status of the corresponding cache line                [0]: valid, [1]: dirty, [2]: cmpt",
        }
      ]
    },
    { name:     "TAG_505",
      desc:     "Tag Address stored in cache line 505",
      swaccess: "rw",
      hwaccess: "hrw",
      hwext:    "true",
      hwqe:     "true", // enable `qe` latched signal of software write pulse
      hwre:     "true",
      fields: [
        { bits: "5-1:0",
          name: "CL_TAG",
          desc: "Tag Address"
        }
      ]
    },
    {
      name:     "STATUS_506",
      desc:     "Status register of cache line 506",
      swaccess: "rw",
      hwaccess: "hrw",
      hwext:    "true",
      hwqe:     "true", // enable `qe` latched signal of software write pulse
      hwre:     "true",
      fields: [
        {
          bits: "5+3:5", // 2 bits for status
          name: "CL_STATUS",
          desc: "Contain the current status of the corresponding cache line                [0]: valid, [1]: dirty, [2]: cmpt",
        }
      ]
    },
    { name:     "TAG_506",
      desc:     "Tag Address stored in cache line 506",
      swaccess: "rw",
      hwaccess: "hrw",
      hwext:    "true",
      hwqe:     "true", // enable `qe` latched signal of software write pulse
      hwre:     "true",
      fields: [
        { bits: "5-1:0",
          name: "CL_TAG",
          desc: "Tag Address"
        }
      ]
    },
    {
      name:     "STATUS_507",
      desc:     "Status register of cache line 507",
      swaccess: "rw",
      hwaccess: "hrw",
      hwext:    "true",
      hwqe:     "true", // enable `qe` latched signal of software write pulse
      hwre:     "true",
      fields: [
        {
          bits: "5+3:5", // 2 bits for status
          name: "CL_STATUS",
          desc: "Contain the current status of the corresponding cache line                [0]: valid, [1]: dirty, [2]: cmpt",
        }
      ]
    },
    { name:     "TAG_507",
      desc:     "Tag Address stored in cache line 507",
      swaccess: "rw",
      hwaccess: "hrw",
      hwext:    "true",
      hwqe:     "true", // enable `qe` latched signal of software write pulse
      hwre:     "true",
      fields: [
        { bits: "5-1:0",
          name: "CL_TAG",
          desc: "Tag Address"
        }
      ]
    },
    {
      name:     "STATUS_508",
      desc:     "Status register of cache line 508",
      swaccess: "rw",
      hwaccess: "hrw",
      hwext:    "true",
      hwqe:     "true", // enable `qe` latched signal of software write pulse
      hwre:     "true",
      fields: [
        {
          bits: "5+3:5", // 2 bits for status
          name: "CL_STATUS",
          desc: "Contain the current status of the corresponding cache line                [0]: valid, [1]: dirty, [2]: cmpt",
        }
      ]
    },
    { name:     "TAG_508",
      desc:     "Tag Address stored in cache line 508",
      swaccess: "rw",
      hwaccess: "hrw",
      hwext:    "true",
      hwqe:     "true", // enable `qe` latched signal of software write pulse
      hwre:     "true",
      fields: [
        { bits: "5-1:0",
          name: "CL_TAG",
          desc: "Tag Address"
        }
      ]
    },
    {
      name:     "STATUS_509",
      desc:     "Status register of cache line 509",
      swaccess: "rw",
      hwaccess: "hrw",
      hwext:    "true",
      hwqe:     "true", // enable `qe` latched signal of software write pulse
      hwre:     "true",
      fields: [
        {
          bits: "5+3:5", // 2 bits for status
          name: "CL_STATUS",
          desc: "Contain the current status of the corresponding cache line                [0]: valid, [1]: dirty, [2]: cmpt",
        }
      ]
    },
    { name:     "TAG_509",
      desc:     "Tag Address stored in cache line 509",
      swaccess: "rw",
      hwaccess: "hrw",
      hwext:    "true",
      hwqe:     "true", // enable `qe` latched signal of software write pulse
      hwre:     "true",
      fields: [
        { bits: "5-1:0",
          name: "CL_TAG",
          desc: "Tag Address"
        }
      ]
    },
    {
      name:     "STATUS_510",
      desc:     "Status register of cache line 510",
      swaccess: "rw",
      hwaccess: "hrw",
      hwext:    "true",
      hwqe:     "true", // enable `qe` latched signal of software write pulse
      hwre:     "true",
      fields: [
        {
          bits: "5+3:5", // 2 bits for status
          name: "CL_STATUS",
          desc: "Contain the current status of the corresponding cache line                [0]: valid, [1]: dirty, [2]: cmpt",
        }
      ]
    },
    { name:     "TAG_510",
      desc:     "Tag Address stored in cache line 510",
      swaccess: "rw",
      hwaccess: "hrw",
      hwext:    "true",
      hwqe:     "true", // enable `qe` latched signal of software write pulse
      hwre:     "true",
      fields: [
        { bits: "5-1:0",
          name: "CL_TAG",
          desc: "Tag Address"
        }
      ]
    },
    {
      name:     "STATUS_511",
      desc:     "Status register of cache line 511",
      swaccess: "rw",
      hwaccess: "hrw",
      hwext:    "true",
      hwqe:     "true", // enable `qe` latched signal of software write pulse
      hwre:     "true",
      fields: [
        {
          bits: "5+3:5", // 2 bits for status
          name: "CL_STATUS",
          desc: "Contain the current status of the corresponding cache line                [0]: valid, [1]: dirty, [2]: cmpt",
        }
      ]
    },
    { name:     "TAG_511",
      desc:     "Tag Address stored in cache line 511",
      swaccess: "rw",
      hwaccess: "hrw",
      hwext:    "true",
      hwqe:     "true", // enable `qe` latched signal of software write pulse
      hwre:     "true",
      fields: [
        { bits: "5-1:0",
          name: "CL_TAG",
          desc: "Tag Address"
        }
      ]
    },
    {
      name:     "STATUS_512",
      desc:     "Status register of cache line 512",
      swaccess: "rw",
      hwaccess: "hrw",
      hwext:    "true",
      hwqe:     "true", // enable `qe` latched signal of software write pulse
      hwre:     "true",
      fields: [
        {
          bits: "5+3:5", // 2 bits for status
          name: "CL_STATUS",
          desc: "Contain the current status of the corresponding cache line                [0]: valid, [1]: dirty, [2]: cmpt",
        }
      ]
    },
    { name:     "TAG_512",
      desc:     "Tag Address stored in cache line 512",
      swaccess: "rw",
      hwaccess: "hrw",
      hwext:    "true",
      hwqe:     "true", // enable `qe` latched signal of software write pulse
      hwre:     "true",
      fields: [
        { bits: "5-1:0",
          name: "CL_TAG",
          desc: "Tag Address"
        }
      ]
    },
    {
      name:     "STATUS_513",
      desc:     "Status register of cache line 513",
      swaccess: "rw",
      hwaccess: "hrw",
      hwext:    "true",
      hwqe:     "true", // enable `qe` latched signal of software write pulse
      hwre:     "true",
      fields: [
        {
          bits: "5+3:5", // 2 bits for status
          name: "CL_STATUS",
          desc: "Contain the current status of the corresponding cache line                [0]: valid, [1]: dirty, [2]: cmpt",
        }
      ]
    },
    { name:     "TAG_513",
      desc:     "Tag Address stored in cache line 513",
      swaccess: "rw",
      hwaccess: "hrw",
      hwext:    "true",
      hwqe:     "true", // enable `qe` latched signal of software write pulse
      hwre:     "true",
      fields: [
        { bits: "5-1:0",
          name: "CL_TAG",
          desc: "Tag Address"
        }
      ]
    },
    {
      name:     "STATUS_514",
      desc:     "Status register of cache line 514",
      swaccess: "rw",
      hwaccess: "hrw",
      hwext:    "true",
      hwqe:     "true", // enable `qe` latched signal of software write pulse
      hwre:     "true",
      fields: [
        {
          bits: "5+3:5", // 2 bits for status
          name: "CL_STATUS",
          desc: "Contain the current status of the corresponding cache line                [0]: valid, [1]: dirty, [2]: cmpt",
        }
      ]
    },
    { name:     "TAG_514",
      desc:     "Tag Address stored in cache line 514",
      swaccess: "rw",
      hwaccess: "hrw",
      hwext:    "true",
      hwqe:     "true", // enable `qe` latched signal of software write pulse
      hwre:     "true",
      fields: [
        { bits: "5-1:0",
          name: "CL_TAG",
          desc: "Tag Address"
        }
      ]
    },
    {
      name:     "STATUS_515",
      desc:     "Status register of cache line 515",
      swaccess: "rw",
      hwaccess: "hrw",
      hwext:    "true",
      hwqe:     "true", // enable `qe` latched signal of software write pulse
      hwre:     "true",
      fields: [
        {
          bits: "5+3:5", // 2 bits for status
          name: "CL_STATUS",
          desc: "Contain the current status of the corresponding cache line                [0]: valid, [1]: dirty, [2]: cmpt",
        }
      ]
    },
    { name:     "TAG_515",
      desc:     "Tag Address stored in cache line 515",
      swaccess: "rw",
      hwaccess: "hrw",
      hwext:    "true",
      hwqe:     "true", // enable `qe` latched signal of software write pulse
      hwre:     "true",
      fields: [
        { bits: "5-1:0",
          name: "CL_TAG",
          desc: "Tag Address"
        }
      ]
    },
    {
      name:     "STATUS_516",
      desc:     "Status register of cache line 516",
      swaccess: "rw",
      hwaccess: "hrw",
      hwext:    "true",
      hwqe:     "true", // enable `qe` latched signal of software write pulse
      hwre:     "true",
      fields: [
        {
          bits: "5+3:5", // 2 bits for status
          name: "CL_STATUS",
          desc: "Contain the current status of the corresponding cache line                [0]: valid, [1]: dirty, [2]: cmpt",
        }
      ]
    },
    { name:     "TAG_516",
      desc:     "Tag Address stored in cache line 516",
      swaccess: "rw",
      hwaccess: "hrw",
      hwext:    "true",
      hwqe:     "true", // enable `qe` latched signal of software write pulse
      hwre:     "true",
      fields: [
        { bits: "5-1:0",
          name: "CL_TAG",
          desc: "Tag Address"
        }
      ]
    },
    {
      name:     "STATUS_517",
      desc:     "Status register of cache line 517",
      swaccess: "rw",
      hwaccess: "hrw",
      hwext:    "true",
      hwqe:     "true", // enable `qe` latched signal of software write pulse
      hwre:     "true",
      fields: [
        {
          bits: "5+3:5", // 2 bits for status
          name: "CL_STATUS",
          desc: "Contain the current status of the corresponding cache line                [0]: valid, [1]: dirty, [2]: cmpt",
        }
      ]
    },
    { name:     "TAG_517",
      desc:     "Tag Address stored in cache line 517",
      swaccess: "rw",
      hwaccess: "hrw",
      hwext:    "true",
      hwqe:     "true", // enable `qe` latched signal of software write pulse
      hwre:     "true",
      fields: [
        { bits: "5-1:0",
          name: "CL_TAG",
          desc: "Tag Address"
        }
      ]
    },
    {
      name:     "STATUS_518",
      desc:     "Status register of cache line 518",
      swaccess: "rw",
      hwaccess: "hrw",
      hwext:    "true",
      hwqe:     "true", // enable `qe` latched signal of software write pulse
      hwre:     "true",
      fields: [
        {
          bits: "5+3:5", // 2 bits for status
          name: "CL_STATUS",
          desc: "Contain the current status of the corresponding cache line                [0]: valid, [1]: dirty, [2]: cmpt",
        }
      ]
    },
    { name:     "TAG_518",
      desc:     "Tag Address stored in cache line 518",
      swaccess: "rw",
      hwaccess: "hrw",
      hwext:    "true",
      hwqe:     "true", // enable `qe` latched signal of software write pulse
      hwre:     "true",
      fields: [
        { bits: "5-1:0",
          name: "CL_TAG",
          desc: "Tag Address"
        }
      ]
    },
    {
      name:     "STATUS_519",
      desc:     "Status register of cache line 519",
      swaccess: "rw",
      hwaccess: "hrw",
      hwext:    "true",
      hwqe:     "true", // enable `qe` latched signal of software write pulse
      hwre:     "true",
      fields: [
        {
          bits: "5+3:5", // 2 bits for status
          name: "CL_STATUS",
          desc: "Contain the current status of the corresponding cache line                [0]: valid, [1]: dirty, [2]: cmpt",
        }
      ]
    },
    { name:     "TAG_519",
      desc:     "Tag Address stored in cache line 519",
      swaccess: "rw",
      hwaccess: "hrw",
      hwext:    "true",
      hwqe:     "true", // enable `qe` latched signal of software write pulse
      hwre:     "true",
      fields: [
        { bits: "5-1:0",
          name: "CL_TAG",
          desc: "Tag Address"
        }
      ]
    },
    {
      name:     "STATUS_520",
      desc:     "Status register of cache line 520",
      swaccess: "rw",
      hwaccess: "hrw",
      hwext:    "true",
      hwqe:     "true", // enable `qe` latched signal of software write pulse
      hwre:     "true",
      fields: [
        {
          bits: "5+3:5", // 2 bits for status
          name: "CL_STATUS",
          desc: "Contain the current status of the corresponding cache line                [0]: valid, [1]: dirty, [2]: cmpt",
        }
      ]
    },
    { name:     "TAG_520",
      desc:     "Tag Address stored in cache line 520",
      swaccess: "rw",
      hwaccess: "hrw",
      hwext:    "true",
      hwqe:     "true", // enable `qe` latched signal of software write pulse
      hwre:     "true",
      fields: [
        { bits: "5-1:0",
          name: "CL_TAG",
          desc: "Tag Address"
        }
      ]
    },
    {
      name:     "STATUS_521",
      desc:     "Status register of cache line 521",
      swaccess: "rw",
      hwaccess: "hrw",
      hwext:    "true",
      hwqe:     "true", // enable `qe` latched signal of software write pulse
      hwre:     "true",
      fields: [
        {
          bits: "5+3:5", // 2 bits for status
          name: "CL_STATUS",
          desc: "Contain the current status of the corresponding cache line                [0]: valid, [1]: dirty, [2]: cmpt",
        }
      ]
    },
    { name:     "TAG_521",
      desc:     "Tag Address stored in cache line 521",
      swaccess: "rw",
      hwaccess: "hrw",
      hwext:    "true",
      hwqe:     "true", // enable `qe` latched signal of software write pulse
      hwre:     "true",
      fields: [
        { bits: "5-1:0",
          name: "CL_TAG",
          desc: "Tag Address"
        }
      ]
    },
    {
      name:     "STATUS_522",
      desc:     "Status register of cache line 522",
      swaccess: "rw",
      hwaccess: "hrw",
      hwext:    "true",
      hwqe:     "true", // enable `qe` latched signal of software write pulse
      hwre:     "true",
      fields: [
        {
          bits: "5+3:5", // 2 bits for status
          name: "CL_STATUS",
          desc: "Contain the current status of the corresponding cache line                [0]: valid, [1]: dirty, [2]: cmpt",
        }
      ]
    },
    { name:     "TAG_522",
      desc:     "Tag Address stored in cache line 522",
      swaccess: "rw",
      hwaccess: "hrw",
      hwext:    "true",
      hwqe:     "true", // enable `qe` latched signal of software write pulse
      hwre:     "true",
      fields: [
        { bits: "5-1:0",
          name: "CL_TAG",
          desc: "Tag Address"
        }
      ]
    },
    {
      name:     "STATUS_523",
      desc:     "Status register of cache line 523",
      swaccess: "rw",
      hwaccess: "hrw",
      hwext:    "true",
      hwqe:     "true", // enable `qe` latched signal of software write pulse
      hwre:     "true",
      fields: [
        {
          bits: "5+3:5", // 2 bits for status
          name: "CL_STATUS",
          desc: "Contain the current status of the corresponding cache line                [0]: valid, [1]: dirty, [2]: cmpt",
        }
      ]
    },
    { name:     "TAG_523",
      desc:     "Tag Address stored in cache line 523",
      swaccess: "rw",
      hwaccess: "hrw",
      hwext:    "true",
      hwqe:     "true", // enable `qe` latched signal of software write pulse
      hwre:     "true",
      fields: [
        { bits: "5-1:0",
          name: "CL_TAG",
          desc: "Tag Address"
        }
      ]
    },
    {
      name:     "STATUS_524",
      desc:     "Status register of cache line 524",
      swaccess: "rw",
      hwaccess: "hrw",
      hwext:    "true",
      hwqe:     "true", // enable `qe` latched signal of software write pulse
      hwre:     "true",
      fields: [
        {
          bits: "5+3:5", // 2 bits for status
          name: "CL_STATUS",
          desc: "Contain the current status of the corresponding cache line                [0]: valid, [1]: dirty, [2]: cmpt",
        }
      ]
    },
    { name:     "TAG_524",
      desc:     "Tag Address stored in cache line 524",
      swaccess: "rw",
      hwaccess: "hrw",
      hwext:    "true",
      hwqe:     "true", // enable `qe` latched signal of software write pulse
      hwre:     "true",
      fields: [
        { bits: "5-1:0",
          name: "CL_TAG",
          desc: "Tag Address"
        }
      ]
    },
    {
      name:     "STATUS_525",
      desc:     "Status register of cache line 525",
      swaccess: "rw",
      hwaccess: "hrw",
      hwext:    "true",
      hwqe:     "true", // enable `qe` latched signal of software write pulse
      hwre:     "true",
      fields: [
        {
          bits: "5+3:5", // 2 bits for status
          name: "CL_STATUS",
          desc: "Contain the current status of the corresponding cache line                [0]: valid, [1]: dirty, [2]: cmpt",
        }
      ]
    },
    { name:     "TAG_525",
      desc:     "Tag Address stored in cache line 525",
      swaccess: "rw",
      hwaccess: "hrw",
      hwext:    "true",
      hwqe:     "true", // enable `qe` latched signal of software write pulse
      hwre:     "true",
      fields: [
        { bits: "5-1:0",
          name: "CL_TAG",
          desc: "Tag Address"
        }
      ]
    },
    {
      name:     "STATUS_526",
      desc:     "Status register of cache line 526",
      swaccess: "rw",
      hwaccess: "hrw",
      hwext:    "true",
      hwqe:     "true", // enable `qe` latched signal of software write pulse
      hwre:     "true",
      fields: [
        {
          bits: "5+3:5", // 2 bits for status
          name: "CL_STATUS",
          desc: "Contain the current status of the corresponding cache line                [0]: valid, [1]: dirty, [2]: cmpt",
        }
      ]
    },
    { name:     "TAG_526",
      desc:     "Tag Address stored in cache line 526",
      swaccess: "rw",
      hwaccess: "hrw",
      hwext:    "true",
      hwqe:     "true", // enable `qe` latched signal of software write pulse
      hwre:     "true",
      fields: [
        { bits: "5-1:0",
          name: "CL_TAG",
          desc: "Tag Address"
        }
      ]
    },
    {
      name:     "STATUS_527",
      desc:     "Status register of cache line 527",
      swaccess: "rw",
      hwaccess: "hrw",
      hwext:    "true",
      hwqe:     "true", // enable `qe` latched signal of software write pulse
      hwre:     "true",
      fields: [
        {
          bits: "5+3:5", // 2 bits for status
          name: "CL_STATUS",
          desc: "Contain the current status of the corresponding cache line                [0]: valid, [1]: dirty, [2]: cmpt",
        }
      ]
    },
    { name:     "TAG_527",
      desc:     "Tag Address stored in cache line 527",
      swaccess: "rw",
      hwaccess: "hrw",
      hwext:    "true",
      hwqe:     "true", // enable `qe` latched signal of software write pulse
      hwre:     "true",
      fields: [
        { bits: "5-1:0",
          name: "CL_TAG",
          desc: "Tag Address"
        }
      ]
    },
    {
      name:     "STATUS_528",
      desc:     "Status register of cache line 528",
      swaccess: "rw",
      hwaccess: "hrw",
      hwext:    "true",
      hwqe:     "true", // enable `qe` latched signal of software write pulse
      hwre:     "true",
      fields: [
        {
          bits: "5+3:5", // 2 bits for status
          name: "CL_STATUS",
          desc: "Contain the current status of the corresponding cache line                [0]: valid, [1]: dirty, [2]: cmpt",
        }
      ]
    },
    { name:     "TAG_528",
      desc:     "Tag Address stored in cache line 528",
      swaccess: "rw",
      hwaccess: "hrw",
      hwext:    "true",
      hwqe:     "true", // enable `qe` latched signal of software write pulse
      hwre:     "true",
      fields: [
        { bits: "5-1:0",
          name: "CL_TAG",
          desc: "Tag Address"
        }
      ]
    },
    {
      name:     "STATUS_529",
      desc:     "Status register of cache line 529",
      swaccess: "rw",
      hwaccess: "hrw",
      hwext:    "true",
      hwqe:     "true", // enable `qe` latched signal of software write pulse
      hwre:     "true",
      fields: [
        {
          bits: "5+3:5", // 2 bits for status
          name: "CL_STATUS",
          desc: "Contain the current status of the corresponding cache line                [0]: valid, [1]: dirty, [2]: cmpt",
        }
      ]
    },
    { name:     "TAG_529",
      desc:     "Tag Address stored in cache line 529",
      swaccess: "rw",
      hwaccess: "hrw",
      hwext:    "true",
      hwqe:     "true", // enable `qe` latched signal of software write pulse
      hwre:     "true",
      fields: [
        { bits: "5-1:0",
          name: "CL_TAG",
          desc: "Tag Address"
        }
      ]
    },
    {
      name:     "STATUS_530",
      desc:     "Status register of cache line 530",
      swaccess: "rw",
      hwaccess: "hrw",
      hwext:    "true",
      hwqe:     "true", // enable `qe` latched signal of software write pulse
      hwre:     "true",
      fields: [
        {
          bits: "5+3:5", // 2 bits for status
          name: "CL_STATUS",
          desc: "Contain the current status of the corresponding cache line                [0]: valid, [1]: dirty, [2]: cmpt",
        }
      ]
    },
    { name:     "TAG_530",
      desc:     "Tag Address stored in cache line 530",
      swaccess: "rw",
      hwaccess: "hrw",
      hwext:    "true",
      hwqe:     "true", // enable `qe` latched signal of software write pulse
      hwre:     "true",
      fields: [
        { bits: "5-1:0",
          name: "CL_TAG",
          desc: "Tag Address"
        }
      ]
    },
    {
      name:     "STATUS_531",
      desc:     "Status register of cache line 531",
      swaccess: "rw",
      hwaccess: "hrw",
      hwext:    "true",
      hwqe:     "true", // enable `qe` latched signal of software write pulse
      hwre:     "true",
      fields: [
        {
          bits: "5+3:5", // 2 bits for status
          name: "CL_STATUS",
          desc: "Contain the current status of the corresponding cache line                [0]: valid, [1]: dirty, [2]: cmpt",
        }
      ]
    },
    { name:     "TAG_531",
      desc:     "Tag Address stored in cache line 531",
      swaccess: "rw",
      hwaccess: "hrw",
      hwext:    "true",
      hwqe:     "true", // enable `qe` latched signal of software write pulse
      hwre:     "true",
      fields: [
        { bits: "5-1:0",
          name: "CL_TAG",
          desc: "Tag Address"
        }
      ]
    },
    {
      name:     "STATUS_532",
      desc:     "Status register of cache line 532",
      swaccess: "rw",
      hwaccess: "hrw",
      hwext:    "true",
      hwqe:     "true", // enable `qe` latched signal of software write pulse
      hwre:     "true",
      fields: [
        {
          bits: "5+3:5", // 2 bits for status
          name: "CL_STATUS",
          desc: "Contain the current status of the corresponding cache line                [0]: valid, [1]: dirty, [2]: cmpt",
        }
      ]
    },
    { name:     "TAG_532",
      desc:     "Tag Address stored in cache line 532",
      swaccess: "rw",
      hwaccess: "hrw",
      hwext:    "true",
      hwqe:     "true", // enable `qe` latched signal of software write pulse
      hwre:     "true",
      fields: [
        { bits: "5-1:0",
          name: "CL_TAG",
          desc: "Tag Address"
        }
      ]
    },
    {
      name:     "STATUS_533",
      desc:     "Status register of cache line 533",
      swaccess: "rw",
      hwaccess: "hrw",
      hwext:    "true",
      hwqe:     "true", // enable `qe` latched signal of software write pulse
      hwre:     "true",
      fields: [
        {
          bits: "5+3:5", // 2 bits for status
          name: "CL_STATUS",
          desc: "Contain the current status of the corresponding cache line                [0]: valid, [1]: dirty, [2]: cmpt",
        }
      ]
    },
    { name:     "TAG_533",
      desc:     "Tag Address stored in cache line 533",
      swaccess: "rw",
      hwaccess: "hrw",
      hwext:    "true",
      hwqe:     "true", // enable `qe` latched signal of software write pulse
      hwre:     "true",
      fields: [
        { bits: "5-1:0",
          name: "CL_TAG",
          desc: "Tag Address"
        }
      ]
    },
    {
      name:     "STATUS_534",
      desc:     "Status register of cache line 534",
      swaccess: "rw",
      hwaccess: "hrw",
      hwext:    "true",
      hwqe:     "true", // enable `qe` latched signal of software write pulse
      hwre:     "true",
      fields: [
        {
          bits: "5+3:5", // 2 bits for status
          name: "CL_STATUS",
          desc: "Contain the current status of the corresponding cache line                [0]: valid, [1]: dirty, [2]: cmpt",
        }
      ]
    },
    { name:     "TAG_534",
      desc:     "Tag Address stored in cache line 534",
      swaccess: "rw",
      hwaccess: "hrw",
      hwext:    "true",
      hwqe:     "true", // enable `qe` latched signal of software write pulse
      hwre:     "true",
      fields: [
        { bits: "5-1:0",
          name: "CL_TAG",
          desc: "Tag Address"
        }
      ]
    },
    {
      name:     "STATUS_535",
      desc:     "Status register of cache line 535",
      swaccess: "rw",
      hwaccess: "hrw",
      hwext:    "true",
      hwqe:     "true", // enable `qe` latched signal of software write pulse
      hwre:     "true",
      fields: [
        {
          bits: "5+3:5", // 2 bits for status
          name: "CL_STATUS",
          desc: "Contain the current status of the corresponding cache line                [0]: valid, [1]: dirty, [2]: cmpt",
        }
      ]
    },
    { name:     "TAG_535",
      desc:     "Tag Address stored in cache line 535",
      swaccess: "rw",
      hwaccess: "hrw",
      hwext:    "true",
      hwqe:     "true", // enable `qe` latched signal of software write pulse
      hwre:     "true",
      fields: [
        { bits: "5-1:0",
          name: "CL_TAG",
          desc: "Tag Address"
        }
      ]
    },
    {
      name:     "STATUS_536",
      desc:     "Status register of cache line 536",
      swaccess: "rw",
      hwaccess: "hrw",
      hwext:    "true",
      hwqe:     "true", // enable `qe` latched signal of software write pulse
      hwre:     "true",
      fields: [
        {
          bits: "5+3:5", // 2 bits for status
          name: "CL_STATUS",
          desc: "Contain the current status of the corresponding cache line                [0]: valid, [1]: dirty, [2]: cmpt",
        }
      ]
    },
    { name:     "TAG_536",
      desc:     "Tag Address stored in cache line 536",
      swaccess: "rw",
      hwaccess: "hrw",
      hwext:    "true",
      hwqe:     "true", // enable `qe` latched signal of software write pulse
      hwre:     "true",
      fields: [
        { bits: "5-1:0",
          name: "CL_TAG",
          desc: "Tag Address"
        }
      ]
    },
    {
      name:     "STATUS_537",
      desc:     "Status register of cache line 537",
      swaccess: "rw",
      hwaccess: "hrw",
      hwext:    "true",
      hwqe:     "true", // enable `qe` latched signal of software write pulse
      hwre:     "true",
      fields: [
        {
          bits: "5+3:5", // 2 bits for status
          name: "CL_STATUS",
          desc: "Contain the current status of the corresponding cache line                [0]: valid, [1]: dirty, [2]: cmpt",
        }
      ]
    },
    { name:     "TAG_537",
      desc:     "Tag Address stored in cache line 537",
      swaccess: "rw",
      hwaccess: "hrw",
      hwext:    "true",
      hwqe:     "true", // enable `qe` latched signal of software write pulse
      hwre:     "true",
      fields: [
        { bits: "5-1:0",
          name: "CL_TAG",
          desc: "Tag Address"
        }
      ]
    },
    {
      name:     "STATUS_538",
      desc:     "Status register of cache line 538",
      swaccess: "rw",
      hwaccess: "hrw",
      hwext:    "true",
      hwqe:     "true", // enable `qe` latched signal of software write pulse
      hwre:     "true",
      fields: [
        {
          bits: "5+3:5", // 2 bits for status
          name: "CL_STATUS",
          desc: "Contain the current status of the corresponding cache line                [0]: valid, [1]: dirty, [2]: cmpt",
        }
      ]
    },
    { name:     "TAG_538",
      desc:     "Tag Address stored in cache line 538",
      swaccess: "rw",
      hwaccess: "hrw",
      hwext:    "true",
      hwqe:     "true", // enable `qe` latched signal of software write pulse
      hwre:     "true",
      fields: [
        { bits: "5-1:0",
          name: "CL_TAG",
          desc: "Tag Address"
        }
      ]
    },
    {
      name:     "STATUS_539",
      desc:     "Status register of cache line 539",
      swaccess: "rw",
      hwaccess: "hrw",
      hwext:    "true",
      hwqe:     "true", // enable `qe` latched signal of software write pulse
      hwre:     "true",
      fields: [
        {
          bits: "5+3:5", // 2 bits for status
          name: "CL_STATUS",
          desc: "Contain the current status of the corresponding cache line                [0]: valid, [1]: dirty, [2]: cmpt",
        }
      ]
    },
    { name:     "TAG_539",
      desc:     "Tag Address stored in cache line 539",
      swaccess: "rw",
      hwaccess: "hrw",
      hwext:    "true",
      hwqe:     "true", // enable `qe` latched signal of software write pulse
      hwre:     "true",
      fields: [
        { bits: "5-1:0",
          name: "CL_TAG",
          desc: "Tag Address"
        }
      ]
    },
    {
      name:     "STATUS_540",
      desc:     "Status register of cache line 540",
      swaccess: "rw",
      hwaccess: "hrw",
      hwext:    "true",
      hwqe:     "true", // enable `qe` latched signal of software write pulse
      hwre:     "true",
      fields: [
        {
          bits: "5+3:5", // 2 bits for status
          name: "CL_STATUS",
          desc: "Contain the current status of the corresponding cache line                [0]: valid, [1]: dirty, [2]: cmpt",
        }
      ]
    },
    { name:     "TAG_540",
      desc:     "Tag Address stored in cache line 540",
      swaccess: "rw",
      hwaccess: "hrw",
      hwext:    "true",
      hwqe:     "true", // enable `qe` latched signal of software write pulse
      hwre:     "true",
      fields: [
        { bits: "5-1:0",
          name: "CL_TAG",
          desc: "Tag Address"
        }
      ]
    },
    {
      name:     "STATUS_541",
      desc:     "Status register of cache line 541",
      swaccess: "rw",
      hwaccess: "hrw",
      hwext:    "true",
      hwqe:     "true", // enable `qe` latched signal of software write pulse
      hwre:     "true",
      fields: [
        {
          bits: "5+3:5", // 2 bits for status
          name: "CL_STATUS",
          desc: "Contain the current status of the corresponding cache line                [0]: valid, [1]: dirty, [2]: cmpt",
        }
      ]
    },
    { name:     "TAG_541",
      desc:     "Tag Address stored in cache line 541",
      swaccess: "rw",
      hwaccess: "hrw",
      hwext:    "true",
      hwqe:     "true", // enable `qe` latched signal of software write pulse
      hwre:     "true",
      fields: [
        { bits: "5-1:0",
          name: "CL_TAG",
          desc: "Tag Address"
        }
      ]
    },
    {
      name:     "STATUS_542",
      desc:     "Status register of cache line 542",
      swaccess: "rw",
      hwaccess: "hrw",
      hwext:    "true",
      hwqe:     "true", // enable `qe` latched signal of software write pulse
      hwre:     "true",
      fields: [
        {
          bits: "5+3:5", // 2 bits for status
          name: "CL_STATUS",
          desc: "Contain the current status of the corresponding cache line                [0]: valid, [1]: dirty, [2]: cmpt",
        }
      ]
    },
    { name:     "TAG_542",
      desc:     "Tag Address stored in cache line 542",
      swaccess: "rw",
      hwaccess: "hrw",
      hwext:    "true",
      hwqe:     "true", // enable `qe` latched signal of software write pulse
      hwre:     "true",
      fields: [
        { bits: "5-1:0",
          name: "CL_TAG",
          desc: "Tag Address"
        }
      ]
    },
    {
      name:     "STATUS_543",
      desc:     "Status register of cache line 543",
      swaccess: "rw",
      hwaccess: "hrw",
      hwext:    "true",
      hwqe:     "true", // enable `qe` latched signal of software write pulse
      hwre:     "true",
      fields: [
        {
          bits: "5+3:5", // 2 bits for status
          name: "CL_STATUS",
          desc: "Contain the current status of the corresponding cache line                [0]: valid, [1]: dirty, [2]: cmpt",
        }
      ]
    },
    { name:     "TAG_543",
      desc:     "Tag Address stored in cache line 543",
      swaccess: "rw",
      hwaccess: "hrw",
      hwext:    "true",
      hwqe:     "true", // enable `qe` latched signal of software write pulse
      hwre:     "true",
      fields: [
        { bits: "5-1:0",
          name: "CL_TAG",
          desc: "Tag Address"
        }
      ]
    },
    {
      name:     "STATUS_544",
      desc:     "Status register of cache line 544",
      swaccess: "rw",
      hwaccess: "hrw",
      hwext:    "true",
      hwqe:     "true", // enable `qe` latched signal of software write pulse
      hwre:     "true",
      fields: [
        {
          bits: "5+3:5", // 2 bits for status
          name: "CL_STATUS",
          desc: "Contain the current status of the corresponding cache line                [0]: valid, [1]: dirty, [2]: cmpt",
        }
      ]
    },
    { name:     "TAG_544",
      desc:     "Tag Address stored in cache line 544",
      swaccess: "rw",
      hwaccess: "hrw",
      hwext:    "true",
      hwqe:     "true", // enable `qe` latched signal of software write pulse
      hwre:     "true",
      fields: [
        { bits: "5-1:0",
          name: "CL_TAG",
          desc: "Tag Address"
        }
      ]
    },
    {
      name:     "STATUS_545",
      desc:     "Status register of cache line 545",
      swaccess: "rw",
      hwaccess: "hrw",
      hwext:    "true",
      hwqe:     "true", // enable `qe` latched signal of software write pulse
      hwre:     "true",
      fields: [
        {
          bits: "5+3:5", // 2 bits for status
          name: "CL_STATUS",
          desc: "Contain the current status of the corresponding cache line                [0]: valid, [1]: dirty, [2]: cmpt",
        }
      ]
    },
    { name:     "TAG_545",
      desc:     "Tag Address stored in cache line 545",
      swaccess: "rw",
      hwaccess: "hrw",
      hwext:    "true",
      hwqe:     "true", // enable `qe` latched signal of software write pulse
      hwre:     "true",
      fields: [
        { bits: "5-1:0",
          name: "CL_TAG",
          desc: "Tag Address"
        }
      ]
    },
    {
      name:     "STATUS_546",
      desc:     "Status register of cache line 546",
      swaccess: "rw",
      hwaccess: "hrw",
      hwext:    "true",
      hwqe:     "true", // enable `qe` latched signal of software write pulse
      hwre:     "true",
      fields: [
        {
          bits: "5+3:5", // 2 bits for status
          name: "CL_STATUS",
          desc: "Contain the current status of the corresponding cache line                [0]: valid, [1]: dirty, [2]: cmpt",
        }
      ]
    },
    { name:     "TAG_546",
      desc:     "Tag Address stored in cache line 546",
      swaccess: "rw",
      hwaccess: "hrw",
      hwext:    "true",
      hwqe:     "true", // enable `qe` latched signal of software write pulse
      hwre:     "true",
      fields: [
        { bits: "5-1:0",
          name: "CL_TAG",
          desc: "Tag Address"
        }
      ]
    },
    {
      name:     "STATUS_547",
      desc:     "Status register of cache line 547",
      swaccess: "rw",
      hwaccess: "hrw",
      hwext:    "true",
      hwqe:     "true", // enable `qe` latched signal of software write pulse
      hwre:     "true",
      fields: [
        {
          bits: "5+3:5", // 2 bits for status
          name: "CL_STATUS",
          desc: "Contain the current status of the corresponding cache line                [0]: valid, [1]: dirty, [2]: cmpt",
        }
      ]
    },
    { name:     "TAG_547",
      desc:     "Tag Address stored in cache line 547",
      swaccess: "rw",
      hwaccess: "hrw",
      hwext:    "true",
      hwqe:     "true", // enable `qe` latched signal of software write pulse
      hwre:     "true",
      fields: [
        { bits: "5-1:0",
          name: "CL_TAG",
          desc: "Tag Address"
        }
      ]
    },
    {
      name:     "STATUS_548",
      desc:     "Status register of cache line 548",
      swaccess: "rw",
      hwaccess: "hrw",
      hwext:    "true",
      hwqe:     "true", // enable `qe` latched signal of software write pulse
      hwre:     "true",
      fields: [
        {
          bits: "5+3:5", // 2 bits for status
          name: "CL_STATUS",
          desc: "Contain the current status of the corresponding cache line                [0]: valid, [1]: dirty, [2]: cmpt",
        }
      ]
    },
    { name:     "TAG_548",
      desc:     "Tag Address stored in cache line 548",
      swaccess: "rw",
      hwaccess: "hrw",
      hwext:    "true",
      hwqe:     "true", // enable `qe` latched signal of software write pulse
      hwre:     "true",
      fields: [
        { bits: "5-1:0",
          name: "CL_TAG",
          desc: "Tag Address"
        }
      ]
    },
    {
      name:     "STATUS_549",
      desc:     "Status register of cache line 549",
      swaccess: "rw",
      hwaccess: "hrw",
      hwext:    "true",
      hwqe:     "true", // enable `qe` latched signal of software write pulse
      hwre:     "true",
      fields: [
        {
          bits: "5+3:5", // 2 bits for status
          name: "CL_STATUS",
          desc: "Contain the current status of the corresponding cache line                [0]: valid, [1]: dirty, [2]: cmpt",
        }
      ]
    },
    { name:     "TAG_549",
      desc:     "Tag Address stored in cache line 549",
      swaccess: "rw",
      hwaccess: "hrw",
      hwext:    "true",
      hwqe:     "true", // enable `qe` latched signal of software write pulse
      hwre:     "true",
      fields: [
        { bits: "5-1:0",
          name: "CL_TAG",
          desc: "Tag Address"
        }
      ]
    },
    {
      name:     "STATUS_550",
      desc:     "Status register of cache line 550",
      swaccess: "rw",
      hwaccess: "hrw",
      hwext:    "true",
      hwqe:     "true", // enable `qe` latched signal of software write pulse
      hwre:     "true",
      fields: [
        {
          bits: "5+3:5", // 2 bits for status
          name: "CL_STATUS",
          desc: "Contain the current status of the corresponding cache line                [0]: valid, [1]: dirty, [2]: cmpt",
        }
      ]
    },
    { name:     "TAG_550",
      desc:     "Tag Address stored in cache line 550",
      swaccess: "rw",
      hwaccess: "hrw",
      hwext:    "true",
      hwqe:     "true", // enable `qe` latched signal of software write pulse
      hwre:     "true",
      fields: [
        { bits: "5-1:0",
          name: "CL_TAG",
          desc: "Tag Address"
        }
      ]
    },
    {
      name:     "STATUS_551",
      desc:     "Status register of cache line 551",
      swaccess: "rw",
      hwaccess: "hrw",
      hwext:    "true",
      hwqe:     "true", // enable `qe` latched signal of software write pulse
      hwre:     "true",
      fields: [
        {
          bits: "5+3:5", // 2 bits for status
          name: "CL_STATUS",
          desc: "Contain the current status of the corresponding cache line                [0]: valid, [1]: dirty, [2]: cmpt",
        }
      ]
    },
    { name:     "TAG_551",
      desc:     "Tag Address stored in cache line 551",
      swaccess: "rw",
      hwaccess: "hrw",
      hwext:    "true",
      hwqe:     "true", // enable `qe` latched signal of software write pulse
      hwre:     "true",
      fields: [
        { bits: "5-1:0",
          name: "CL_TAG",
          desc: "Tag Address"
        }
      ]
    },
    {
      name:     "STATUS_552",
      desc:     "Status register of cache line 552",
      swaccess: "rw",
      hwaccess: "hrw",
      hwext:    "true",
      hwqe:     "true", // enable `qe` latched signal of software write pulse
      hwre:     "true",
      fields: [
        {
          bits: "5+3:5", // 2 bits for status
          name: "CL_STATUS",
          desc: "Contain the current status of the corresponding cache line                [0]: valid, [1]: dirty, [2]: cmpt",
        }
      ]
    },
    { name:     "TAG_552",
      desc:     "Tag Address stored in cache line 552",
      swaccess: "rw",
      hwaccess: "hrw",
      hwext:    "true",
      hwqe:     "true", // enable `qe` latched signal of software write pulse
      hwre:     "true",
      fields: [
        { bits: "5-1:0",
          name: "CL_TAG",
          desc: "Tag Address"
        }
      ]
    },
    {
      name:     "STATUS_553",
      desc:     "Status register of cache line 553",
      swaccess: "rw",
      hwaccess: "hrw",
      hwext:    "true",
      hwqe:     "true", // enable `qe` latched signal of software write pulse
      hwre:     "true",
      fields: [
        {
          bits: "5+3:5", // 2 bits for status
          name: "CL_STATUS",
          desc: "Contain the current status of the corresponding cache line                [0]: valid, [1]: dirty, [2]: cmpt",
        }
      ]
    },
    { name:     "TAG_553",
      desc:     "Tag Address stored in cache line 553",
      swaccess: "rw",
      hwaccess: "hrw",
      hwext:    "true",
      hwqe:     "true", // enable `qe` latched signal of software write pulse
      hwre:     "true",
      fields: [
        { bits: "5-1:0",
          name: "CL_TAG",
          desc: "Tag Address"
        }
      ]
    },
    {
      name:     "STATUS_554",
      desc:     "Status register of cache line 554",
      swaccess: "rw",
      hwaccess: "hrw",
      hwext:    "true",
      hwqe:     "true", // enable `qe` latched signal of software write pulse
      hwre:     "true",
      fields: [
        {
          bits: "5+3:5", // 2 bits for status
          name: "CL_STATUS",
          desc: "Contain the current status of the corresponding cache line                [0]: valid, [1]: dirty, [2]: cmpt",
        }
      ]
    },
    { name:     "TAG_554",
      desc:     "Tag Address stored in cache line 554",
      swaccess: "rw",
      hwaccess: "hrw",
      hwext:    "true",
      hwqe:     "true", // enable `qe` latched signal of software write pulse
      hwre:     "true",
      fields: [
        { bits: "5-1:0",
          name: "CL_TAG",
          desc: "Tag Address"
        }
      ]
    },
    {
      name:     "STATUS_555",
      desc:     "Status register of cache line 555",
      swaccess: "rw",
      hwaccess: "hrw",
      hwext:    "true",
      hwqe:     "true", // enable `qe` latched signal of software write pulse
      hwre:     "true",
      fields: [
        {
          bits: "5+3:5", // 2 bits for status
          name: "CL_STATUS",
          desc: "Contain the current status of the corresponding cache line                [0]: valid, [1]: dirty, [2]: cmpt",
        }
      ]
    },
    { name:     "TAG_555",
      desc:     "Tag Address stored in cache line 555",
      swaccess: "rw",
      hwaccess: "hrw",
      hwext:    "true",
      hwqe:     "true", // enable `qe` latched signal of software write pulse
      hwre:     "true",
      fields: [
        { bits: "5-1:0",
          name: "CL_TAG",
          desc: "Tag Address"
        }
      ]
    },
    {
      name:     "STATUS_556",
      desc:     "Status register of cache line 556",
      swaccess: "rw",
      hwaccess: "hrw",
      hwext:    "true",
      hwqe:     "true", // enable `qe` latched signal of software write pulse
      hwre:     "true",
      fields: [
        {
          bits: "5+3:5", // 2 bits for status
          name: "CL_STATUS",
          desc: "Contain the current status of the corresponding cache line                [0]: valid, [1]: dirty, [2]: cmpt",
        }
      ]
    },
    { name:     "TAG_556",
      desc:     "Tag Address stored in cache line 556",
      swaccess: "rw",
      hwaccess: "hrw",
      hwext:    "true",
      hwqe:     "true", // enable `qe` latched signal of software write pulse
      hwre:     "true",
      fields: [
        { bits: "5-1:0",
          name: "CL_TAG",
          desc: "Tag Address"
        }
      ]
    },
    {
      name:     "STATUS_557",
      desc:     "Status register of cache line 557",
      swaccess: "rw",
      hwaccess: "hrw",
      hwext:    "true",
      hwqe:     "true", // enable `qe` latched signal of software write pulse
      hwre:     "true",
      fields: [
        {
          bits: "5+3:5", // 2 bits for status
          name: "CL_STATUS",
          desc: "Contain the current status of the corresponding cache line                [0]: valid, [1]: dirty, [2]: cmpt",
        }
      ]
    },
    { name:     "TAG_557",
      desc:     "Tag Address stored in cache line 557",
      swaccess: "rw",
      hwaccess: "hrw",
      hwext:    "true",
      hwqe:     "true", // enable `qe` latched signal of software write pulse
      hwre:     "true",
      fields: [
        { bits: "5-1:0",
          name: "CL_TAG",
          desc: "Tag Address"
        }
      ]
    },
    {
      name:     "STATUS_558",
      desc:     "Status register of cache line 558",
      swaccess: "rw",
      hwaccess: "hrw",
      hwext:    "true",
      hwqe:     "true", // enable `qe` latched signal of software write pulse
      hwre:     "true",
      fields: [
        {
          bits: "5+3:5", // 2 bits for status
          name: "CL_STATUS",
          desc: "Contain the current status of the corresponding cache line                [0]: valid, [1]: dirty, [2]: cmpt",
        }
      ]
    },
    { name:     "TAG_558",
      desc:     "Tag Address stored in cache line 558",
      swaccess: "rw",
      hwaccess: "hrw",
      hwext:    "true",
      hwqe:     "true", // enable `qe` latched signal of software write pulse
      hwre:     "true",
      fields: [
        { bits: "5-1:0",
          name: "CL_TAG",
          desc: "Tag Address"
        }
      ]
    },
    {
      name:     "STATUS_559",
      desc:     "Status register of cache line 559",
      swaccess: "rw",
      hwaccess: "hrw",
      hwext:    "true",
      hwqe:     "true", // enable `qe` latched signal of software write pulse
      hwre:     "true",
      fields: [
        {
          bits: "5+3:5", // 2 bits for status
          name: "CL_STATUS",
          desc: "Contain the current status of the corresponding cache line                [0]: valid, [1]: dirty, [2]: cmpt",
        }
      ]
    },
    { name:     "TAG_559",
      desc:     "Tag Address stored in cache line 559",
      swaccess: "rw",
      hwaccess: "hrw",
      hwext:    "true",
      hwqe:     "true", // enable `qe` latched signal of software write pulse
      hwre:     "true",
      fields: [
        { bits: "5-1:0",
          name: "CL_TAG",
          desc: "Tag Address"
        }
      ]
    },
    {
      name:     "STATUS_560",
      desc:     "Status register of cache line 560",
      swaccess: "rw",
      hwaccess: "hrw",
      hwext:    "true",
      hwqe:     "true", // enable `qe` latched signal of software write pulse
      hwre:     "true",
      fields: [
        {
          bits: "5+3:5", // 2 bits for status
          name: "CL_STATUS",
          desc: "Contain the current status of the corresponding cache line                [0]: valid, [1]: dirty, [2]: cmpt",
        }
      ]
    },
    { name:     "TAG_560",
      desc:     "Tag Address stored in cache line 560",
      swaccess: "rw",
      hwaccess: "hrw",
      hwext:    "true",
      hwqe:     "true", // enable `qe` latched signal of software write pulse
      hwre:     "true",
      fields: [
        { bits: "5-1:0",
          name: "CL_TAG",
          desc: "Tag Address"
        }
      ]
    },
    {
      name:     "STATUS_561",
      desc:     "Status register of cache line 561",
      swaccess: "rw",
      hwaccess: "hrw",
      hwext:    "true",
      hwqe:     "true", // enable `qe` latched signal of software write pulse
      hwre:     "true",
      fields: [
        {
          bits: "5+3:5", // 2 bits for status
          name: "CL_STATUS",
          desc: "Contain the current status of the corresponding cache line                [0]: valid, [1]: dirty, [2]: cmpt",
        }
      ]
    },
    { name:     "TAG_561",
      desc:     "Tag Address stored in cache line 561",
      swaccess: "rw",
      hwaccess: "hrw",
      hwext:    "true",
      hwqe:     "true", // enable `qe` latched signal of software write pulse
      hwre:     "true",
      fields: [
        { bits: "5-1:0",
          name: "CL_TAG",
          desc: "Tag Address"
        }
      ]
    },
    {
      name:     "STATUS_562",
      desc:     "Status register of cache line 562",
      swaccess: "rw",
      hwaccess: "hrw",
      hwext:    "true",
      hwqe:     "true", // enable `qe` latched signal of software write pulse
      hwre:     "true",
      fields: [
        {
          bits: "5+3:5", // 2 bits for status
          name: "CL_STATUS",
          desc: "Contain the current status of the corresponding cache line                [0]: valid, [1]: dirty, [2]: cmpt",
        }
      ]
    },
    { name:     "TAG_562",
      desc:     "Tag Address stored in cache line 562",
      swaccess: "rw",
      hwaccess: "hrw",
      hwext:    "true",
      hwqe:     "true", // enable `qe` latched signal of software write pulse
      hwre:     "true",
      fields: [
        { bits: "5-1:0",
          name: "CL_TAG",
          desc: "Tag Address"
        }
      ]
    },
    {
      name:     "STATUS_563",
      desc:     "Status register of cache line 563",
      swaccess: "rw",
      hwaccess: "hrw",
      hwext:    "true",
      hwqe:     "true", // enable `qe` latched signal of software write pulse
      hwre:     "true",
      fields: [
        {
          bits: "5+3:5", // 2 bits for status
          name: "CL_STATUS",
          desc: "Contain the current status of the corresponding cache line                [0]: valid, [1]: dirty, [2]: cmpt",
        }
      ]
    },
    { name:     "TAG_563",
      desc:     "Tag Address stored in cache line 563",
      swaccess: "rw",
      hwaccess: "hrw",
      hwext:    "true",
      hwqe:     "true", // enable `qe` latched signal of software write pulse
      hwre:     "true",
      fields: [
        { bits: "5-1:0",
          name: "CL_TAG",
          desc: "Tag Address"
        }
      ]
    },
    {
      name:     "STATUS_564",
      desc:     "Status register of cache line 564",
      swaccess: "rw",
      hwaccess: "hrw",
      hwext:    "true",
      hwqe:     "true", // enable `qe` latched signal of software write pulse
      hwre:     "true",
      fields: [
        {
          bits: "5+3:5", // 2 bits for status
          name: "CL_STATUS",
          desc: "Contain the current status of the corresponding cache line                [0]: valid, [1]: dirty, [2]: cmpt",
        }
      ]
    },
    { name:     "TAG_564",
      desc:     "Tag Address stored in cache line 564",
      swaccess: "rw",
      hwaccess: "hrw",
      hwext:    "true",
      hwqe:     "true", // enable `qe` latched signal of software write pulse
      hwre:     "true",
      fields: [
        { bits: "5-1:0",
          name: "CL_TAG",
          desc: "Tag Address"
        }
      ]
    },
    {
      name:     "STATUS_565",
      desc:     "Status register of cache line 565",
      swaccess: "rw",
      hwaccess: "hrw",
      hwext:    "true",
      hwqe:     "true", // enable `qe` latched signal of software write pulse
      hwre:     "true",
      fields: [
        {
          bits: "5+3:5", // 2 bits for status
          name: "CL_STATUS",
          desc: "Contain the current status of the corresponding cache line                [0]: valid, [1]: dirty, [2]: cmpt",
        }
      ]
    },
    { name:     "TAG_565",
      desc:     "Tag Address stored in cache line 565",
      swaccess: "rw",
      hwaccess: "hrw",
      hwext:    "true",
      hwqe:     "true", // enable `qe` latched signal of software write pulse
      hwre:     "true",
      fields: [
        { bits: "5-1:0",
          name: "CL_TAG",
          desc: "Tag Address"
        }
      ]
    },
    {
      name:     "STATUS_566",
      desc:     "Status register of cache line 566",
      swaccess: "rw",
      hwaccess: "hrw",
      hwext:    "true",
      hwqe:     "true", // enable `qe` latched signal of software write pulse
      hwre:     "true",
      fields: [
        {
          bits: "5+3:5", // 2 bits for status
          name: "CL_STATUS",
          desc: "Contain the current status of the corresponding cache line                [0]: valid, [1]: dirty, [2]: cmpt",
        }
      ]
    },
    { name:     "TAG_566",
      desc:     "Tag Address stored in cache line 566",
      swaccess: "rw",
      hwaccess: "hrw",
      hwext:    "true",
      hwqe:     "true", // enable `qe` latched signal of software write pulse
      hwre:     "true",
      fields: [
        { bits: "5-1:0",
          name: "CL_TAG",
          desc: "Tag Address"
        }
      ]
    },
    {
      name:     "STATUS_567",
      desc:     "Status register of cache line 567",
      swaccess: "rw",
      hwaccess: "hrw",
      hwext:    "true",
      hwqe:     "true", // enable `qe` latched signal of software write pulse
      hwre:     "true",
      fields: [
        {
          bits: "5+3:5", // 2 bits for status
          name: "CL_STATUS",
          desc: "Contain the current status of the corresponding cache line                [0]: valid, [1]: dirty, [2]: cmpt",
        }
      ]
    },
    { name:     "TAG_567",
      desc:     "Tag Address stored in cache line 567",
      swaccess: "rw",
      hwaccess: "hrw",
      hwext:    "true",
      hwqe:     "true", // enable `qe` latched signal of software write pulse
      hwre:     "true",
      fields: [
        { bits: "5-1:0",
          name: "CL_TAG",
          desc: "Tag Address"
        }
      ]
    },
    {
      name:     "STATUS_568",
      desc:     "Status register of cache line 568",
      swaccess: "rw",
      hwaccess: "hrw",
      hwext:    "true",
      hwqe:     "true", // enable `qe` latched signal of software write pulse
      hwre:     "true",
      fields: [
        {
          bits: "5+3:5", // 2 bits for status
          name: "CL_STATUS",
          desc: "Contain the current status of the corresponding cache line                [0]: valid, [1]: dirty, [2]: cmpt",
        }
      ]
    },
    { name:     "TAG_568",
      desc:     "Tag Address stored in cache line 568",
      swaccess: "rw",
      hwaccess: "hrw",
      hwext:    "true",
      hwqe:     "true", // enable `qe` latched signal of software write pulse
      hwre:     "true",
      fields: [
        { bits: "5-1:0",
          name: "CL_TAG",
          desc: "Tag Address"
        }
      ]
    },
    {
      name:     "STATUS_569",
      desc:     "Status register of cache line 569",
      swaccess: "rw",
      hwaccess: "hrw",
      hwext:    "true",
      hwqe:     "true", // enable `qe` latched signal of software write pulse
      hwre:     "true",
      fields: [
        {
          bits: "5+3:5", // 2 bits for status
          name: "CL_STATUS",
          desc: "Contain the current status of the corresponding cache line                [0]: valid, [1]: dirty, [2]: cmpt",
        }
      ]
    },
    { name:     "TAG_569",
      desc:     "Tag Address stored in cache line 569",
      swaccess: "rw",
      hwaccess: "hrw",
      hwext:    "true",
      hwqe:     "true", // enable `qe` latched signal of software write pulse
      hwre:     "true",
      fields: [
        { bits: "5-1:0",
          name: "CL_TAG",
          desc: "Tag Address"
        }
      ]
    },
    {
      name:     "STATUS_570",
      desc:     "Status register of cache line 570",
      swaccess: "rw",
      hwaccess: "hrw",
      hwext:    "true",
      hwqe:     "true", // enable `qe` latched signal of software write pulse
      hwre:     "true",
      fields: [
        {
          bits: "5+3:5", // 2 bits for status
          name: "CL_STATUS",
          desc: "Contain the current status of the corresponding cache line                [0]: valid, [1]: dirty, [2]: cmpt",
        }
      ]
    },
    { name:     "TAG_570",
      desc:     "Tag Address stored in cache line 570",
      swaccess: "rw",
      hwaccess: "hrw",
      hwext:    "true",
      hwqe:     "true", // enable `qe` latched signal of software write pulse
      hwre:     "true",
      fields: [
        { bits: "5-1:0",
          name: "CL_TAG",
          desc: "Tag Address"
        }
      ]
    },
    {
      name:     "STATUS_571",
      desc:     "Status register of cache line 571",
      swaccess: "rw",
      hwaccess: "hrw",
      hwext:    "true",
      hwqe:     "true", // enable `qe` latched signal of software write pulse
      hwre:     "true",
      fields: [
        {
          bits: "5+3:5", // 2 bits for status
          name: "CL_STATUS",
          desc: "Contain the current status of the corresponding cache line                [0]: valid, [1]: dirty, [2]: cmpt",
        }
      ]
    },
    { name:     "TAG_571",
      desc:     "Tag Address stored in cache line 571",
      swaccess: "rw",
      hwaccess: "hrw",
      hwext:    "true",
      hwqe:     "true", // enable `qe` latched signal of software write pulse
      hwre:     "true",
      fields: [
        { bits: "5-1:0",
          name: "CL_TAG",
          desc: "Tag Address"
        }
      ]
    },
    {
      name:     "STATUS_572",
      desc:     "Status register of cache line 572",
      swaccess: "rw",
      hwaccess: "hrw",
      hwext:    "true",
      hwqe:     "true", // enable `qe` latched signal of software write pulse
      hwre:     "true",
      fields: [
        {
          bits: "5+3:5", // 2 bits for status
          name: "CL_STATUS",
          desc: "Contain the current status of the corresponding cache line                [0]: valid, [1]: dirty, [2]: cmpt",
        }
      ]
    },
    { name:     "TAG_572",
      desc:     "Tag Address stored in cache line 572",
      swaccess: "rw",
      hwaccess: "hrw",
      hwext:    "true",
      hwqe:     "true", // enable `qe` latched signal of software write pulse
      hwre:     "true",
      fields: [
        { bits: "5-1:0",
          name: "CL_TAG",
          desc: "Tag Address"
        }
      ]
    },
    {
      name:     "STATUS_573",
      desc:     "Status register of cache line 573",
      swaccess: "rw",
      hwaccess: "hrw",
      hwext:    "true",
      hwqe:     "true", // enable `qe` latched signal of software write pulse
      hwre:     "true",
      fields: [
        {
          bits: "5+3:5", // 2 bits for status
          name: "CL_STATUS",
          desc: "Contain the current status of the corresponding cache line                [0]: valid, [1]: dirty, [2]: cmpt",
        }
      ]
    },
    { name:     "TAG_573",
      desc:     "Tag Address stored in cache line 573",
      swaccess: "rw",
      hwaccess: "hrw",
      hwext:    "true",
      hwqe:     "true", // enable `qe` latched signal of software write pulse
      hwre:     "true",
      fields: [
        { bits: "5-1:0",
          name: "CL_TAG",
          desc: "Tag Address"
        }
      ]
    },
    {
      name:     "STATUS_574",
      desc:     "Status register of cache line 574",
      swaccess: "rw",
      hwaccess: "hrw",
      hwext:    "true",
      hwqe:     "true", // enable `qe` latched signal of software write pulse
      hwre:     "true",
      fields: [
        {
          bits: "5+3:5", // 2 bits for status
          name: "CL_STATUS",
          desc: "Contain the current status of the corresponding cache line                [0]: valid, [1]: dirty, [2]: cmpt",
        }
      ]
    },
    { name:     "TAG_574",
      desc:     "Tag Address stored in cache line 574",
      swaccess: "rw",
      hwaccess: "hrw",
      hwext:    "true",
      hwqe:     "true", // enable `qe` latched signal of software write pulse
      hwre:     "true",
      fields: [
        { bits: "5-1:0",
          name: "CL_TAG",
          desc: "Tag Address"
        }
      ]
    },
    {
      name:     "STATUS_575",
      desc:     "Status register of cache line 575",
      swaccess: "rw",
      hwaccess: "hrw",
      hwext:    "true",
      hwqe:     "true", // enable `qe` latched signal of software write pulse
      hwre:     "true",
      fields: [
        {
          bits: "5+3:5", // 2 bits for status
          name: "CL_STATUS",
          desc: "Contain the current status of the corresponding cache line                [0]: valid, [1]: dirty, [2]: cmpt",
        }
      ]
    },
    { name:     "TAG_575",
      desc:     "Tag Address stored in cache line 575",
      swaccess: "rw",
      hwaccess: "hrw",
      hwext:    "true",
      hwqe:     "true", // enable `qe` latched signal of software write pulse
      hwre:     "true",
      fields: [
        { bits: "5-1:0",
          name: "CL_TAG",
          desc: "Tag Address"
        }
      ]
    },
    {
      name:     "STATUS_576",
      desc:     "Status register of cache line 576",
      swaccess: "rw",
      hwaccess: "hrw",
      hwext:    "true",
      hwqe:     "true", // enable `qe` latched signal of software write pulse
      hwre:     "true",
      fields: [
        {
          bits: "5+3:5", // 2 bits for status
          name: "CL_STATUS",
          desc: "Contain the current status of the corresponding cache line                [0]: valid, [1]: dirty, [2]: cmpt",
        }
      ]
    },
    { name:     "TAG_576",
      desc:     "Tag Address stored in cache line 576",
      swaccess: "rw",
      hwaccess: "hrw",
      hwext:    "true",
      hwqe:     "true", // enable `qe` latched signal of software write pulse
      hwre:     "true",
      fields: [
        { bits: "5-1:0",
          name: "CL_TAG",
          desc: "Tag Address"
        }
      ]
    },
    {
      name:     "STATUS_577",
      desc:     "Status register of cache line 577",
      swaccess: "rw",
      hwaccess: "hrw",
      hwext:    "true",
      hwqe:     "true", // enable `qe` latched signal of software write pulse
      hwre:     "true",
      fields: [
        {
          bits: "5+3:5", // 2 bits for status
          name: "CL_STATUS",
          desc: "Contain the current status of the corresponding cache line                [0]: valid, [1]: dirty, [2]: cmpt",
        }
      ]
    },
    { name:     "TAG_577",
      desc:     "Tag Address stored in cache line 577",
      swaccess: "rw",
      hwaccess: "hrw",
      hwext:    "true",
      hwqe:     "true", // enable `qe` latched signal of software write pulse
      hwre:     "true",
      fields: [
        { bits: "5-1:0",
          name: "CL_TAG",
          desc: "Tag Address"
        }
      ]
    },
    {
      name:     "STATUS_578",
      desc:     "Status register of cache line 578",
      swaccess: "rw",
      hwaccess: "hrw",
      hwext:    "true",
      hwqe:     "true", // enable `qe` latched signal of software write pulse
      hwre:     "true",
      fields: [
        {
          bits: "5+3:5", // 2 bits for status
          name: "CL_STATUS",
          desc: "Contain the current status of the corresponding cache line                [0]: valid, [1]: dirty, [2]: cmpt",
        }
      ]
    },
    { name:     "TAG_578",
      desc:     "Tag Address stored in cache line 578",
      swaccess: "rw",
      hwaccess: "hrw",
      hwext:    "true",
      hwqe:     "true", // enable `qe` latched signal of software write pulse
      hwre:     "true",
      fields: [
        { bits: "5-1:0",
          name: "CL_TAG",
          desc: "Tag Address"
        }
      ]
    },
    {
      name:     "STATUS_579",
      desc:     "Status register of cache line 579",
      swaccess: "rw",
      hwaccess: "hrw",
      hwext:    "true",
      hwqe:     "true", // enable `qe` latched signal of software write pulse
      hwre:     "true",
      fields: [
        {
          bits: "5+3:5", // 2 bits for status
          name: "CL_STATUS",
          desc: "Contain the current status of the corresponding cache line                [0]: valid, [1]: dirty, [2]: cmpt",
        }
      ]
    },
    { name:     "TAG_579",
      desc:     "Tag Address stored in cache line 579",
      swaccess: "rw",
      hwaccess: "hrw",
      hwext:    "true",
      hwqe:     "true", // enable `qe` latched signal of software write pulse
      hwre:     "true",
      fields: [
        { bits: "5-1:0",
          name: "CL_TAG",
          desc: "Tag Address"
        }
      ]
    },
    {
      name:     "STATUS_580",
      desc:     "Status register of cache line 580",
      swaccess: "rw",
      hwaccess: "hrw",
      hwext:    "true",
      hwqe:     "true", // enable `qe` latched signal of software write pulse
      hwre:     "true",
      fields: [
        {
          bits: "5+3:5", // 2 bits for status
          name: "CL_STATUS",
          desc: "Contain the current status of the corresponding cache line                [0]: valid, [1]: dirty, [2]: cmpt",
        }
      ]
    },
    { name:     "TAG_580",
      desc:     "Tag Address stored in cache line 580",
      swaccess: "rw",
      hwaccess: "hrw",
      hwext:    "true",
      hwqe:     "true", // enable `qe` latched signal of software write pulse
      hwre:     "true",
      fields: [
        { bits: "5-1:0",
          name: "CL_TAG",
          desc: "Tag Address"
        }
      ]
    },
    {
      name:     "STATUS_581",
      desc:     "Status register of cache line 581",
      swaccess: "rw",
      hwaccess: "hrw",
      hwext:    "true",
      hwqe:     "true", // enable `qe` latched signal of software write pulse
      hwre:     "true",
      fields: [
        {
          bits: "5+3:5", // 2 bits for status
          name: "CL_STATUS",
          desc: "Contain the current status of the corresponding cache line                [0]: valid, [1]: dirty, [2]: cmpt",
        }
      ]
    },
    { name:     "TAG_581",
      desc:     "Tag Address stored in cache line 581",
      swaccess: "rw",
      hwaccess: "hrw",
      hwext:    "true",
      hwqe:     "true", // enable `qe` latched signal of software write pulse
      hwre:     "true",
      fields: [
        { bits: "5-1:0",
          name: "CL_TAG",
          desc: "Tag Address"
        }
      ]
    },
    {
      name:     "STATUS_582",
      desc:     "Status register of cache line 582",
      swaccess: "rw",
      hwaccess: "hrw",
      hwext:    "true",
      hwqe:     "true", // enable `qe` latched signal of software write pulse
      hwre:     "true",
      fields: [
        {
          bits: "5+3:5", // 2 bits for status
          name: "CL_STATUS",
          desc: "Contain the current status of the corresponding cache line                [0]: valid, [1]: dirty, [2]: cmpt",
        }
      ]
    },
    { name:     "TAG_582",
      desc:     "Tag Address stored in cache line 582",
      swaccess: "rw",
      hwaccess: "hrw",
      hwext:    "true",
      hwqe:     "true", // enable `qe` latched signal of software write pulse
      hwre:     "true",
      fields: [
        { bits: "5-1:0",
          name: "CL_TAG",
          desc: "Tag Address"
        }
      ]
    },
    {
      name:     "STATUS_583",
      desc:     "Status register of cache line 583",
      swaccess: "rw",
      hwaccess: "hrw",
      hwext:    "true",
      hwqe:     "true", // enable `qe` latched signal of software write pulse
      hwre:     "true",
      fields: [
        {
          bits: "5+3:5", // 2 bits for status
          name: "CL_STATUS",
          desc: "Contain the current status of the corresponding cache line                [0]: valid, [1]: dirty, [2]: cmpt",
        }
      ]
    },
    { name:     "TAG_583",
      desc:     "Tag Address stored in cache line 583",
      swaccess: "rw",
      hwaccess: "hrw",
      hwext:    "true",
      hwqe:     "true", // enable `qe` latched signal of software write pulse
      hwre:     "true",
      fields: [
        { bits: "5-1:0",
          name: "CL_TAG",
          desc: "Tag Address"
        }
      ]
    },
    {
      name:     "STATUS_584",
      desc:     "Status register of cache line 584",
      swaccess: "rw",
      hwaccess: "hrw",
      hwext:    "true",
      hwqe:     "true", // enable `qe` latched signal of software write pulse
      hwre:     "true",
      fields: [
        {
          bits: "5+3:5", // 2 bits for status
          name: "CL_STATUS",
          desc: "Contain the current status of the corresponding cache line                [0]: valid, [1]: dirty, [2]: cmpt",
        }
      ]
    },
    { name:     "TAG_584",
      desc:     "Tag Address stored in cache line 584",
      swaccess: "rw",
      hwaccess: "hrw",
      hwext:    "true",
      hwqe:     "true", // enable `qe` latched signal of software write pulse
      hwre:     "true",
      fields: [
        { bits: "5-1:0",
          name: "CL_TAG",
          desc: "Tag Address"
        }
      ]
    },
    {
      name:     "STATUS_585",
      desc:     "Status register of cache line 585",
      swaccess: "rw",
      hwaccess: "hrw",
      hwext:    "true",
      hwqe:     "true", // enable `qe` latched signal of software write pulse
      hwre:     "true",
      fields: [
        {
          bits: "5+3:5", // 2 bits for status
          name: "CL_STATUS",
          desc: "Contain the current status of the corresponding cache line                [0]: valid, [1]: dirty, [2]: cmpt",
        }
      ]
    },
    { name:     "TAG_585",
      desc:     "Tag Address stored in cache line 585",
      swaccess: "rw",
      hwaccess: "hrw",
      hwext:    "true",
      hwqe:     "true", // enable `qe` latched signal of software write pulse
      hwre:     "true",
      fields: [
        { bits: "5-1:0",
          name: "CL_TAG",
          desc: "Tag Address"
        }
      ]
    },
    {
      name:     "STATUS_586",
      desc:     "Status register of cache line 586",
      swaccess: "rw",
      hwaccess: "hrw",
      hwext:    "true",
      hwqe:     "true", // enable `qe` latched signal of software write pulse
      hwre:     "true",
      fields: [
        {
          bits: "5+3:5", // 2 bits for status
          name: "CL_STATUS",
          desc: "Contain the current status of the corresponding cache line                [0]: valid, [1]: dirty, [2]: cmpt",
        }
      ]
    },
    { name:     "TAG_586",
      desc:     "Tag Address stored in cache line 586",
      swaccess: "rw",
      hwaccess: "hrw",
      hwext:    "true",
      hwqe:     "true", // enable `qe` latched signal of software write pulse
      hwre:     "true",
      fields: [
        { bits: "5-1:0",
          name: "CL_TAG",
          desc: "Tag Address"
        }
      ]
    },
    {
      name:     "STATUS_587",
      desc:     "Status register of cache line 587",
      swaccess: "rw",
      hwaccess: "hrw",
      hwext:    "true",
      hwqe:     "true", // enable `qe` latched signal of software write pulse
      hwre:     "true",
      fields: [
        {
          bits: "5+3:5", // 2 bits for status
          name: "CL_STATUS",
          desc: "Contain the current status of the corresponding cache line                [0]: valid, [1]: dirty, [2]: cmpt",
        }
      ]
    },
    { name:     "TAG_587",
      desc:     "Tag Address stored in cache line 587",
      swaccess: "rw",
      hwaccess: "hrw",
      hwext:    "true",
      hwqe:     "true", // enable `qe` latched signal of software write pulse
      hwre:     "true",
      fields: [
        { bits: "5-1:0",
          name: "CL_TAG",
          desc: "Tag Address"
        }
      ]
    },
    {
      name:     "STATUS_588",
      desc:     "Status register of cache line 588",
      swaccess: "rw",
      hwaccess: "hrw",
      hwext:    "true",
      hwqe:     "true", // enable `qe` latched signal of software write pulse
      hwre:     "true",
      fields: [
        {
          bits: "5+3:5", // 2 bits for status
          name: "CL_STATUS",
          desc: "Contain the current status of the corresponding cache line                [0]: valid, [1]: dirty, [2]: cmpt",
        }
      ]
    },
    { name:     "TAG_588",
      desc:     "Tag Address stored in cache line 588",
      swaccess: "rw",
      hwaccess: "hrw",
      hwext:    "true",
      hwqe:     "true", // enable `qe` latched signal of software write pulse
      hwre:     "true",
      fields: [
        { bits: "5-1:0",
          name: "CL_TAG",
          desc: "Tag Address"
        }
      ]
    },
    {
      name:     "STATUS_589",
      desc:     "Status register of cache line 589",
      swaccess: "rw",
      hwaccess: "hrw",
      hwext:    "true",
      hwqe:     "true", // enable `qe` latched signal of software write pulse
      hwre:     "true",
      fields: [
        {
          bits: "5+3:5", // 2 bits for status
          name: "CL_STATUS",
          desc: "Contain the current status of the corresponding cache line                [0]: valid, [1]: dirty, [2]: cmpt",
        }
      ]
    },
    { name:     "TAG_589",
      desc:     "Tag Address stored in cache line 589",
      swaccess: "rw",
      hwaccess: "hrw",
      hwext:    "true",
      hwqe:     "true", // enable `qe` latched signal of software write pulse
      hwre:     "true",
      fields: [
        { bits: "5-1:0",
          name: "CL_TAG",
          desc: "Tag Address"
        }
      ]
    },
    {
      name:     "STATUS_590",
      desc:     "Status register of cache line 590",
      swaccess: "rw",
      hwaccess: "hrw",
      hwext:    "true",
      hwqe:     "true", // enable `qe` latched signal of software write pulse
      hwre:     "true",
      fields: [
        {
          bits: "5+3:5", // 2 bits for status
          name: "CL_STATUS",
          desc: "Contain the current status of the corresponding cache line                [0]: valid, [1]: dirty, [2]: cmpt",
        }
      ]
    },
    { name:     "TAG_590",
      desc:     "Tag Address stored in cache line 590",
      swaccess: "rw",
      hwaccess: "hrw",
      hwext:    "true",
      hwqe:     "true", // enable `qe` latched signal of software write pulse
      hwre:     "true",
      fields: [
        { bits: "5-1:0",
          name: "CL_TAG",
          desc: "Tag Address"
        }
      ]
    },
    {
      name:     "STATUS_591",
      desc:     "Status register of cache line 591",
      swaccess: "rw",
      hwaccess: "hrw",
      hwext:    "true",
      hwqe:     "true", // enable `qe` latched signal of software write pulse
      hwre:     "true",
      fields: [
        {
          bits: "5+3:5", // 2 bits for status
          name: "CL_STATUS",
          desc: "Contain the current status of the corresponding cache line                [0]: valid, [1]: dirty, [2]: cmpt",
        }
      ]
    },
    { name:     "TAG_591",
      desc:     "Tag Address stored in cache line 591",
      swaccess: "rw",
      hwaccess: "hrw",
      hwext:    "true",
      hwqe:     "true", // enable `qe` latched signal of software write pulse
      hwre:     "true",
      fields: [
        { bits: "5-1:0",
          name: "CL_TAG",
          desc: "Tag Address"
        }
      ]
    },
    {
      name:     "STATUS_592",
      desc:     "Status register of cache line 592",
      swaccess: "rw",
      hwaccess: "hrw",
      hwext:    "true",
      hwqe:     "true", // enable `qe` latched signal of software write pulse
      hwre:     "true",
      fields: [
        {
          bits: "5+3:5", // 2 bits for status
          name: "CL_STATUS",
          desc: "Contain the current status of the corresponding cache line                [0]: valid, [1]: dirty, [2]: cmpt",
        }
      ]
    },
    { name:     "TAG_592",
      desc:     "Tag Address stored in cache line 592",
      swaccess: "rw",
      hwaccess: "hrw",
      hwext:    "true",
      hwqe:     "true", // enable `qe` latched signal of software write pulse
      hwre:     "true",
      fields: [
        { bits: "5-1:0",
          name: "CL_TAG",
          desc: "Tag Address"
        }
      ]
    },
    {
      name:     "STATUS_593",
      desc:     "Status register of cache line 593",
      swaccess: "rw",
      hwaccess: "hrw",
      hwext:    "true",
      hwqe:     "true", // enable `qe` latched signal of software write pulse
      hwre:     "true",
      fields: [
        {
          bits: "5+3:5", // 2 bits for status
          name: "CL_STATUS",
          desc: "Contain the current status of the corresponding cache line                [0]: valid, [1]: dirty, [2]: cmpt",
        }
      ]
    },
    { name:     "TAG_593",
      desc:     "Tag Address stored in cache line 593",
      swaccess: "rw",
      hwaccess: "hrw",
      hwext:    "true",
      hwqe:     "true", // enable `qe` latched signal of software write pulse
      hwre:     "true",
      fields: [
        { bits: "5-1:0",
          name: "CL_TAG",
          desc: "Tag Address"
        }
      ]
    },
    {
      name:     "STATUS_594",
      desc:     "Status register of cache line 594",
      swaccess: "rw",
      hwaccess: "hrw",
      hwext:    "true",
      hwqe:     "true", // enable `qe` latched signal of software write pulse
      hwre:     "true",
      fields: [
        {
          bits: "5+3:5", // 2 bits for status
          name: "CL_STATUS",
          desc: "Contain the current status of the corresponding cache line                [0]: valid, [1]: dirty, [2]: cmpt",
        }
      ]
    },
    { name:     "TAG_594",
      desc:     "Tag Address stored in cache line 594",
      swaccess: "rw",
      hwaccess: "hrw",
      hwext:    "true",
      hwqe:     "true", // enable `qe` latched signal of software write pulse
      hwre:     "true",
      fields: [
        { bits: "5-1:0",
          name: "CL_TAG",
          desc: "Tag Address"
        }
      ]
    },
    {
      name:     "STATUS_595",
      desc:     "Status register of cache line 595",
      swaccess: "rw",
      hwaccess: "hrw",
      hwext:    "true",
      hwqe:     "true", // enable `qe` latched signal of software write pulse
      hwre:     "true",
      fields: [
        {
          bits: "5+3:5", // 2 bits for status
          name: "CL_STATUS",
          desc: "Contain the current status of the corresponding cache line                [0]: valid, [1]: dirty, [2]: cmpt",
        }
      ]
    },
    { name:     "TAG_595",
      desc:     "Tag Address stored in cache line 595",
      swaccess: "rw",
      hwaccess: "hrw",
      hwext:    "true",
      hwqe:     "true", // enable `qe` latched signal of software write pulse
      hwre:     "true",
      fields: [
        { bits: "5-1:0",
          name: "CL_TAG",
          desc: "Tag Address"
        }
      ]
    },
    {
      name:     "STATUS_596",
      desc:     "Status register of cache line 596",
      swaccess: "rw",
      hwaccess: "hrw",
      hwext:    "true",
      hwqe:     "true", // enable `qe` latched signal of software write pulse
      hwre:     "true",
      fields: [
        {
          bits: "5+3:5", // 2 bits for status
          name: "CL_STATUS",
          desc: "Contain the current status of the corresponding cache line                [0]: valid, [1]: dirty, [2]: cmpt",
        }
      ]
    },
    { name:     "TAG_596",
      desc:     "Tag Address stored in cache line 596",
      swaccess: "rw",
      hwaccess: "hrw",
      hwext:    "true",
      hwqe:     "true", // enable `qe` latched signal of software write pulse
      hwre:     "true",
      fields: [
        { bits: "5-1:0",
          name: "CL_TAG",
          desc: "Tag Address"
        }
      ]
    },
    {
      name:     "STATUS_597",
      desc:     "Status register of cache line 597",
      swaccess: "rw",
      hwaccess: "hrw",
      hwext:    "true",
      hwqe:     "true", // enable `qe` latched signal of software write pulse
      hwre:     "true",
      fields: [
        {
          bits: "5+3:5", // 2 bits for status
          name: "CL_STATUS",
          desc: "Contain the current status of the corresponding cache line                [0]: valid, [1]: dirty, [2]: cmpt",
        }
      ]
    },
    { name:     "TAG_597",
      desc:     "Tag Address stored in cache line 597",
      swaccess: "rw",
      hwaccess: "hrw",
      hwext:    "true",
      hwqe:     "true", // enable `qe` latched signal of software write pulse
      hwre:     "true",
      fields: [
        { bits: "5-1:0",
          name: "CL_TAG",
          desc: "Tag Address"
        }
      ]
    },
    {
      name:     "STATUS_598",
      desc:     "Status register of cache line 598",
      swaccess: "rw",
      hwaccess: "hrw",
      hwext:    "true",
      hwqe:     "true", // enable `qe` latched signal of software write pulse
      hwre:     "true",
      fields: [
        {
          bits: "5+3:5", // 2 bits for status
          name: "CL_STATUS",
          desc: "Contain the current status of the corresponding cache line                [0]: valid, [1]: dirty, [2]: cmpt",
        }
      ]
    },
    { name:     "TAG_598",
      desc:     "Tag Address stored in cache line 598",
      swaccess: "rw",
      hwaccess: "hrw",
      hwext:    "true",
      hwqe:     "true", // enable `qe` latched signal of software write pulse
      hwre:     "true",
      fields: [
        { bits: "5-1:0",
          name: "CL_TAG",
          desc: "Tag Address"
        }
      ]
    },
    {
      name:     "STATUS_599",
      desc:     "Status register of cache line 599",
      swaccess: "rw",
      hwaccess: "hrw",
      hwext:    "true",
      hwqe:     "true", // enable `qe` latched signal of software write pulse
      hwre:     "true",
      fields: [
        {
          bits: "5+3:5", // 2 bits for status
          name: "CL_STATUS",
          desc: "Contain the current status of the corresponding cache line                [0]: valid, [1]: dirty, [2]: cmpt",
        }
      ]
    },
    { name:     "TAG_599",
      desc:     "Tag Address stored in cache line 599",
      swaccess: "rw",
      hwaccess: "hrw",
      hwext:    "true",
      hwqe:     "true", // enable `qe` latched signal of software write pulse
      hwre:     "true",
      fields: [
        { bits: "5-1:0",
          name: "CL_TAG",
          desc: "Tag Address"
        }
      ]
    },
    {
      name:     "STATUS_600",
      desc:     "Status register of cache line 600",
      swaccess: "rw",
      hwaccess: "hrw",
      hwext:    "true",
      hwqe:     "true", // enable `qe` latched signal of software write pulse
      hwre:     "true",
      fields: [
        {
          bits: "5+3:5", // 2 bits for status
          name: "CL_STATUS",
          desc: "Contain the current status of the corresponding cache line                [0]: valid, [1]: dirty, [2]: cmpt",
        }
      ]
    },
    { name:     "TAG_600",
      desc:     "Tag Address stored in cache line 600",
      swaccess: "rw",
      hwaccess: "hrw",
      hwext:    "true",
      hwqe:     "true", // enable `qe` latched signal of software write pulse
      hwre:     "true",
      fields: [
        { bits: "5-1:0",
          name: "CL_TAG",
          desc: "Tag Address"
        }
      ]
    },
    {
      name:     "STATUS_601",
      desc:     "Status register of cache line 601",
      swaccess: "rw",
      hwaccess: "hrw",
      hwext:    "true",
      hwqe:     "true", // enable `qe` latched signal of software write pulse
      hwre:     "true",
      fields: [
        {
          bits: "5+3:5", // 2 bits for status
          name: "CL_STATUS",
          desc: "Contain the current status of the corresponding cache line                [0]: valid, [1]: dirty, [2]: cmpt",
        }
      ]
    },
    { name:     "TAG_601",
      desc:     "Tag Address stored in cache line 601",
      swaccess: "rw",
      hwaccess: "hrw",
      hwext:    "true",
      hwqe:     "true", // enable `qe` latched signal of software write pulse
      hwre:     "true",
      fields: [
        { bits: "5-1:0",
          name: "CL_TAG",
          desc: "Tag Address"
        }
      ]
    },
    {
      name:     "STATUS_602",
      desc:     "Status register of cache line 602",
      swaccess: "rw",
      hwaccess: "hrw",
      hwext:    "true",
      hwqe:     "true", // enable `qe` latched signal of software write pulse
      hwre:     "true",
      fields: [
        {
          bits: "5+3:5", // 2 bits for status
          name: "CL_STATUS",
          desc: "Contain the current status of the corresponding cache line                [0]: valid, [1]: dirty, [2]: cmpt",
        }
      ]
    },
    { name:     "TAG_602",
      desc:     "Tag Address stored in cache line 602",
      swaccess: "rw",
      hwaccess: "hrw",
      hwext:    "true",
      hwqe:     "true", // enable `qe` latched signal of software write pulse
      hwre:     "true",
      fields: [
        { bits: "5-1:0",
          name: "CL_TAG",
          desc: "Tag Address"
        }
      ]
    },
    {
      name:     "STATUS_603",
      desc:     "Status register of cache line 603",
      swaccess: "rw",
      hwaccess: "hrw",
      hwext:    "true",
      hwqe:     "true", // enable `qe` latched signal of software write pulse
      hwre:     "true",
      fields: [
        {
          bits: "5+3:5", // 2 bits for status
          name: "CL_STATUS",
          desc: "Contain the current status of the corresponding cache line                [0]: valid, [1]: dirty, [2]: cmpt",
        }
      ]
    },
    { name:     "TAG_603",
      desc:     "Tag Address stored in cache line 603",
      swaccess: "rw",
      hwaccess: "hrw",
      hwext:    "true",
      hwqe:     "true", // enable `qe` latched signal of software write pulse
      hwre:     "true",
      fields: [
        { bits: "5-1:0",
          name: "CL_TAG",
          desc: "Tag Address"
        }
      ]
    },
    {
      name:     "STATUS_604",
      desc:     "Status register of cache line 604",
      swaccess: "rw",
      hwaccess: "hrw",
      hwext:    "true",
      hwqe:     "true", // enable `qe` latched signal of software write pulse
      hwre:     "true",
      fields: [
        {
          bits: "5+3:5", // 2 bits for status
          name: "CL_STATUS",
          desc: "Contain the current status of the corresponding cache line                [0]: valid, [1]: dirty, [2]: cmpt",
        }
      ]
    },
    { name:     "TAG_604",
      desc:     "Tag Address stored in cache line 604",
      swaccess: "rw",
      hwaccess: "hrw",
      hwext:    "true",
      hwqe:     "true", // enable `qe` latched signal of software write pulse
      hwre:     "true",
      fields: [
        { bits: "5-1:0",
          name: "CL_TAG",
          desc: "Tag Address"
        }
      ]
    },
    {
      name:     "STATUS_605",
      desc:     "Status register of cache line 605",
      swaccess: "rw",
      hwaccess: "hrw",
      hwext:    "true",
      hwqe:     "true", // enable `qe` latched signal of software write pulse
      hwre:     "true",
      fields: [
        {
          bits: "5+3:5", // 2 bits for status
          name: "CL_STATUS",
          desc: "Contain the current status of the corresponding cache line                [0]: valid, [1]: dirty, [2]: cmpt",
        }
      ]
    },
    { name:     "TAG_605",
      desc:     "Tag Address stored in cache line 605",
      swaccess: "rw",
      hwaccess: "hrw",
      hwext:    "true",
      hwqe:     "true", // enable `qe` latched signal of software write pulse
      hwre:     "true",
      fields: [
        { bits: "5-1:0",
          name: "CL_TAG",
          desc: "Tag Address"
        }
      ]
    },
    {
      name:     "STATUS_606",
      desc:     "Status register of cache line 606",
      swaccess: "rw",
      hwaccess: "hrw",
      hwext:    "true",
      hwqe:     "true", // enable `qe` latched signal of software write pulse
      hwre:     "true",
      fields: [
        {
          bits: "5+3:5", // 2 bits for status
          name: "CL_STATUS",
          desc: "Contain the current status of the corresponding cache line                [0]: valid, [1]: dirty, [2]: cmpt",
        }
      ]
    },
    { name:     "TAG_606",
      desc:     "Tag Address stored in cache line 606",
      swaccess: "rw",
      hwaccess: "hrw",
      hwext:    "true",
      hwqe:     "true", // enable `qe` latched signal of software write pulse
      hwre:     "true",
      fields: [
        { bits: "5-1:0",
          name: "CL_TAG",
          desc: "Tag Address"
        }
      ]
    },
    {
      name:     "STATUS_607",
      desc:     "Status register of cache line 607",
      swaccess: "rw",
      hwaccess: "hrw",
      hwext:    "true",
      hwqe:     "true", // enable `qe` latched signal of software write pulse
      hwre:     "true",
      fields: [
        {
          bits: "5+3:5", // 2 bits for status
          name: "CL_STATUS",
          desc: "Contain the current status of the corresponding cache line                [0]: valid, [1]: dirty, [2]: cmpt",
        }
      ]
    },
    { name:     "TAG_607",
      desc:     "Tag Address stored in cache line 607",
      swaccess: "rw",
      hwaccess: "hrw",
      hwext:    "true",
      hwqe:     "true", // enable `qe` latched signal of software write pulse
      hwre:     "true",
      fields: [
        { bits: "5-1:0",
          name: "CL_TAG",
          desc: "Tag Address"
        }
      ]
    },
    {
      name:     "STATUS_608",
      desc:     "Status register of cache line 608",
      swaccess: "rw",
      hwaccess: "hrw",
      hwext:    "true",
      hwqe:     "true", // enable `qe` latched signal of software write pulse
      hwre:     "true",
      fields: [
        {
          bits: "5+3:5", // 2 bits for status
          name: "CL_STATUS",
          desc: "Contain the current status of the corresponding cache line                [0]: valid, [1]: dirty, [2]: cmpt",
        }
      ]
    },
    { name:     "TAG_608",
      desc:     "Tag Address stored in cache line 608",
      swaccess: "rw",
      hwaccess: "hrw",
      hwext:    "true",
      hwqe:     "true", // enable `qe` latched signal of software write pulse
      hwre:     "true",
      fields: [
        { bits: "5-1:0",
          name: "CL_TAG",
          desc: "Tag Address"
        }
      ]
    },
    {
      name:     "STATUS_609",
      desc:     "Status register of cache line 609",
      swaccess: "rw",
      hwaccess: "hrw",
      hwext:    "true",
      hwqe:     "true", // enable `qe` latched signal of software write pulse
      hwre:     "true",
      fields: [
        {
          bits: "5+3:5", // 2 bits for status
          name: "CL_STATUS",
          desc: "Contain the current status of the corresponding cache line                [0]: valid, [1]: dirty, [2]: cmpt",
        }
      ]
    },
    { name:     "TAG_609",
      desc:     "Tag Address stored in cache line 609",
      swaccess: "rw",
      hwaccess: "hrw",
      hwext:    "true",
      hwqe:     "true", // enable `qe` latched signal of software write pulse
      hwre:     "true",
      fields: [
        { bits: "5-1:0",
          name: "CL_TAG",
          desc: "Tag Address"
        }
      ]
    },
    {
      name:     "STATUS_610",
      desc:     "Status register of cache line 610",
      swaccess: "rw",
      hwaccess: "hrw",
      hwext:    "true",
      hwqe:     "true", // enable `qe` latched signal of software write pulse
      hwre:     "true",
      fields: [
        {
          bits: "5+3:5", // 2 bits for status
          name: "CL_STATUS",
          desc: "Contain the current status of the corresponding cache line                [0]: valid, [1]: dirty, [2]: cmpt",
        }
      ]
    },
    { name:     "TAG_610",
      desc:     "Tag Address stored in cache line 610",
      swaccess: "rw",
      hwaccess: "hrw",
      hwext:    "true",
      hwqe:     "true", // enable `qe` latched signal of software write pulse
      hwre:     "true",
      fields: [
        { bits: "5-1:0",
          name: "CL_TAG",
          desc: "Tag Address"
        }
      ]
    },
    {
      name:     "STATUS_611",
      desc:     "Status register of cache line 611",
      swaccess: "rw",
      hwaccess: "hrw",
      hwext:    "true",
      hwqe:     "true", // enable `qe` latched signal of software write pulse
      hwre:     "true",
      fields: [
        {
          bits: "5+3:5", // 2 bits for status
          name: "CL_STATUS",
          desc: "Contain the current status of the corresponding cache line                [0]: valid, [1]: dirty, [2]: cmpt",
        }
      ]
    },
    { name:     "TAG_611",
      desc:     "Tag Address stored in cache line 611",
      swaccess: "rw",
      hwaccess: "hrw",
      hwext:    "true",
      hwqe:     "true", // enable `qe` latched signal of software write pulse
      hwre:     "true",
      fields: [
        { bits: "5-1:0",
          name: "CL_TAG",
          desc: "Tag Address"
        }
      ]
    },
    {
      name:     "STATUS_612",
      desc:     "Status register of cache line 612",
      swaccess: "rw",
      hwaccess: "hrw",
      hwext:    "true",
      hwqe:     "true", // enable `qe` latched signal of software write pulse
      hwre:     "true",
      fields: [
        {
          bits: "5+3:5", // 2 bits for status
          name: "CL_STATUS",
          desc: "Contain the current status of the corresponding cache line                [0]: valid, [1]: dirty, [2]: cmpt",
        }
      ]
    },
    { name:     "TAG_612",
      desc:     "Tag Address stored in cache line 612",
      swaccess: "rw",
      hwaccess: "hrw",
      hwext:    "true",
      hwqe:     "true", // enable `qe` latched signal of software write pulse
      hwre:     "true",
      fields: [
        { bits: "5-1:0",
          name: "CL_TAG",
          desc: "Tag Address"
        }
      ]
    },
    {
      name:     "STATUS_613",
      desc:     "Status register of cache line 613",
      swaccess: "rw",
      hwaccess: "hrw",
      hwext:    "true",
      hwqe:     "true", // enable `qe` latched signal of software write pulse
      hwre:     "true",
      fields: [
        {
          bits: "5+3:5", // 2 bits for status
          name: "CL_STATUS",
          desc: "Contain the current status of the corresponding cache line                [0]: valid, [1]: dirty, [2]: cmpt",
        }
      ]
    },
    { name:     "TAG_613",
      desc:     "Tag Address stored in cache line 613",
      swaccess: "rw",
      hwaccess: "hrw",
      hwext:    "true",
      hwqe:     "true", // enable `qe` latched signal of software write pulse
      hwre:     "true",
      fields: [
        { bits: "5-1:0",
          name: "CL_TAG",
          desc: "Tag Address"
        }
      ]
    },
    {
      name:     "STATUS_614",
      desc:     "Status register of cache line 614",
      swaccess: "rw",
      hwaccess: "hrw",
      hwext:    "true",
      hwqe:     "true", // enable `qe` latched signal of software write pulse
      hwre:     "true",
      fields: [
        {
          bits: "5+3:5", // 2 bits for status
          name: "CL_STATUS",
          desc: "Contain the current status of the corresponding cache line                [0]: valid, [1]: dirty, [2]: cmpt",
        }
      ]
    },
    { name:     "TAG_614",
      desc:     "Tag Address stored in cache line 614",
      swaccess: "rw",
      hwaccess: "hrw",
      hwext:    "true",
      hwqe:     "true", // enable `qe` latched signal of software write pulse
      hwre:     "true",
      fields: [
        { bits: "5-1:0",
          name: "CL_TAG",
          desc: "Tag Address"
        }
      ]
    },
    {
      name:     "STATUS_615",
      desc:     "Status register of cache line 615",
      swaccess: "rw",
      hwaccess: "hrw",
      hwext:    "true",
      hwqe:     "true", // enable `qe` latched signal of software write pulse
      hwre:     "true",
      fields: [
        {
          bits: "5+3:5", // 2 bits for status
          name: "CL_STATUS",
          desc: "Contain the current status of the corresponding cache line                [0]: valid, [1]: dirty, [2]: cmpt",
        }
      ]
    },
    { name:     "TAG_615",
      desc:     "Tag Address stored in cache line 615",
      swaccess: "rw",
      hwaccess: "hrw",
      hwext:    "true",
      hwqe:     "true", // enable `qe` latched signal of software write pulse
      hwre:     "true",
      fields: [
        { bits: "5-1:0",
          name: "CL_TAG",
          desc: "Tag Address"
        }
      ]
    },
    {
      name:     "STATUS_616",
      desc:     "Status register of cache line 616",
      swaccess: "rw",
      hwaccess: "hrw",
      hwext:    "true",
      hwqe:     "true", // enable `qe` latched signal of software write pulse
      hwre:     "true",
      fields: [
        {
          bits: "5+3:5", // 2 bits for status
          name: "CL_STATUS",
          desc: "Contain the current status of the corresponding cache line                [0]: valid, [1]: dirty, [2]: cmpt",
        }
      ]
    },
    { name:     "TAG_616",
      desc:     "Tag Address stored in cache line 616",
      swaccess: "rw",
      hwaccess: "hrw",
      hwext:    "true",
      hwqe:     "true", // enable `qe` latched signal of software write pulse
      hwre:     "true",
      fields: [
        { bits: "5-1:0",
          name: "CL_TAG",
          desc: "Tag Address"
        }
      ]
    },
    {
      name:     "STATUS_617",
      desc:     "Status register of cache line 617",
      swaccess: "rw",
      hwaccess: "hrw",
      hwext:    "true",
      hwqe:     "true", // enable `qe` latched signal of software write pulse
      hwre:     "true",
      fields: [
        {
          bits: "5+3:5", // 2 bits for status
          name: "CL_STATUS",
          desc: "Contain the current status of the corresponding cache line                [0]: valid, [1]: dirty, [2]: cmpt",
        }
      ]
    },
    { name:     "TAG_617",
      desc:     "Tag Address stored in cache line 617",
      swaccess: "rw",
      hwaccess: "hrw",
      hwext:    "true",
      hwqe:     "true", // enable `qe` latched signal of software write pulse
      hwre:     "true",
      fields: [
        { bits: "5-1:0",
          name: "CL_TAG",
          desc: "Tag Address"
        }
      ]
    },
    {
      name:     "STATUS_618",
      desc:     "Status register of cache line 618",
      swaccess: "rw",
      hwaccess: "hrw",
      hwext:    "true",
      hwqe:     "true", // enable `qe` latched signal of software write pulse
      hwre:     "true",
      fields: [
        {
          bits: "5+3:5", // 2 bits for status
          name: "CL_STATUS",
          desc: "Contain the current status of the corresponding cache line                [0]: valid, [1]: dirty, [2]: cmpt",
        }
      ]
    },
    { name:     "TAG_618",
      desc:     "Tag Address stored in cache line 618",
      swaccess: "rw",
      hwaccess: "hrw",
      hwext:    "true",
      hwqe:     "true", // enable `qe` latched signal of software write pulse
      hwre:     "true",
      fields: [
        { bits: "5-1:0",
          name: "CL_TAG",
          desc: "Tag Address"
        }
      ]
    },
    {
      name:     "STATUS_619",
      desc:     "Status register of cache line 619",
      swaccess: "rw",
      hwaccess: "hrw",
      hwext:    "true",
      hwqe:     "true", // enable `qe` latched signal of software write pulse
      hwre:     "true",
      fields: [
        {
          bits: "5+3:5", // 2 bits for status
          name: "CL_STATUS",
          desc: "Contain the current status of the corresponding cache line                [0]: valid, [1]: dirty, [2]: cmpt",
        }
      ]
    },
    { name:     "TAG_619",
      desc:     "Tag Address stored in cache line 619",
      swaccess: "rw",
      hwaccess: "hrw",
      hwext:    "true",
      hwqe:     "true", // enable `qe` latched signal of software write pulse
      hwre:     "true",
      fields: [
        { bits: "5-1:0",
          name: "CL_TAG",
          desc: "Tag Address"
        }
      ]
    },
    {
      name:     "STATUS_620",
      desc:     "Status register of cache line 620",
      swaccess: "rw",
      hwaccess: "hrw",
      hwext:    "true",
      hwqe:     "true", // enable `qe` latched signal of software write pulse
      hwre:     "true",
      fields: [
        {
          bits: "5+3:5", // 2 bits for status
          name: "CL_STATUS",
          desc: "Contain the current status of the corresponding cache line                [0]: valid, [1]: dirty, [2]: cmpt",
        }
      ]
    },
    { name:     "TAG_620",
      desc:     "Tag Address stored in cache line 620",
      swaccess: "rw",
      hwaccess: "hrw",
      hwext:    "true",
      hwqe:     "true", // enable `qe` latched signal of software write pulse
      hwre:     "true",
      fields: [
        { bits: "5-1:0",
          name: "CL_TAG",
          desc: "Tag Address"
        }
      ]
    },
    {
      name:     "STATUS_621",
      desc:     "Status register of cache line 621",
      swaccess: "rw",
      hwaccess: "hrw",
      hwext:    "true",
      hwqe:     "true", // enable `qe` latched signal of software write pulse
      hwre:     "true",
      fields: [
        {
          bits: "5+3:5", // 2 bits for status
          name: "CL_STATUS",
          desc: "Contain the current status of the corresponding cache line                [0]: valid, [1]: dirty, [2]: cmpt",
        }
      ]
    },
    { name:     "TAG_621",
      desc:     "Tag Address stored in cache line 621",
      swaccess: "rw",
      hwaccess: "hrw",
      hwext:    "true",
      hwqe:     "true", // enable `qe` latched signal of software write pulse
      hwre:     "true",
      fields: [
        { bits: "5-1:0",
          name: "CL_TAG",
          desc: "Tag Address"
        }
      ]
    },
    {
      name:     "STATUS_622",
      desc:     "Status register of cache line 622",
      swaccess: "rw",
      hwaccess: "hrw",
      hwext:    "true",
      hwqe:     "true", // enable `qe` latched signal of software write pulse
      hwre:     "true",
      fields: [
        {
          bits: "5+3:5", // 2 bits for status
          name: "CL_STATUS",
          desc: "Contain the current status of the corresponding cache line                [0]: valid, [1]: dirty, [2]: cmpt",
        }
      ]
    },
    { name:     "TAG_622",
      desc:     "Tag Address stored in cache line 622",
      swaccess: "rw",
      hwaccess: "hrw",
      hwext:    "true",
      hwqe:     "true", // enable `qe` latched signal of software write pulse
      hwre:     "true",
      fields: [
        { bits: "5-1:0",
          name: "CL_TAG",
          desc: "Tag Address"
        }
      ]
    },
    {
      name:     "STATUS_623",
      desc:     "Status register of cache line 623",
      swaccess: "rw",
      hwaccess: "hrw",
      hwext:    "true",
      hwqe:     "true", // enable `qe` latched signal of software write pulse
      hwre:     "true",
      fields: [
        {
          bits: "5+3:5", // 2 bits for status
          name: "CL_STATUS",
          desc: "Contain the current status of the corresponding cache line                [0]: valid, [1]: dirty, [2]: cmpt",
        }
      ]
    },
    { name:     "TAG_623",
      desc:     "Tag Address stored in cache line 623",
      swaccess: "rw",
      hwaccess: "hrw",
      hwext:    "true",
      hwqe:     "true", // enable `qe` latched signal of software write pulse
      hwre:     "true",
      fields: [
        { bits: "5-1:0",
          name: "CL_TAG",
          desc: "Tag Address"
        }
      ]
    },
    {
      name:     "STATUS_624",
      desc:     "Status register of cache line 624",
      swaccess: "rw",
      hwaccess: "hrw",
      hwext:    "true",
      hwqe:     "true", // enable `qe` latched signal of software write pulse
      hwre:     "true",
      fields: [
        {
          bits: "5+3:5", // 2 bits for status
          name: "CL_STATUS",
          desc: "Contain the current status of the corresponding cache line                [0]: valid, [1]: dirty, [2]: cmpt",
        }
      ]
    },
    { name:     "TAG_624",
      desc:     "Tag Address stored in cache line 624",
      swaccess: "rw",
      hwaccess: "hrw",
      hwext:    "true",
      hwqe:     "true", // enable `qe` latched signal of software write pulse
      hwre:     "true",
      fields: [
        { bits: "5-1:0",
          name: "CL_TAG",
          desc: "Tag Address"
        }
      ]
    },
    {
      name:     "STATUS_625",
      desc:     "Status register of cache line 625",
      swaccess: "rw",
      hwaccess: "hrw",
      hwext:    "true",
      hwqe:     "true", // enable `qe` latched signal of software write pulse
      hwre:     "true",
      fields: [
        {
          bits: "5+3:5", // 2 bits for status
          name: "CL_STATUS",
          desc: "Contain the current status of the corresponding cache line                [0]: valid, [1]: dirty, [2]: cmpt",
        }
      ]
    },
    { name:     "TAG_625",
      desc:     "Tag Address stored in cache line 625",
      swaccess: "rw",
      hwaccess: "hrw",
      hwext:    "true",
      hwqe:     "true", // enable `qe` latched signal of software write pulse
      hwre:     "true",
      fields: [
        { bits: "5-1:0",
          name: "CL_TAG",
          desc: "Tag Address"
        }
      ]
    },
    {
      name:     "STATUS_626",
      desc:     "Status register of cache line 626",
      swaccess: "rw",
      hwaccess: "hrw",
      hwext:    "true",
      hwqe:     "true", // enable `qe` latched signal of software write pulse
      hwre:     "true",
      fields: [
        {
          bits: "5+3:5", // 2 bits for status
          name: "CL_STATUS",
          desc: "Contain the current status of the corresponding cache line                [0]: valid, [1]: dirty, [2]: cmpt",
        }
      ]
    },
    { name:     "TAG_626",
      desc:     "Tag Address stored in cache line 626",
      swaccess: "rw",
      hwaccess: "hrw",
      hwext:    "true",
      hwqe:     "true", // enable `qe` latched signal of software write pulse
      hwre:     "true",
      fields: [
        { bits: "5-1:0",
          name: "CL_TAG",
          desc: "Tag Address"
        }
      ]
    },
    {
      name:     "STATUS_627",
      desc:     "Status register of cache line 627",
      swaccess: "rw",
      hwaccess: "hrw",
      hwext:    "true",
      hwqe:     "true", // enable `qe` latched signal of software write pulse
      hwre:     "true",
      fields: [
        {
          bits: "5+3:5", // 2 bits for status
          name: "CL_STATUS",
          desc: "Contain the current status of the corresponding cache line                [0]: valid, [1]: dirty, [2]: cmpt",
        }
      ]
    },
    { name:     "TAG_627",
      desc:     "Tag Address stored in cache line 627",
      swaccess: "rw",
      hwaccess: "hrw",
      hwext:    "true",
      hwqe:     "true", // enable `qe` latched signal of software write pulse
      hwre:     "true",
      fields: [
        { bits: "5-1:0",
          name: "CL_TAG",
          desc: "Tag Address"
        }
      ]
    },
    {
      name:     "STATUS_628",
      desc:     "Status register of cache line 628",
      swaccess: "rw",
      hwaccess: "hrw",
      hwext:    "true",
      hwqe:     "true", // enable `qe` latched signal of software write pulse
      hwre:     "true",
      fields: [
        {
          bits: "5+3:5", // 2 bits for status
          name: "CL_STATUS",
          desc: "Contain the current status of the corresponding cache line                [0]: valid, [1]: dirty, [2]: cmpt",
        }
      ]
    },
    { name:     "TAG_628",
      desc:     "Tag Address stored in cache line 628",
      swaccess: "rw",
      hwaccess: "hrw",
      hwext:    "true",
      hwqe:     "true", // enable `qe` latched signal of software write pulse
      hwre:     "true",
      fields: [
        { bits: "5-1:0",
          name: "CL_TAG",
          desc: "Tag Address"
        }
      ]
    },
    {
      name:     "STATUS_629",
      desc:     "Status register of cache line 629",
      swaccess: "rw",
      hwaccess: "hrw",
      hwext:    "true",
      hwqe:     "true", // enable `qe` latched signal of software write pulse
      hwre:     "true",
      fields: [
        {
          bits: "5+3:5", // 2 bits for status
          name: "CL_STATUS",
          desc: "Contain the current status of the corresponding cache line                [0]: valid, [1]: dirty, [2]: cmpt",
        }
      ]
    },
    { name:     "TAG_629",
      desc:     "Tag Address stored in cache line 629",
      swaccess: "rw",
      hwaccess: "hrw",
      hwext:    "true",
      hwqe:     "true", // enable `qe` latched signal of software write pulse
      hwre:     "true",
      fields: [
        { bits: "5-1:0",
          name: "CL_TAG",
          desc: "Tag Address"
        }
      ]
    },
    {
      name:     "STATUS_630",
      desc:     "Status register of cache line 630",
      swaccess: "rw",
      hwaccess: "hrw",
      hwext:    "true",
      hwqe:     "true", // enable `qe` latched signal of software write pulse
      hwre:     "true",
      fields: [
        {
          bits: "5+3:5", // 2 bits for status
          name: "CL_STATUS",
          desc: "Contain the current status of the corresponding cache line                [0]: valid, [1]: dirty, [2]: cmpt",
        }
      ]
    },
    { name:     "TAG_630",
      desc:     "Tag Address stored in cache line 630",
      swaccess: "rw",
      hwaccess: "hrw",
      hwext:    "true",
      hwqe:     "true", // enable `qe` latched signal of software write pulse
      hwre:     "true",
      fields: [
        { bits: "5-1:0",
          name: "CL_TAG",
          desc: "Tag Address"
        }
      ]
    },
    {
      name:     "STATUS_631",
      desc:     "Status register of cache line 631",
      swaccess: "rw",
      hwaccess: "hrw",
      hwext:    "true",
      hwqe:     "true", // enable `qe` latched signal of software write pulse
      hwre:     "true",
      fields: [
        {
          bits: "5+3:5", // 2 bits for status
          name: "CL_STATUS",
          desc: "Contain the current status of the corresponding cache line                [0]: valid, [1]: dirty, [2]: cmpt",
        }
      ]
    },
    { name:     "TAG_631",
      desc:     "Tag Address stored in cache line 631",
      swaccess: "rw",
      hwaccess: "hrw",
      hwext:    "true",
      hwqe:     "true", // enable `qe` latched signal of software write pulse
      hwre:     "true",
      fields: [
        { bits: "5-1:0",
          name: "CL_TAG",
          desc: "Tag Address"
        }
      ]
    },
    {
      name:     "STATUS_632",
      desc:     "Status register of cache line 632",
      swaccess: "rw",
      hwaccess: "hrw",
      hwext:    "true",
      hwqe:     "true", // enable `qe` latched signal of software write pulse
      hwre:     "true",
      fields: [
        {
          bits: "5+3:5", // 2 bits for status
          name: "CL_STATUS",
          desc: "Contain the current status of the corresponding cache line                [0]: valid, [1]: dirty, [2]: cmpt",
        }
      ]
    },
    { name:     "TAG_632",
      desc:     "Tag Address stored in cache line 632",
      swaccess: "rw",
      hwaccess: "hrw",
      hwext:    "true",
      hwqe:     "true", // enable `qe` latched signal of software write pulse
      hwre:     "true",
      fields: [
        { bits: "5-1:0",
          name: "CL_TAG",
          desc: "Tag Address"
        }
      ]
    },
    {
      name:     "STATUS_633",
      desc:     "Status register of cache line 633",
      swaccess: "rw",
      hwaccess: "hrw",
      hwext:    "true",
      hwqe:     "true", // enable `qe` latched signal of software write pulse
      hwre:     "true",
      fields: [
        {
          bits: "5+3:5", // 2 bits for status
          name: "CL_STATUS",
          desc: "Contain the current status of the corresponding cache line                [0]: valid, [1]: dirty, [2]: cmpt",
        }
      ]
    },
    { name:     "TAG_633",
      desc:     "Tag Address stored in cache line 633",
      swaccess: "rw",
      hwaccess: "hrw",
      hwext:    "true",
      hwqe:     "true", // enable `qe` latched signal of software write pulse
      hwre:     "true",
      fields: [
        { bits: "5-1:0",
          name: "CL_TAG",
          desc: "Tag Address"
        }
      ]
    },
    {
      name:     "STATUS_634",
      desc:     "Status register of cache line 634",
      swaccess: "rw",
      hwaccess: "hrw",
      hwext:    "true",
      hwqe:     "true", // enable `qe` latched signal of software write pulse
      hwre:     "true",
      fields: [
        {
          bits: "5+3:5", // 2 bits for status
          name: "CL_STATUS",
          desc: "Contain the current status of the corresponding cache line                [0]: valid, [1]: dirty, [2]: cmpt",
        }
      ]
    },
    { name:     "TAG_634",
      desc:     "Tag Address stored in cache line 634",
      swaccess: "rw",
      hwaccess: "hrw",
      hwext:    "true",
      hwqe:     "true", // enable `qe` latched signal of software write pulse
      hwre:     "true",
      fields: [
        { bits: "5-1:0",
          name: "CL_TAG",
          desc: "Tag Address"
        }
      ]
    },
    {
      name:     "STATUS_635",
      desc:     "Status register of cache line 635",
      swaccess: "rw",
      hwaccess: "hrw",
      hwext:    "true",
      hwqe:     "true", // enable `qe` latched signal of software write pulse
      hwre:     "true",
      fields: [
        {
          bits: "5+3:5", // 2 bits for status
          name: "CL_STATUS",
          desc: "Contain the current status of the corresponding cache line                [0]: valid, [1]: dirty, [2]: cmpt",
        }
      ]
    },
    { name:     "TAG_635",
      desc:     "Tag Address stored in cache line 635",
      swaccess: "rw",
      hwaccess: "hrw",
      hwext:    "true",
      hwqe:     "true", // enable `qe` latched signal of software write pulse
      hwre:     "true",
      fields: [
        { bits: "5-1:0",
          name: "CL_TAG",
          desc: "Tag Address"
        }
      ]
    },
    {
      name:     "STATUS_636",
      desc:     "Status register of cache line 636",
      swaccess: "rw",
      hwaccess: "hrw",
      hwext:    "true",
      hwqe:     "true", // enable `qe` latched signal of software write pulse
      hwre:     "true",
      fields: [
        {
          bits: "5+3:5", // 2 bits for status
          name: "CL_STATUS",
          desc: "Contain the current status of the corresponding cache line                [0]: valid, [1]: dirty, [2]: cmpt",
        }
      ]
    },
    { name:     "TAG_636",
      desc:     "Tag Address stored in cache line 636",
      swaccess: "rw",
      hwaccess: "hrw",
      hwext:    "true",
      hwqe:     "true", // enable `qe` latched signal of software write pulse
      hwre:     "true",
      fields: [
        { bits: "5-1:0",
          name: "CL_TAG",
          desc: "Tag Address"
        }
      ]
    },
    {
      name:     "STATUS_637",
      desc:     "Status register of cache line 637",
      swaccess: "rw",
      hwaccess: "hrw",
      hwext:    "true",
      hwqe:     "true", // enable `qe` latched signal of software write pulse
      hwre:     "true",
      fields: [
        {
          bits: "5+3:5", // 2 bits for status
          name: "CL_STATUS",
          desc: "Contain the current status of the corresponding cache line                [0]: valid, [1]: dirty, [2]: cmpt",
        }
      ]
    },
    { name:     "TAG_637",
      desc:     "Tag Address stored in cache line 637",
      swaccess: "rw",
      hwaccess: "hrw",
      hwext:    "true",
      hwqe:     "true", // enable `qe` latched signal of software write pulse
      hwre:     "true",
      fields: [
        { bits: "5-1:0",
          name: "CL_TAG",
          desc: "Tag Address"
        }
      ]
    },
    {
      name:     "STATUS_638",
      desc:     "Status register of cache line 638",
      swaccess: "rw",
      hwaccess: "hrw",
      hwext:    "true",
      hwqe:     "true", // enable `qe` latched signal of software write pulse
      hwre:     "true",
      fields: [
        {
          bits: "5+3:5", // 2 bits for status
          name: "CL_STATUS",
          desc: "Contain the current status of the corresponding cache line                [0]: valid, [1]: dirty, [2]: cmpt",
        }
      ]
    },
    { name:     "TAG_638",
      desc:     "Tag Address stored in cache line 638",
      swaccess: "rw",
      hwaccess: "hrw",
      hwext:    "true",
      hwqe:     "true", // enable `qe` latched signal of software write pulse
      hwre:     "true",
      fields: [
        { bits: "5-1:0",
          name: "CL_TAG",
          desc: "Tag Address"
        }
      ]
    },
    {
      name:     "STATUS_639",
      desc:     "Status register of cache line 639",
      swaccess: "rw",
      hwaccess: "hrw",
      hwext:    "true",
      hwqe:     "true", // enable `qe` latched signal of software write pulse
      hwre:     "true",
      fields: [
        {
          bits: "5+3:5", // 2 bits for status
          name: "CL_STATUS",
          desc: "Contain the current status of the corresponding cache line                [0]: valid, [1]: dirty, [2]: cmpt",
        }
      ]
    },
    { name:     "TAG_639",
      desc:     "Tag Address stored in cache line 639",
      swaccess: "rw",
      hwaccess: "hrw",
      hwext:    "true",
      hwqe:     "true", // enable `qe` latched signal of software write pulse
      hwre:     "true",
      fields: [
        { bits: "5-1:0",
          name: "CL_TAG",
          desc: "Tag Address"
        }
      ]
    },
    {
      name:     "STATUS_640",
      desc:     "Status register of cache line 640",
      swaccess: "rw",
      hwaccess: "hrw",
      hwext:    "true",
      hwqe:     "true", // enable `qe` latched signal of software write pulse
      hwre:     "true",
      fields: [
        {
          bits: "5+3:5", // 2 bits for status
          name: "CL_STATUS",
          desc: "Contain the current status of the corresponding cache line                [0]: valid, [1]: dirty, [2]: cmpt",
        }
      ]
    },
    { name:     "TAG_640",
      desc:     "Tag Address stored in cache line 640",
      swaccess: "rw",
      hwaccess: "hrw",
      hwext:    "true",
      hwqe:     "true", // enable `qe` latched signal of software write pulse
      hwre:     "true",
      fields: [
        { bits: "5-1:0",
          name: "CL_TAG",
          desc: "Tag Address"
        }
      ]
    },
    {
      name:     "STATUS_641",
      desc:     "Status register of cache line 641",
      swaccess: "rw",
      hwaccess: "hrw",
      hwext:    "true",
      hwqe:     "true", // enable `qe` latched signal of software write pulse
      hwre:     "true",
      fields: [
        {
          bits: "5+3:5", // 2 bits for status
          name: "CL_STATUS",
          desc: "Contain the current status of the corresponding cache line                [0]: valid, [1]: dirty, [2]: cmpt",
        }
      ]
    },
    { name:     "TAG_641",
      desc:     "Tag Address stored in cache line 641",
      swaccess: "rw",
      hwaccess: "hrw",
      hwext:    "true",
      hwqe:     "true", // enable `qe` latched signal of software write pulse
      hwre:     "true",
      fields: [
        { bits: "5-1:0",
          name: "CL_TAG",
          desc: "Tag Address"
        }
      ]
    },
    {
      name:     "STATUS_642",
      desc:     "Status register of cache line 642",
      swaccess: "rw",
      hwaccess: "hrw",
      hwext:    "true",
      hwqe:     "true", // enable `qe` latched signal of software write pulse
      hwre:     "true",
      fields: [
        {
          bits: "5+3:5", // 2 bits for status
          name: "CL_STATUS",
          desc: "Contain the current status of the corresponding cache line                [0]: valid, [1]: dirty, [2]: cmpt",
        }
      ]
    },
    { name:     "TAG_642",
      desc:     "Tag Address stored in cache line 642",
      swaccess: "rw",
      hwaccess: "hrw",
      hwext:    "true",
      hwqe:     "true", // enable `qe` latched signal of software write pulse
      hwre:     "true",
      fields: [
        { bits: "5-1:0",
          name: "CL_TAG",
          desc: "Tag Address"
        }
      ]
    },
    {
      name:     "STATUS_643",
      desc:     "Status register of cache line 643",
      swaccess: "rw",
      hwaccess: "hrw",
      hwext:    "true",
      hwqe:     "true", // enable `qe` latched signal of software write pulse
      hwre:     "true",
      fields: [
        {
          bits: "5+3:5", // 2 bits for status
          name: "CL_STATUS",
          desc: "Contain the current status of the corresponding cache line                [0]: valid, [1]: dirty, [2]: cmpt",
        }
      ]
    },
    { name:     "TAG_643",
      desc:     "Tag Address stored in cache line 643",
      swaccess: "rw",
      hwaccess: "hrw",
      hwext:    "true",
      hwqe:     "true", // enable `qe` latched signal of software write pulse
      hwre:     "true",
      fields: [
        { bits: "5-1:0",
          name: "CL_TAG",
          desc: "Tag Address"
        }
      ]
    },
    {
      name:     "STATUS_644",
      desc:     "Status register of cache line 644",
      swaccess: "rw",
      hwaccess: "hrw",
      hwext:    "true",
      hwqe:     "true", // enable `qe` latched signal of software write pulse
      hwre:     "true",
      fields: [
        {
          bits: "5+3:5", // 2 bits for status
          name: "CL_STATUS",
          desc: "Contain the current status of the corresponding cache line                [0]: valid, [1]: dirty, [2]: cmpt",
        }
      ]
    },
    { name:     "TAG_644",
      desc:     "Tag Address stored in cache line 644",
      swaccess: "rw",
      hwaccess: "hrw",
      hwext:    "true",
      hwqe:     "true", // enable `qe` latched signal of software write pulse
      hwre:     "true",
      fields: [
        { bits: "5-1:0",
          name: "CL_TAG",
          desc: "Tag Address"
        }
      ]
    },
    {
      name:     "STATUS_645",
      desc:     "Status register of cache line 645",
      swaccess: "rw",
      hwaccess: "hrw",
      hwext:    "true",
      hwqe:     "true", // enable `qe` latched signal of software write pulse
      hwre:     "true",
      fields: [
        {
          bits: "5+3:5", // 2 bits for status
          name: "CL_STATUS",
          desc: "Contain the current status of the corresponding cache line                [0]: valid, [1]: dirty, [2]: cmpt",
        }
      ]
    },
    { name:     "TAG_645",
      desc:     "Tag Address stored in cache line 645",
      swaccess: "rw",
      hwaccess: "hrw",
      hwext:    "true",
      hwqe:     "true", // enable `qe` latched signal of software write pulse
      hwre:     "true",
      fields: [
        { bits: "5-1:0",
          name: "CL_TAG",
          desc: "Tag Address"
        }
      ]
    },
    {
      name:     "STATUS_646",
      desc:     "Status register of cache line 646",
      swaccess: "rw",
      hwaccess: "hrw",
      hwext:    "true",
      hwqe:     "true", // enable `qe` latched signal of software write pulse
      hwre:     "true",
      fields: [
        {
          bits: "5+3:5", // 2 bits for status
          name: "CL_STATUS",
          desc: "Contain the current status of the corresponding cache line                [0]: valid, [1]: dirty, [2]: cmpt",
        }
      ]
    },
    { name:     "TAG_646",
      desc:     "Tag Address stored in cache line 646",
      swaccess: "rw",
      hwaccess: "hrw",
      hwext:    "true",
      hwqe:     "true", // enable `qe` latched signal of software write pulse
      hwre:     "true",
      fields: [
        { bits: "5-1:0",
          name: "CL_TAG",
          desc: "Tag Address"
        }
      ]
    },
    {
      name:     "STATUS_647",
      desc:     "Status register of cache line 647",
      swaccess: "rw",
      hwaccess: "hrw",
      hwext:    "true",
      hwqe:     "true", // enable `qe` latched signal of software write pulse
      hwre:     "true",
      fields: [
        {
          bits: "5+3:5", // 2 bits for status
          name: "CL_STATUS",
          desc: "Contain the current status of the corresponding cache line                [0]: valid, [1]: dirty, [2]: cmpt",
        }
      ]
    },
    { name:     "TAG_647",
      desc:     "Tag Address stored in cache line 647",
      swaccess: "rw",
      hwaccess: "hrw",
      hwext:    "true",
      hwqe:     "true", // enable `qe` latched signal of software write pulse
      hwre:     "true",
      fields: [
        { bits: "5-1:0",
          name: "CL_TAG",
          desc: "Tag Address"
        }
      ]
    },
    {
      name:     "STATUS_648",
      desc:     "Status register of cache line 648",
      swaccess: "rw",
      hwaccess: "hrw",
      hwext:    "true",
      hwqe:     "true", // enable `qe` latched signal of software write pulse
      hwre:     "true",
      fields: [
        {
          bits: "5+3:5", // 2 bits for status
          name: "CL_STATUS",
          desc: "Contain the current status of the corresponding cache line                [0]: valid, [1]: dirty, [2]: cmpt",
        }
      ]
    },
    { name:     "TAG_648",
      desc:     "Tag Address stored in cache line 648",
      swaccess: "rw",
      hwaccess: "hrw",
      hwext:    "true",
      hwqe:     "true", // enable `qe` latched signal of software write pulse
      hwre:     "true",
      fields: [
        { bits: "5-1:0",
          name: "CL_TAG",
          desc: "Tag Address"
        }
      ]
    },
    {
      name:     "STATUS_649",
      desc:     "Status register of cache line 649",
      swaccess: "rw",
      hwaccess: "hrw",
      hwext:    "true",
      hwqe:     "true", // enable `qe` latched signal of software write pulse
      hwre:     "true",
      fields: [
        {
          bits: "5+3:5", // 2 bits for status
          name: "CL_STATUS",
          desc: "Contain the current status of the corresponding cache line                [0]: valid, [1]: dirty, [2]: cmpt",
        }
      ]
    },
    { name:     "TAG_649",
      desc:     "Tag Address stored in cache line 649",
      swaccess: "rw",
      hwaccess: "hrw",
      hwext:    "true",
      hwqe:     "true", // enable `qe` latched signal of software write pulse
      hwre:     "true",
      fields: [
        { bits: "5-1:0",
          name: "CL_TAG",
          desc: "Tag Address"
        }
      ]
    },
    {
      name:     "STATUS_650",
      desc:     "Status register of cache line 650",
      swaccess: "rw",
      hwaccess: "hrw",
      hwext:    "true",
      hwqe:     "true", // enable `qe` latched signal of software write pulse
      hwre:     "true",
      fields: [
        {
          bits: "5+3:5", // 2 bits for status
          name: "CL_STATUS",
          desc: "Contain the current status of the corresponding cache line                [0]: valid, [1]: dirty, [2]: cmpt",
        }
      ]
    },
    { name:     "TAG_650",
      desc:     "Tag Address stored in cache line 650",
      swaccess: "rw",
      hwaccess: "hrw",
      hwext:    "true",
      hwqe:     "true", // enable `qe` latched signal of software write pulse
      hwre:     "true",
      fields: [
        { bits: "5-1:0",
          name: "CL_TAG",
          desc: "Tag Address"
        }
      ]
    },
    {
      name:     "STATUS_651",
      desc:     "Status register of cache line 651",
      swaccess: "rw",
      hwaccess: "hrw",
      hwext:    "true",
      hwqe:     "true", // enable `qe` latched signal of software write pulse
      hwre:     "true",
      fields: [
        {
          bits: "5+3:5", // 2 bits for status
          name: "CL_STATUS",
          desc: "Contain the current status of the corresponding cache line                [0]: valid, [1]: dirty, [2]: cmpt",
        }
      ]
    },
    { name:     "TAG_651",
      desc:     "Tag Address stored in cache line 651",
      swaccess: "rw",
      hwaccess: "hrw",
      hwext:    "true",
      hwqe:     "true", // enable `qe` latched signal of software write pulse
      hwre:     "true",
      fields: [
        { bits: "5-1:0",
          name: "CL_TAG",
          desc: "Tag Address"
        }
      ]
    },
    {
      name:     "STATUS_652",
      desc:     "Status register of cache line 652",
      swaccess: "rw",
      hwaccess: "hrw",
      hwext:    "true",
      hwqe:     "true", // enable `qe` latched signal of software write pulse
      hwre:     "true",
      fields: [
        {
          bits: "5+3:5", // 2 bits for status
          name: "CL_STATUS",
          desc: "Contain the current status of the corresponding cache line                [0]: valid, [1]: dirty, [2]: cmpt",
        }
      ]
    },
    { name:     "TAG_652",
      desc:     "Tag Address stored in cache line 652",
      swaccess: "rw",
      hwaccess: "hrw",
      hwext:    "true",
      hwqe:     "true", // enable `qe` latched signal of software write pulse
      hwre:     "true",
      fields: [
        { bits: "5-1:0",
          name: "CL_TAG",
          desc: "Tag Address"
        }
      ]
    },
    {
      name:     "STATUS_653",
      desc:     "Status register of cache line 653",
      swaccess: "rw",
      hwaccess: "hrw",
      hwext:    "true",
      hwqe:     "true", // enable `qe` latched signal of software write pulse
      hwre:     "true",
      fields: [
        {
          bits: "5+3:5", // 2 bits for status
          name: "CL_STATUS",
          desc: "Contain the current status of the corresponding cache line                [0]: valid, [1]: dirty, [2]: cmpt",
        }
      ]
    },
    { name:     "TAG_653",
      desc:     "Tag Address stored in cache line 653",
      swaccess: "rw",
      hwaccess: "hrw",
      hwext:    "true",
      hwqe:     "true", // enable `qe` latched signal of software write pulse
      hwre:     "true",
      fields: [
        { bits: "5-1:0",
          name: "CL_TAG",
          desc: "Tag Address"
        }
      ]
    },
    {
      name:     "STATUS_654",
      desc:     "Status register of cache line 654",
      swaccess: "rw",
      hwaccess: "hrw",
      hwext:    "true",
      hwqe:     "true", // enable `qe` latched signal of software write pulse
      hwre:     "true",
      fields: [
        {
          bits: "5+3:5", // 2 bits for status
          name: "CL_STATUS",
          desc: "Contain the current status of the corresponding cache line                [0]: valid, [1]: dirty, [2]: cmpt",
        }
      ]
    },
    { name:     "TAG_654",
      desc:     "Tag Address stored in cache line 654",
      swaccess: "rw",
      hwaccess: "hrw",
      hwext:    "true",
      hwqe:     "true", // enable `qe` latched signal of software write pulse
      hwre:     "true",
      fields: [
        { bits: "5-1:0",
          name: "CL_TAG",
          desc: "Tag Address"
        }
      ]
    },
    {
      name:     "STATUS_655",
      desc:     "Status register of cache line 655",
      swaccess: "rw",
      hwaccess: "hrw",
      hwext:    "true",
      hwqe:     "true", // enable `qe` latched signal of software write pulse
      hwre:     "true",
      fields: [
        {
          bits: "5+3:5", // 2 bits for status
          name: "CL_STATUS",
          desc: "Contain the current status of the corresponding cache line                [0]: valid, [1]: dirty, [2]: cmpt",
        }
      ]
    },
    { name:     "TAG_655",
      desc:     "Tag Address stored in cache line 655",
      swaccess: "rw",
      hwaccess: "hrw",
      hwext:    "true",
      hwqe:     "true", // enable `qe` latched signal of software write pulse
      hwre:     "true",
      fields: [
        { bits: "5-1:0",
          name: "CL_TAG",
          desc: "Tag Address"
        }
      ]
    },
    {
      name:     "STATUS_656",
      desc:     "Status register of cache line 656",
      swaccess: "rw",
      hwaccess: "hrw",
      hwext:    "true",
      hwqe:     "true", // enable `qe` latched signal of software write pulse
      hwre:     "true",
      fields: [
        {
          bits: "5+3:5", // 2 bits for status
          name: "CL_STATUS",
          desc: "Contain the current status of the corresponding cache line                [0]: valid, [1]: dirty, [2]: cmpt",
        }
      ]
    },
    { name:     "TAG_656",
      desc:     "Tag Address stored in cache line 656",
      swaccess: "rw",
      hwaccess: "hrw",
      hwext:    "true",
      hwqe:     "true", // enable `qe` latched signal of software write pulse
      hwre:     "true",
      fields: [
        { bits: "5-1:0",
          name: "CL_TAG",
          desc: "Tag Address"
        }
      ]
    },
    {
      name:     "STATUS_657",
      desc:     "Status register of cache line 657",
      swaccess: "rw",
      hwaccess: "hrw",
      hwext:    "true",
      hwqe:     "true", // enable `qe` latched signal of software write pulse
      hwre:     "true",
      fields: [
        {
          bits: "5+3:5", // 2 bits for status
          name: "CL_STATUS",
          desc: "Contain the current status of the corresponding cache line                [0]: valid, [1]: dirty, [2]: cmpt",
        }
      ]
    },
    { name:     "TAG_657",
      desc:     "Tag Address stored in cache line 657",
      swaccess: "rw",
      hwaccess: "hrw",
      hwext:    "true",
      hwqe:     "true", // enable `qe` latched signal of software write pulse
      hwre:     "true",
      fields: [
        { bits: "5-1:0",
          name: "CL_TAG",
          desc: "Tag Address"
        }
      ]
    },
    {
      name:     "STATUS_658",
      desc:     "Status register of cache line 658",
      swaccess: "rw",
      hwaccess: "hrw",
      hwext:    "true",
      hwqe:     "true", // enable `qe` latched signal of software write pulse
      hwre:     "true",
      fields: [
        {
          bits: "5+3:5", // 2 bits for status
          name: "CL_STATUS",
          desc: "Contain the current status of the corresponding cache line                [0]: valid, [1]: dirty, [2]: cmpt",
        }
      ]
    },
    { name:     "TAG_658",
      desc:     "Tag Address stored in cache line 658",
      swaccess: "rw",
      hwaccess: "hrw",
      hwext:    "true",
      hwqe:     "true", // enable `qe` latched signal of software write pulse
      hwre:     "true",
      fields: [
        { bits: "5-1:0",
          name: "CL_TAG",
          desc: "Tag Address"
        }
      ]
    },
    {
      name:     "STATUS_659",
      desc:     "Status register of cache line 659",
      swaccess: "rw",
      hwaccess: "hrw",
      hwext:    "true",
      hwqe:     "true", // enable `qe` latched signal of software write pulse
      hwre:     "true",
      fields: [
        {
          bits: "5+3:5", // 2 bits for status
          name: "CL_STATUS",
          desc: "Contain the current status of the corresponding cache line                [0]: valid, [1]: dirty, [2]: cmpt",
        }
      ]
    },
    { name:     "TAG_659",
      desc:     "Tag Address stored in cache line 659",
      swaccess: "rw",
      hwaccess: "hrw",
      hwext:    "true",
      hwqe:     "true", // enable `qe` latched signal of software write pulse
      hwre:     "true",
      fields: [
        { bits: "5-1:0",
          name: "CL_TAG",
          desc: "Tag Address"
        }
      ]
    },
    {
      name:     "STATUS_660",
      desc:     "Status register of cache line 660",
      swaccess: "rw",
      hwaccess: "hrw",
      hwext:    "true",
      hwqe:     "true", // enable `qe` latched signal of software write pulse
      hwre:     "true",
      fields: [
        {
          bits: "5+3:5", // 2 bits for status
          name: "CL_STATUS",
          desc: "Contain the current status of the corresponding cache line                [0]: valid, [1]: dirty, [2]: cmpt",
        }
      ]
    },
    { name:     "TAG_660",
      desc:     "Tag Address stored in cache line 660",
      swaccess: "rw",
      hwaccess: "hrw",
      hwext:    "true",
      hwqe:     "true", // enable `qe` latched signal of software write pulse
      hwre:     "true",
      fields: [
        { bits: "5-1:0",
          name: "CL_TAG",
          desc: "Tag Address"
        }
      ]
    },
    {
      name:     "STATUS_661",
      desc:     "Status register of cache line 661",
      swaccess: "rw",
      hwaccess: "hrw",
      hwext:    "true",
      hwqe:     "true", // enable `qe` latched signal of software write pulse
      hwre:     "true",
      fields: [
        {
          bits: "5+3:5", // 2 bits for status
          name: "CL_STATUS",
          desc: "Contain the current status of the corresponding cache line                [0]: valid, [1]: dirty, [2]: cmpt",
        }
      ]
    },
    { name:     "TAG_661",
      desc:     "Tag Address stored in cache line 661",
      swaccess: "rw",
      hwaccess: "hrw",
      hwext:    "true",
      hwqe:     "true", // enable `qe` latched signal of software write pulse
      hwre:     "true",
      fields: [
        { bits: "5-1:0",
          name: "CL_TAG",
          desc: "Tag Address"
        }
      ]
    },
    {
      name:     "STATUS_662",
      desc:     "Status register of cache line 662",
      swaccess: "rw",
      hwaccess: "hrw",
      hwext:    "true",
      hwqe:     "true", // enable `qe` latched signal of software write pulse
      hwre:     "true",
      fields: [
        {
          bits: "5+3:5", // 2 bits for status
          name: "CL_STATUS",
          desc: "Contain the current status of the corresponding cache line                [0]: valid, [1]: dirty, [2]: cmpt",
        }
      ]
    },
    { name:     "TAG_662",
      desc:     "Tag Address stored in cache line 662",
      swaccess: "rw",
      hwaccess: "hrw",
      hwext:    "true",
      hwqe:     "true", // enable `qe` latched signal of software write pulse
      hwre:     "true",
      fields: [
        { bits: "5-1:0",
          name: "CL_TAG",
          desc: "Tag Address"
        }
      ]
    },
    {
      name:     "STATUS_663",
      desc:     "Status register of cache line 663",
      swaccess: "rw",
      hwaccess: "hrw",
      hwext:    "true",
      hwqe:     "true", // enable `qe` latched signal of software write pulse
      hwre:     "true",
      fields: [
        {
          bits: "5+3:5", // 2 bits for status
          name: "CL_STATUS",
          desc: "Contain the current status of the corresponding cache line                [0]: valid, [1]: dirty, [2]: cmpt",
        }
      ]
    },
    { name:     "TAG_663",
      desc:     "Tag Address stored in cache line 663",
      swaccess: "rw",
      hwaccess: "hrw",
      hwext:    "true",
      hwqe:     "true", // enable `qe` latched signal of software write pulse
      hwre:     "true",
      fields: [
        { bits: "5-1:0",
          name: "CL_TAG",
          desc: "Tag Address"
        }
      ]
    },
    {
      name:     "STATUS_664",
      desc:     "Status register of cache line 664",
      swaccess: "rw",
      hwaccess: "hrw",
      hwext:    "true",
      hwqe:     "true", // enable `qe` latched signal of software write pulse
      hwre:     "true",
      fields: [
        {
          bits: "5+3:5", // 2 bits for status
          name: "CL_STATUS",
          desc: "Contain the current status of the corresponding cache line                [0]: valid, [1]: dirty, [2]: cmpt",
        }
      ]
    },
    { name:     "TAG_664",
      desc:     "Tag Address stored in cache line 664",
      swaccess: "rw",
      hwaccess: "hrw",
      hwext:    "true",
      hwqe:     "true", // enable `qe` latched signal of software write pulse
      hwre:     "true",
      fields: [
        { bits: "5-1:0",
          name: "CL_TAG",
          desc: "Tag Address"
        }
      ]
    },
    {
      name:     "STATUS_665",
      desc:     "Status register of cache line 665",
      swaccess: "rw",
      hwaccess: "hrw",
      hwext:    "true",
      hwqe:     "true", // enable `qe` latched signal of software write pulse
      hwre:     "true",
      fields: [
        {
          bits: "5+3:5", // 2 bits for status
          name: "CL_STATUS",
          desc: "Contain the current status of the corresponding cache line                [0]: valid, [1]: dirty, [2]: cmpt",
        }
      ]
    },
    { name:     "TAG_665",
      desc:     "Tag Address stored in cache line 665",
      swaccess: "rw",
      hwaccess: "hrw",
      hwext:    "true",
      hwqe:     "true", // enable `qe` latched signal of software write pulse
      hwre:     "true",
      fields: [
        { bits: "5-1:0",
          name: "CL_TAG",
          desc: "Tag Address"
        }
      ]
    },
    {
      name:     "STATUS_666",
      desc:     "Status register of cache line 666",
      swaccess: "rw",
      hwaccess: "hrw",
      hwext:    "true",
      hwqe:     "true", // enable `qe` latched signal of software write pulse
      hwre:     "true",
      fields: [
        {
          bits: "5+3:5", // 2 bits for status
          name: "CL_STATUS",
          desc: "Contain the current status of the corresponding cache line                [0]: valid, [1]: dirty, [2]: cmpt",
        }
      ]
    },
    { name:     "TAG_666",
      desc:     "Tag Address stored in cache line 666",
      swaccess: "rw",
      hwaccess: "hrw",
      hwext:    "true",
      hwqe:     "true", // enable `qe` latched signal of software write pulse
      hwre:     "true",
      fields: [
        { bits: "5-1:0",
          name: "CL_TAG",
          desc: "Tag Address"
        }
      ]
    },
    {
      name:     "STATUS_667",
      desc:     "Status register of cache line 667",
      swaccess: "rw",
      hwaccess: "hrw",
      hwext:    "true",
      hwqe:     "true", // enable `qe` latched signal of software write pulse
      hwre:     "true",
      fields: [
        {
          bits: "5+3:5", // 2 bits for status
          name: "CL_STATUS",
          desc: "Contain the current status of the corresponding cache line                [0]: valid, [1]: dirty, [2]: cmpt",
        }
      ]
    },
    { name:     "TAG_667",
      desc:     "Tag Address stored in cache line 667",
      swaccess: "rw",
      hwaccess: "hrw",
      hwext:    "true",
      hwqe:     "true", // enable `qe` latched signal of software write pulse
      hwre:     "true",
      fields: [
        { bits: "5-1:0",
          name: "CL_TAG",
          desc: "Tag Address"
        }
      ]
    },
    {
      name:     "STATUS_668",
      desc:     "Status register of cache line 668",
      swaccess: "rw",
      hwaccess: "hrw",
      hwext:    "true",
      hwqe:     "true", // enable `qe` latched signal of software write pulse
      hwre:     "true",
      fields: [
        {
          bits: "5+3:5", // 2 bits for status
          name: "CL_STATUS",
          desc: "Contain the current status of the corresponding cache line                [0]: valid, [1]: dirty, [2]: cmpt",
        }
      ]
    },
    { name:     "TAG_668",
      desc:     "Tag Address stored in cache line 668",
      swaccess: "rw",
      hwaccess: "hrw",
      hwext:    "true",
      hwqe:     "true", // enable `qe` latched signal of software write pulse
      hwre:     "true",
      fields: [
        { bits: "5-1:0",
          name: "CL_TAG",
          desc: "Tag Address"
        }
      ]
    },
    {
      name:     "STATUS_669",
      desc:     "Status register of cache line 669",
      swaccess: "rw",
      hwaccess: "hrw",
      hwext:    "true",
      hwqe:     "true", // enable `qe` latched signal of software write pulse
      hwre:     "true",
      fields: [
        {
          bits: "5+3:5", // 2 bits for status
          name: "CL_STATUS",
          desc: "Contain the current status of the corresponding cache line                [0]: valid, [1]: dirty, [2]: cmpt",
        }
      ]
    },
    { name:     "TAG_669",
      desc:     "Tag Address stored in cache line 669",
      swaccess: "rw",
      hwaccess: "hrw",
      hwext:    "true",
      hwqe:     "true", // enable `qe` latched signal of software write pulse
      hwre:     "true",
      fields: [
        { bits: "5-1:0",
          name: "CL_TAG",
          desc: "Tag Address"
        }
      ]
    },
    {
      name:     "STATUS_670",
      desc:     "Status register of cache line 670",
      swaccess: "rw",
      hwaccess: "hrw",
      hwext:    "true",
      hwqe:     "true", // enable `qe` latched signal of software write pulse
      hwre:     "true",
      fields: [
        {
          bits: "5+3:5", // 2 bits for status
          name: "CL_STATUS",
          desc: "Contain the current status of the corresponding cache line                [0]: valid, [1]: dirty, [2]: cmpt",
        }
      ]
    },
    { name:     "TAG_670",
      desc:     "Tag Address stored in cache line 670",
      swaccess: "rw",
      hwaccess: "hrw",
      hwext:    "true",
      hwqe:     "true", // enable `qe` latched signal of software write pulse
      hwre:     "true",
      fields: [
        { bits: "5-1:0",
          name: "CL_TAG",
          desc: "Tag Address"
        }
      ]
    },
    {
      name:     "STATUS_671",
      desc:     "Status register of cache line 671",
      swaccess: "rw",
      hwaccess: "hrw",
      hwext:    "true",
      hwqe:     "true", // enable `qe` latched signal of software write pulse
      hwre:     "true",
      fields: [
        {
          bits: "5+3:5", // 2 bits for status
          name: "CL_STATUS",
          desc: "Contain the current status of the corresponding cache line                [0]: valid, [1]: dirty, [2]: cmpt",
        }
      ]
    },
    { name:     "TAG_671",
      desc:     "Tag Address stored in cache line 671",
      swaccess: "rw",
      hwaccess: "hrw",
      hwext:    "true",
      hwqe:     "true", // enable `qe` latched signal of software write pulse
      hwre:     "true",
      fields: [
        { bits: "5-1:0",
          name: "CL_TAG",
          desc: "Tag Address"
        }
      ]
    },
    {
      name:     "STATUS_672",
      desc:     "Status register of cache line 672",
      swaccess: "rw",
      hwaccess: "hrw",
      hwext:    "true",
      hwqe:     "true", // enable `qe` latched signal of software write pulse
      hwre:     "true",
      fields: [
        {
          bits: "5+3:5", // 2 bits for status
          name: "CL_STATUS",
          desc: "Contain the current status of the corresponding cache line                [0]: valid, [1]: dirty, [2]: cmpt",
        }
      ]
    },
    { name:     "TAG_672",
      desc:     "Tag Address stored in cache line 672",
      swaccess: "rw",
      hwaccess: "hrw",
      hwext:    "true",
      hwqe:     "true", // enable `qe` latched signal of software write pulse
      hwre:     "true",
      fields: [
        { bits: "5-1:0",
          name: "CL_TAG",
          desc: "Tag Address"
        }
      ]
    },
    {
      name:     "STATUS_673",
      desc:     "Status register of cache line 673",
      swaccess: "rw",
      hwaccess: "hrw",
      hwext:    "true",
      hwqe:     "true", // enable `qe` latched signal of software write pulse
      hwre:     "true",
      fields: [
        {
          bits: "5+3:5", // 2 bits for status
          name: "CL_STATUS",
          desc: "Contain the current status of the corresponding cache line                [0]: valid, [1]: dirty, [2]: cmpt",
        }
      ]
    },
    { name:     "TAG_673",
      desc:     "Tag Address stored in cache line 673",
      swaccess: "rw",
      hwaccess: "hrw",
      hwext:    "true",
      hwqe:     "true", // enable `qe` latched signal of software write pulse
      hwre:     "true",
      fields: [
        { bits: "5-1:0",
          name: "CL_TAG",
          desc: "Tag Address"
        }
      ]
    },
    {
      name:     "STATUS_674",
      desc:     "Status register of cache line 674",
      swaccess: "rw",
      hwaccess: "hrw",
      hwext:    "true",
      hwqe:     "true", // enable `qe` latched signal of software write pulse
      hwre:     "true",
      fields: [
        {
          bits: "5+3:5", // 2 bits for status
          name: "CL_STATUS",
          desc: "Contain the current status of the corresponding cache line                [0]: valid, [1]: dirty, [2]: cmpt",
        }
      ]
    },
    { name:     "TAG_674",
      desc:     "Tag Address stored in cache line 674",
      swaccess: "rw",
      hwaccess: "hrw",
      hwext:    "true",
      hwqe:     "true", // enable `qe` latched signal of software write pulse
      hwre:     "true",
      fields: [
        { bits: "5-1:0",
          name: "CL_TAG",
          desc: "Tag Address"
        }
      ]
    },
    {
      name:     "STATUS_675",
      desc:     "Status register of cache line 675",
      swaccess: "rw",
      hwaccess: "hrw",
      hwext:    "true",
      hwqe:     "true", // enable `qe` latched signal of software write pulse
      hwre:     "true",
      fields: [
        {
          bits: "5+3:5", // 2 bits for status
          name: "CL_STATUS",
          desc: "Contain the current status of the corresponding cache line                [0]: valid, [1]: dirty, [2]: cmpt",
        }
      ]
    },
    { name:     "TAG_675",
      desc:     "Tag Address stored in cache line 675",
      swaccess: "rw",
      hwaccess: "hrw",
      hwext:    "true",
      hwqe:     "true", // enable `qe` latched signal of software write pulse
      hwre:     "true",
      fields: [
        { bits: "5-1:0",
          name: "CL_TAG",
          desc: "Tag Address"
        }
      ]
    },
    {
      name:     "STATUS_676",
      desc:     "Status register of cache line 676",
      swaccess: "rw",
      hwaccess: "hrw",
      hwext:    "true",
      hwqe:     "true", // enable `qe` latched signal of software write pulse
      hwre:     "true",
      fields: [
        {
          bits: "5+3:5", // 2 bits for status
          name: "CL_STATUS",
          desc: "Contain the current status of the corresponding cache line                [0]: valid, [1]: dirty, [2]: cmpt",
        }
      ]
    },
    { name:     "TAG_676",
      desc:     "Tag Address stored in cache line 676",
      swaccess: "rw",
      hwaccess: "hrw",
      hwext:    "true",
      hwqe:     "true", // enable `qe` latched signal of software write pulse
      hwre:     "true",
      fields: [
        { bits: "5-1:0",
          name: "CL_TAG",
          desc: "Tag Address"
        }
      ]
    },
    {
      name:     "STATUS_677",
      desc:     "Status register of cache line 677",
      swaccess: "rw",
      hwaccess: "hrw",
      hwext:    "true",
      hwqe:     "true", // enable `qe` latched signal of software write pulse
      hwre:     "true",
      fields: [
        {
          bits: "5+3:5", // 2 bits for status
          name: "CL_STATUS",
          desc: "Contain the current status of the corresponding cache line                [0]: valid, [1]: dirty, [2]: cmpt",
        }
      ]
    },
    { name:     "TAG_677",
      desc:     "Tag Address stored in cache line 677",
      swaccess: "rw",
      hwaccess: "hrw",
      hwext:    "true",
      hwqe:     "true", // enable `qe` latched signal of software write pulse
      hwre:     "true",
      fields: [
        { bits: "5-1:0",
          name: "CL_TAG",
          desc: "Tag Address"
        }
      ]
    },
    {
      name:     "STATUS_678",
      desc:     "Status register of cache line 678",
      swaccess: "rw",
      hwaccess: "hrw",
      hwext:    "true",
      hwqe:     "true", // enable `qe` latched signal of software write pulse
      hwre:     "true",
      fields: [
        {
          bits: "5+3:5", // 2 bits for status
          name: "CL_STATUS",
          desc: "Contain the current status of the corresponding cache line                [0]: valid, [1]: dirty, [2]: cmpt",
        }
      ]
    },
    { name:     "TAG_678",
      desc:     "Tag Address stored in cache line 678",
      swaccess: "rw",
      hwaccess: "hrw",
      hwext:    "true",
      hwqe:     "true", // enable `qe` latched signal of software write pulse
      hwre:     "true",
      fields: [
        { bits: "5-1:0",
          name: "CL_TAG",
          desc: "Tag Address"
        }
      ]
    },
    {
      name:     "STATUS_679",
      desc:     "Status register of cache line 679",
      swaccess: "rw",
      hwaccess: "hrw",
      hwext:    "true",
      hwqe:     "true", // enable `qe` latched signal of software write pulse
      hwre:     "true",
      fields: [
        {
          bits: "5+3:5", // 2 bits for status
          name: "CL_STATUS",
          desc: "Contain the current status of the corresponding cache line                [0]: valid, [1]: dirty, [2]: cmpt",
        }
      ]
    },
    { name:     "TAG_679",
      desc:     "Tag Address stored in cache line 679",
      swaccess: "rw",
      hwaccess: "hrw",
      hwext:    "true",
      hwqe:     "true", // enable `qe` latched signal of software write pulse
      hwre:     "true",
      fields: [
        { bits: "5-1:0",
          name: "CL_TAG",
          desc: "Tag Address"
        }
      ]
    },
    {
      name:     "STATUS_680",
      desc:     "Status register of cache line 680",
      swaccess: "rw",
      hwaccess: "hrw",
      hwext:    "true",
      hwqe:     "true", // enable `qe` latched signal of software write pulse
      hwre:     "true",
      fields: [
        {
          bits: "5+3:5", // 2 bits for status
          name: "CL_STATUS",
          desc: "Contain the current status of the corresponding cache line                [0]: valid, [1]: dirty, [2]: cmpt",
        }
      ]
    },
    { name:     "TAG_680",
      desc:     "Tag Address stored in cache line 680",
      swaccess: "rw",
      hwaccess: "hrw",
      hwext:    "true",
      hwqe:     "true", // enable `qe` latched signal of software write pulse
      hwre:     "true",
      fields: [
        { bits: "5-1:0",
          name: "CL_TAG",
          desc: "Tag Address"
        }
      ]
    },
    {
      name:     "STATUS_681",
      desc:     "Status register of cache line 681",
      swaccess: "rw",
      hwaccess: "hrw",
      hwext:    "true",
      hwqe:     "true", // enable `qe` latched signal of software write pulse
      hwre:     "true",
      fields: [
        {
          bits: "5+3:5", // 2 bits for status
          name: "CL_STATUS",
          desc: "Contain the current status of the corresponding cache line                [0]: valid, [1]: dirty, [2]: cmpt",
        }
      ]
    },
    { name:     "TAG_681",
      desc:     "Tag Address stored in cache line 681",
      swaccess: "rw",
      hwaccess: "hrw",
      hwext:    "true",
      hwqe:     "true", // enable `qe` latched signal of software write pulse
      hwre:     "true",
      fields: [
        { bits: "5-1:0",
          name: "CL_TAG",
          desc: "Tag Address"
        }
      ]
    },
    {
      name:     "STATUS_682",
      desc:     "Status register of cache line 682",
      swaccess: "rw",
      hwaccess: "hrw",
      hwext:    "true",
      hwqe:     "true", // enable `qe` latched signal of software write pulse
      hwre:     "true",
      fields: [
        {
          bits: "5+3:5", // 2 bits for status
          name: "CL_STATUS",
          desc: "Contain the current status of the corresponding cache line                [0]: valid, [1]: dirty, [2]: cmpt",
        }
      ]
    },
    { name:     "TAG_682",
      desc:     "Tag Address stored in cache line 682",
      swaccess: "rw",
      hwaccess: "hrw",
      hwext:    "true",
      hwqe:     "true", // enable `qe` latched signal of software write pulse
      hwre:     "true",
      fields: [
        { bits: "5-1:0",
          name: "CL_TAG",
          desc: "Tag Address"
        }
      ]
    },
    {
      name:     "STATUS_683",
      desc:     "Status register of cache line 683",
      swaccess: "rw",
      hwaccess: "hrw",
      hwext:    "true",
      hwqe:     "true", // enable `qe` latched signal of software write pulse
      hwre:     "true",
      fields: [
        {
          bits: "5+3:5", // 2 bits for status
          name: "CL_STATUS",
          desc: "Contain the current status of the corresponding cache line                [0]: valid, [1]: dirty, [2]: cmpt",
        }
      ]
    },
    { name:     "TAG_683",
      desc:     "Tag Address stored in cache line 683",
      swaccess: "rw",
      hwaccess: "hrw",
      hwext:    "true",
      hwqe:     "true", // enable `qe` latched signal of software write pulse
      hwre:     "true",
      fields: [
        { bits: "5-1:0",
          name: "CL_TAG",
          desc: "Tag Address"
        }
      ]
    },
    {
      name:     "STATUS_684",
      desc:     "Status register of cache line 684",
      swaccess: "rw",
      hwaccess: "hrw",
      hwext:    "true",
      hwqe:     "true", // enable `qe` latched signal of software write pulse
      hwre:     "true",
      fields: [
        {
          bits: "5+3:5", // 2 bits for status
          name: "CL_STATUS",
          desc: "Contain the current status of the corresponding cache line                [0]: valid, [1]: dirty, [2]: cmpt",
        }
      ]
    },
    { name:     "TAG_684",
      desc:     "Tag Address stored in cache line 684",
      swaccess: "rw",
      hwaccess: "hrw",
      hwext:    "true",
      hwqe:     "true", // enable `qe` latched signal of software write pulse
      hwre:     "true",
      fields: [
        { bits: "5-1:0",
          name: "CL_TAG",
          desc: "Tag Address"
        }
      ]
    },
    {
      name:     "STATUS_685",
      desc:     "Status register of cache line 685",
      swaccess: "rw",
      hwaccess: "hrw",
      hwext:    "true",
      hwqe:     "true", // enable `qe` latched signal of software write pulse
      hwre:     "true",
      fields: [
        {
          bits: "5+3:5", // 2 bits for status
          name: "CL_STATUS",
          desc: "Contain the current status of the corresponding cache line                [0]: valid, [1]: dirty, [2]: cmpt",
        }
      ]
    },
    { name:     "TAG_685",
      desc:     "Tag Address stored in cache line 685",
      swaccess: "rw",
      hwaccess: "hrw",
      hwext:    "true",
      hwqe:     "true", // enable `qe` latched signal of software write pulse
      hwre:     "true",
      fields: [
        { bits: "5-1:0",
          name: "CL_TAG",
          desc: "Tag Address"
        }
      ]
    },
    {
      name:     "STATUS_686",
      desc:     "Status register of cache line 686",
      swaccess: "rw",
      hwaccess: "hrw",
      hwext:    "true",
      hwqe:     "true", // enable `qe` latched signal of software write pulse
      hwre:     "true",
      fields: [
        {
          bits: "5+3:5", // 2 bits for status
          name: "CL_STATUS",
          desc: "Contain the current status of the corresponding cache line                [0]: valid, [1]: dirty, [2]: cmpt",
        }
      ]
    },
    { name:     "TAG_686",
      desc:     "Tag Address stored in cache line 686",
      swaccess: "rw",
      hwaccess: "hrw",
      hwext:    "true",
      hwqe:     "true", // enable `qe` latched signal of software write pulse
      hwre:     "true",
      fields: [
        { bits: "5-1:0",
          name: "CL_TAG",
          desc: "Tag Address"
        }
      ]
    },
    {
      name:     "STATUS_687",
      desc:     "Status register of cache line 687",
      swaccess: "rw",
      hwaccess: "hrw",
      hwext:    "true",
      hwqe:     "true", // enable `qe` latched signal of software write pulse
      hwre:     "true",
      fields: [
        {
          bits: "5+3:5", // 2 bits for status
          name: "CL_STATUS",
          desc: "Contain the current status of the corresponding cache line                [0]: valid, [1]: dirty, [2]: cmpt",
        }
      ]
    },
    { name:     "TAG_687",
      desc:     "Tag Address stored in cache line 687",
      swaccess: "rw",
      hwaccess: "hrw",
      hwext:    "true",
      hwqe:     "true", // enable `qe` latched signal of software write pulse
      hwre:     "true",
      fields: [
        { bits: "5-1:0",
          name: "CL_TAG",
          desc: "Tag Address"
        }
      ]
    },
    {
      name:     "STATUS_688",
      desc:     "Status register of cache line 688",
      swaccess: "rw",
      hwaccess: "hrw",
      hwext:    "true",
      hwqe:     "true", // enable `qe` latched signal of software write pulse
      hwre:     "true",
      fields: [
        {
          bits: "5+3:5", // 2 bits for status
          name: "CL_STATUS",
          desc: "Contain the current status of the corresponding cache line                [0]: valid, [1]: dirty, [2]: cmpt",
        }
      ]
    },
    { name:     "TAG_688",
      desc:     "Tag Address stored in cache line 688",
      swaccess: "rw",
      hwaccess: "hrw",
      hwext:    "true",
      hwqe:     "true", // enable `qe` latched signal of software write pulse
      hwre:     "true",
      fields: [
        { bits: "5-1:0",
          name: "CL_TAG",
          desc: "Tag Address"
        }
      ]
    },
    {
      name:     "STATUS_689",
      desc:     "Status register of cache line 689",
      swaccess: "rw",
      hwaccess: "hrw",
      hwext:    "true",
      hwqe:     "true", // enable `qe` latched signal of software write pulse
      hwre:     "true",
      fields: [
        {
          bits: "5+3:5", // 2 bits for status
          name: "CL_STATUS",
          desc: "Contain the current status of the corresponding cache line                [0]: valid, [1]: dirty, [2]: cmpt",
        }
      ]
    },
    { name:     "TAG_689",
      desc:     "Tag Address stored in cache line 689",
      swaccess: "rw",
      hwaccess: "hrw",
      hwext:    "true",
      hwqe:     "true", // enable `qe` latched signal of software write pulse
      hwre:     "true",
      fields: [
        { bits: "5-1:0",
          name: "CL_TAG",
          desc: "Tag Address"
        }
      ]
    },
    {
      name:     "STATUS_690",
      desc:     "Status register of cache line 690",
      swaccess: "rw",
      hwaccess: "hrw",
      hwext:    "true",
      hwqe:     "true", // enable `qe` latched signal of software write pulse
      hwre:     "true",
      fields: [
        {
          bits: "5+3:5", // 2 bits for status
          name: "CL_STATUS",
          desc: "Contain the current status of the corresponding cache line                [0]: valid, [1]: dirty, [2]: cmpt",
        }
      ]
    },
    { name:     "TAG_690",
      desc:     "Tag Address stored in cache line 690",
      swaccess: "rw",
      hwaccess: "hrw",
      hwext:    "true",
      hwqe:     "true", // enable `qe` latched signal of software write pulse
      hwre:     "true",
      fields: [
        { bits: "5-1:0",
          name: "CL_TAG",
          desc: "Tag Address"
        }
      ]
    },
    {
      name:     "STATUS_691",
      desc:     "Status register of cache line 691",
      swaccess: "rw",
      hwaccess: "hrw",
      hwext:    "true",
      hwqe:     "true", // enable `qe` latched signal of software write pulse
      hwre:     "true",
      fields: [
        {
          bits: "5+3:5", // 2 bits for status
          name: "CL_STATUS",
          desc: "Contain the current status of the corresponding cache line                [0]: valid, [1]: dirty, [2]: cmpt",
        }
      ]
    },
    { name:     "TAG_691",
      desc:     "Tag Address stored in cache line 691",
      swaccess: "rw",
      hwaccess: "hrw",
      hwext:    "true",
      hwqe:     "true", // enable `qe` latched signal of software write pulse
      hwre:     "true",
      fields: [
        { bits: "5-1:0",
          name: "CL_TAG",
          desc: "Tag Address"
        }
      ]
    },
    {
      name:     "STATUS_692",
      desc:     "Status register of cache line 692",
      swaccess: "rw",
      hwaccess: "hrw",
      hwext:    "true",
      hwqe:     "true", // enable `qe` latched signal of software write pulse
      hwre:     "true",
      fields: [
        {
          bits: "5+3:5", // 2 bits for status
          name: "CL_STATUS",
          desc: "Contain the current status of the corresponding cache line                [0]: valid, [1]: dirty, [2]: cmpt",
        }
      ]
    },
    { name:     "TAG_692",
      desc:     "Tag Address stored in cache line 692",
      swaccess: "rw",
      hwaccess: "hrw",
      hwext:    "true",
      hwqe:     "true", // enable `qe` latched signal of software write pulse
      hwre:     "true",
      fields: [
        { bits: "5-1:0",
          name: "CL_TAG",
          desc: "Tag Address"
        }
      ]
    },
    {
      name:     "STATUS_693",
      desc:     "Status register of cache line 693",
      swaccess: "rw",
      hwaccess: "hrw",
      hwext:    "true",
      hwqe:     "true", // enable `qe` latched signal of software write pulse
      hwre:     "true",
      fields: [
        {
          bits: "5+3:5", // 2 bits for status
          name: "CL_STATUS",
          desc: "Contain the current status of the corresponding cache line                [0]: valid, [1]: dirty, [2]: cmpt",
        }
      ]
    },
    { name:     "TAG_693",
      desc:     "Tag Address stored in cache line 693",
      swaccess: "rw",
      hwaccess: "hrw",
      hwext:    "true",
      hwqe:     "true", // enable `qe` latched signal of software write pulse
      hwre:     "true",
      fields: [
        { bits: "5-1:0",
          name: "CL_TAG",
          desc: "Tag Address"
        }
      ]
    },
    {
      name:     "STATUS_694",
      desc:     "Status register of cache line 694",
      swaccess: "rw",
      hwaccess: "hrw",
      hwext:    "true",
      hwqe:     "true", // enable `qe` latched signal of software write pulse
      hwre:     "true",
      fields: [
        {
          bits: "5+3:5", // 2 bits for status
          name: "CL_STATUS",
          desc: "Contain the current status of the corresponding cache line                [0]: valid, [1]: dirty, [2]: cmpt",
        }
      ]
    },
    { name:     "TAG_694",
      desc:     "Tag Address stored in cache line 694",
      swaccess: "rw",
      hwaccess: "hrw",
      hwext:    "true",
      hwqe:     "true", // enable `qe` latched signal of software write pulse
      hwre:     "true",
      fields: [
        { bits: "5-1:0",
          name: "CL_TAG",
          desc: "Tag Address"
        }
      ]
    },
    {
      name:     "STATUS_695",
      desc:     "Status register of cache line 695",
      swaccess: "rw",
      hwaccess: "hrw",
      hwext:    "true",
      hwqe:     "true", // enable `qe` latched signal of software write pulse
      hwre:     "true",
      fields: [
        {
          bits: "5+3:5", // 2 bits for status
          name: "CL_STATUS",
          desc: "Contain the current status of the corresponding cache line                [0]: valid, [1]: dirty, [2]: cmpt",
        }
      ]
    },
    { name:     "TAG_695",
      desc:     "Tag Address stored in cache line 695",
      swaccess: "rw",
      hwaccess: "hrw",
      hwext:    "true",
      hwqe:     "true", // enable `qe` latched signal of software write pulse
      hwre:     "true",
      fields: [
        { bits: "5-1:0",
          name: "CL_TAG",
          desc: "Tag Address"
        }
      ]
    },
    {
      name:     "STATUS_696",
      desc:     "Status register of cache line 696",
      swaccess: "rw",
      hwaccess: "hrw",
      hwext:    "true",
      hwqe:     "true", // enable `qe` latched signal of software write pulse
      hwre:     "true",
      fields: [
        {
          bits: "5+3:5", // 2 bits for status
          name: "CL_STATUS",
          desc: "Contain the current status of the corresponding cache line                [0]: valid, [1]: dirty, [2]: cmpt",
        }
      ]
    },
    { name:     "TAG_696",
      desc:     "Tag Address stored in cache line 696",
      swaccess: "rw",
      hwaccess: "hrw",
      hwext:    "true",
      hwqe:     "true", // enable `qe` latched signal of software write pulse
      hwre:     "true",
      fields: [
        { bits: "5-1:0",
          name: "CL_TAG",
          desc: "Tag Address"
        }
      ]
    },
    {
      name:     "STATUS_697",
      desc:     "Status register of cache line 697",
      swaccess: "rw",
      hwaccess: "hrw",
      hwext:    "true",
      hwqe:     "true", // enable `qe` latched signal of software write pulse
      hwre:     "true",
      fields: [
        {
          bits: "5+3:5", // 2 bits for status
          name: "CL_STATUS",
          desc: "Contain the current status of the corresponding cache line                [0]: valid, [1]: dirty, [2]: cmpt",
        }
      ]
    },
    { name:     "TAG_697",
      desc:     "Tag Address stored in cache line 697",
      swaccess: "rw",
      hwaccess: "hrw",
      hwext:    "true",
      hwqe:     "true", // enable `qe` latched signal of software write pulse
      hwre:     "true",
      fields: [
        { bits: "5-1:0",
          name: "CL_TAG",
          desc: "Tag Address"
        }
      ]
    },
    {
      name:     "STATUS_698",
      desc:     "Status register of cache line 698",
      swaccess: "rw",
      hwaccess: "hrw",
      hwext:    "true",
      hwqe:     "true", // enable `qe` latched signal of software write pulse
      hwre:     "true",
      fields: [
        {
          bits: "5+3:5", // 2 bits for status
          name: "CL_STATUS",
          desc: "Contain the current status of the corresponding cache line                [0]: valid, [1]: dirty, [2]: cmpt",
        }
      ]
    },
    { name:     "TAG_698",
      desc:     "Tag Address stored in cache line 698",
      swaccess: "rw",
      hwaccess: "hrw",
      hwext:    "true",
      hwqe:     "true", // enable `qe` latched signal of software write pulse
      hwre:     "true",
      fields: [
        { bits: "5-1:0",
          name: "CL_TAG",
          desc: "Tag Address"
        }
      ]
    },
    {
      name:     "STATUS_699",
      desc:     "Status register of cache line 699",
      swaccess: "rw",
      hwaccess: "hrw",
      hwext:    "true",
      hwqe:     "true", // enable `qe` latched signal of software write pulse
      hwre:     "true",
      fields: [
        {
          bits: "5+3:5", // 2 bits for status
          name: "CL_STATUS",
          desc: "Contain the current status of the corresponding cache line                [0]: valid, [1]: dirty, [2]: cmpt",
        }
      ]
    },
    { name:     "TAG_699",
      desc:     "Tag Address stored in cache line 699",
      swaccess: "rw",
      hwaccess: "hrw",
      hwext:    "true",
      hwqe:     "true", // enable `qe` latched signal of software write pulse
      hwre:     "true",
      fields: [
        { bits: "5-1:0",
          name: "CL_TAG",
          desc: "Tag Address"
        }
      ]
    },
    {
      name:     "STATUS_700",
      desc:     "Status register of cache line 700",
      swaccess: "rw",
      hwaccess: "hrw",
      hwext:    "true",
      hwqe:     "true", // enable `qe` latched signal of software write pulse
      hwre:     "true",
      fields: [
        {
          bits: "5+3:5", // 2 bits for status
          name: "CL_STATUS",
          desc: "Contain the current status of the corresponding cache line                [0]: valid, [1]: dirty, [2]: cmpt",
        }
      ]
    },
    { name:     "TAG_700",
      desc:     "Tag Address stored in cache line 700",
      swaccess: "rw",
      hwaccess: "hrw",
      hwext:    "true",
      hwqe:     "true", // enable `qe` latched signal of software write pulse
      hwre:     "true",
      fields: [
        { bits: "5-1:0",
          name: "CL_TAG",
          desc: "Tag Address"
        }
      ]
    },
    {
      name:     "STATUS_701",
      desc:     "Status register of cache line 701",
      swaccess: "rw",
      hwaccess: "hrw",
      hwext:    "true",
      hwqe:     "true", // enable `qe` latched signal of software write pulse
      hwre:     "true",
      fields: [
        {
          bits: "5+3:5", // 2 bits for status
          name: "CL_STATUS",
          desc: "Contain the current status of the corresponding cache line                [0]: valid, [1]: dirty, [2]: cmpt",
        }
      ]
    },
    { name:     "TAG_701",
      desc:     "Tag Address stored in cache line 701",
      swaccess: "rw",
      hwaccess: "hrw",
      hwext:    "true",
      hwqe:     "true", // enable `qe` latched signal of software write pulse
      hwre:     "true",
      fields: [
        { bits: "5-1:0",
          name: "CL_TAG",
          desc: "Tag Address"
        }
      ]
    },
    {
      name:     "STATUS_702",
      desc:     "Status register of cache line 702",
      swaccess: "rw",
      hwaccess: "hrw",
      hwext:    "true",
      hwqe:     "true", // enable `qe` latched signal of software write pulse
      hwre:     "true",
      fields: [
        {
          bits: "5+3:5", // 2 bits for status
          name: "CL_STATUS",
          desc: "Contain the current status of the corresponding cache line                [0]: valid, [1]: dirty, [2]: cmpt",
        }
      ]
    },
    { name:     "TAG_702",
      desc:     "Tag Address stored in cache line 702",
      swaccess: "rw",
      hwaccess: "hrw",
      hwext:    "true",
      hwqe:     "true", // enable `qe` latched signal of software write pulse
      hwre:     "true",
      fields: [
        { bits: "5-1:0",
          name: "CL_TAG",
          desc: "Tag Address"
        }
      ]
    },
    {
      name:     "STATUS_703",
      desc:     "Status register of cache line 703",
      swaccess: "rw",
      hwaccess: "hrw",
      hwext:    "true",
      hwqe:     "true", // enable `qe` latched signal of software write pulse
      hwre:     "true",
      fields: [
        {
          bits: "5+3:5", // 2 bits for status
          name: "CL_STATUS",
          desc: "Contain the current status of the corresponding cache line                [0]: valid, [1]: dirty, [2]: cmpt",
        }
      ]
    },
    { name:     "TAG_703",
      desc:     "Tag Address stored in cache line 703",
      swaccess: "rw",
      hwaccess: "hrw",
      hwext:    "true",
      hwqe:     "true", // enable `qe` latched signal of software write pulse
      hwre:     "true",
      fields: [
        { bits: "5-1:0",
          name: "CL_TAG",
          desc: "Tag Address"
        }
      ]
    },
    {
      name:     "STATUS_704",
      desc:     "Status register of cache line 704",
      swaccess: "rw",
      hwaccess: "hrw",
      hwext:    "true",
      hwqe:     "true", // enable `qe` latched signal of software write pulse
      hwre:     "true",
      fields: [
        {
          bits: "5+3:5", // 2 bits for status
          name: "CL_STATUS",
          desc: "Contain the current status of the corresponding cache line                [0]: valid, [1]: dirty, [2]: cmpt",
        }
      ]
    },
    { name:     "TAG_704",
      desc:     "Tag Address stored in cache line 704",
      swaccess: "rw",
      hwaccess: "hrw",
      hwext:    "true",
      hwqe:     "true", // enable `qe` latched signal of software write pulse
      hwre:     "true",
      fields: [
        { bits: "5-1:0",
          name: "CL_TAG",
          desc: "Tag Address"
        }
      ]
    },
    {
      name:     "STATUS_705",
      desc:     "Status register of cache line 705",
      swaccess: "rw",
      hwaccess: "hrw",
      hwext:    "true",
      hwqe:     "true", // enable `qe` latched signal of software write pulse
      hwre:     "true",
      fields: [
        {
          bits: "5+3:5", // 2 bits for status
          name: "CL_STATUS",
          desc: "Contain the current status of the corresponding cache line                [0]: valid, [1]: dirty, [2]: cmpt",
        }
      ]
    },
    { name:     "TAG_705",
      desc:     "Tag Address stored in cache line 705",
      swaccess: "rw",
      hwaccess: "hrw",
      hwext:    "true",
      hwqe:     "true", // enable `qe` latched signal of software write pulse
      hwre:     "true",
      fields: [
        { bits: "5-1:0",
          name: "CL_TAG",
          desc: "Tag Address"
        }
      ]
    },
    {
      name:     "STATUS_706",
      desc:     "Status register of cache line 706",
      swaccess: "rw",
      hwaccess: "hrw",
      hwext:    "true",
      hwqe:     "true", // enable `qe` latched signal of software write pulse
      hwre:     "true",
      fields: [
        {
          bits: "5+3:5", // 2 bits for status
          name: "CL_STATUS",
          desc: "Contain the current status of the corresponding cache line                [0]: valid, [1]: dirty, [2]: cmpt",
        }
      ]
    },
    { name:     "TAG_706",
      desc:     "Tag Address stored in cache line 706",
      swaccess: "rw",
      hwaccess: "hrw",
      hwext:    "true",
      hwqe:     "true", // enable `qe` latched signal of software write pulse
      hwre:     "true",
      fields: [
        { bits: "5-1:0",
          name: "CL_TAG",
          desc: "Tag Address"
        }
      ]
    },
    {
      name:     "STATUS_707",
      desc:     "Status register of cache line 707",
      swaccess: "rw",
      hwaccess: "hrw",
      hwext:    "true",
      hwqe:     "true", // enable `qe` latched signal of software write pulse
      hwre:     "true",
      fields: [
        {
          bits: "5+3:5", // 2 bits for status
          name: "CL_STATUS",
          desc: "Contain the current status of the corresponding cache line                [0]: valid, [1]: dirty, [2]: cmpt",
        }
      ]
    },
    { name:     "TAG_707",
      desc:     "Tag Address stored in cache line 707",
      swaccess: "rw",
      hwaccess: "hrw",
      hwext:    "true",
      hwqe:     "true", // enable `qe` latched signal of software write pulse
      hwre:     "true",
      fields: [
        { bits: "5-1:0",
          name: "CL_TAG",
          desc: "Tag Address"
        }
      ]
    },
    {
      name:     "STATUS_708",
      desc:     "Status register of cache line 708",
      swaccess: "rw",
      hwaccess: "hrw",
      hwext:    "true",
      hwqe:     "true", // enable `qe` latched signal of software write pulse
      hwre:     "true",
      fields: [
        {
          bits: "5+3:5", // 2 bits for status
          name: "CL_STATUS",
          desc: "Contain the current status of the corresponding cache line                [0]: valid, [1]: dirty, [2]: cmpt",
        }
      ]
    },
    { name:     "TAG_708",
      desc:     "Tag Address stored in cache line 708",
      swaccess: "rw",
      hwaccess: "hrw",
      hwext:    "true",
      hwqe:     "true", // enable `qe` latched signal of software write pulse
      hwre:     "true",
      fields: [
        { bits: "5-1:0",
          name: "CL_TAG",
          desc: "Tag Address"
        }
      ]
    },
    {
      name:     "STATUS_709",
      desc:     "Status register of cache line 709",
      swaccess: "rw",
      hwaccess: "hrw",
      hwext:    "true",
      hwqe:     "true", // enable `qe` latched signal of software write pulse
      hwre:     "true",
      fields: [
        {
          bits: "5+3:5", // 2 bits for status
          name: "CL_STATUS",
          desc: "Contain the current status of the corresponding cache line                [0]: valid, [1]: dirty, [2]: cmpt",
        }
      ]
    },
    { name:     "TAG_709",
      desc:     "Tag Address stored in cache line 709",
      swaccess: "rw",
      hwaccess: "hrw",
      hwext:    "true",
      hwqe:     "true", // enable `qe` latched signal of software write pulse
      hwre:     "true",
      fields: [
        { bits: "5-1:0",
          name: "CL_TAG",
          desc: "Tag Address"
        }
      ]
    },
    {
      name:     "STATUS_710",
      desc:     "Status register of cache line 710",
      swaccess: "rw",
      hwaccess: "hrw",
      hwext:    "true",
      hwqe:     "true", // enable `qe` latched signal of software write pulse
      hwre:     "true",
      fields: [
        {
          bits: "5+3:5", // 2 bits for status
          name: "CL_STATUS",
          desc: "Contain the current status of the corresponding cache line                [0]: valid, [1]: dirty, [2]: cmpt",
        }
      ]
    },
    { name:     "TAG_710",
      desc:     "Tag Address stored in cache line 710",
      swaccess: "rw",
      hwaccess: "hrw",
      hwext:    "true",
      hwqe:     "true", // enable `qe` latched signal of software write pulse
      hwre:     "true",
      fields: [
        { bits: "5-1:0",
          name: "CL_TAG",
          desc: "Tag Address"
        }
      ]
    },
    {
      name:     "STATUS_711",
      desc:     "Status register of cache line 711",
      swaccess: "rw",
      hwaccess: "hrw",
      hwext:    "true",
      hwqe:     "true", // enable `qe` latched signal of software write pulse
      hwre:     "true",
      fields: [
        {
          bits: "5+3:5", // 2 bits for status
          name: "CL_STATUS",
          desc: "Contain the current status of the corresponding cache line                [0]: valid, [1]: dirty, [2]: cmpt",
        }
      ]
    },
    { name:     "TAG_711",
      desc:     "Tag Address stored in cache line 711",
      swaccess: "rw",
      hwaccess: "hrw",
      hwext:    "true",
      hwqe:     "true", // enable `qe` latched signal of software write pulse
      hwre:     "true",
      fields: [
        { bits: "5-1:0",
          name: "CL_TAG",
          desc: "Tag Address"
        }
      ]
    },
    {
      name:     "STATUS_712",
      desc:     "Status register of cache line 712",
      swaccess: "rw",
      hwaccess: "hrw",
      hwext:    "true",
      hwqe:     "true", // enable `qe` latched signal of software write pulse
      hwre:     "true",
      fields: [
        {
          bits: "5+3:5", // 2 bits for status
          name: "CL_STATUS",
          desc: "Contain the current status of the corresponding cache line                [0]: valid, [1]: dirty, [2]: cmpt",
        }
      ]
    },
    { name:     "TAG_712",
      desc:     "Tag Address stored in cache line 712",
      swaccess: "rw",
      hwaccess: "hrw",
      hwext:    "true",
      hwqe:     "true", // enable `qe` latched signal of software write pulse
      hwre:     "true",
      fields: [
        { bits: "5-1:0",
          name: "CL_TAG",
          desc: "Tag Address"
        }
      ]
    },
    {
      name:     "STATUS_713",
      desc:     "Status register of cache line 713",
      swaccess: "rw",
      hwaccess: "hrw",
      hwext:    "true",
      hwqe:     "true", // enable `qe` latched signal of software write pulse
      hwre:     "true",
      fields: [
        {
          bits: "5+3:5", // 2 bits for status
          name: "CL_STATUS",
          desc: "Contain the current status of the corresponding cache line                [0]: valid, [1]: dirty, [2]: cmpt",
        }
      ]
    },
    { name:     "TAG_713",
      desc:     "Tag Address stored in cache line 713",
      swaccess: "rw",
      hwaccess: "hrw",
      hwext:    "true",
      hwqe:     "true", // enable `qe` latched signal of software write pulse
      hwre:     "true",
      fields: [
        { bits: "5-1:0",
          name: "CL_TAG",
          desc: "Tag Address"
        }
      ]
    },
    {
      name:     "STATUS_714",
      desc:     "Status register of cache line 714",
      swaccess: "rw",
      hwaccess: "hrw",
      hwext:    "true",
      hwqe:     "true", // enable `qe` latched signal of software write pulse
      hwre:     "true",
      fields: [
        {
          bits: "5+3:5", // 2 bits for status
          name: "CL_STATUS",
          desc: "Contain the current status of the corresponding cache line                [0]: valid, [1]: dirty, [2]: cmpt",
        }
      ]
    },
    { name:     "TAG_714",
      desc:     "Tag Address stored in cache line 714",
      swaccess: "rw",
      hwaccess: "hrw",
      hwext:    "true",
      hwqe:     "true", // enable `qe` latched signal of software write pulse
      hwre:     "true",
      fields: [
        { bits: "5-1:0",
          name: "CL_TAG",
          desc: "Tag Address"
        }
      ]
    },
    {
      name:     "STATUS_715",
      desc:     "Status register of cache line 715",
      swaccess: "rw",
      hwaccess: "hrw",
      hwext:    "true",
      hwqe:     "true", // enable `qe` latched signal of software write pulse
      hwre:     "true",
      fields: [
        {
          bits: "5+3:5", // 2 bits for status
          name: "CL_STATUS",
          desc: "Contain the current status of the corresponding cache line                [0]: valid, [1]: dirty, [2]: cmpt",
        }
      ]
    },
    { name:     "TAG_715",
      desc:     "Tag Address stored in cache line 715",
      swaccess: "rw",
      hwaccess: "hrw",
      hwext:    "true",
      hwqe:     "true", // enable `qe` latched signal of software write pulse
      hwre:     "true",
      fields: [
        { bits: "5-1:0",
          name: "CL_TAG",
          desc: "Tag Address"
        }
      ]
    },
    {
      name:     "STATUS_716",
      desc:     "Status register of cache line 716",
      swaccess: "rw",
      hwaccess: "hrw",
      hwext:    "true",
      hwqe:     "true", // enable `qe` latched signal of software write pulse
      hwre:     "true",
      fields: [
        {
          bits: "5+3:5", // 2 bits for status
          name: "CL_STATUS",
          desc: "Contain the current status of the corresponding cache line                [0]: valid, [1]: dirty, [2]: cmpt",
        }
      ]
    },
    { name:     "TAG_716",
      desc:     "Tag Address stored in cache line 716",
      swaccess: "rw",
      hwaccess: "hrw",
      hwext:    "true",
      hwqe:     "true", // enable `qe` latched signal of software write pulse
      hwre:     "true",
      fields: [
        { bits: "5-1:0",
          name: "CL_TAG",
          desc: "Tag Address"
        }
      ]
    },
    {
      name:     "STATUS_717",
      desc:     "Status register of cache line 717",
      swaccess: "rw",
      hwaccess: "hrw",
      hwext:    "true",
      hwqe:     "true", // enable `qe` latched signal of software write pulse
      hwre:     "true",
      fields: [
        {
          bits: "5+3:5", // 2 bits for status
          name: "CL_STATUS",
          desc: "Contain the current status of the corresponding cache line                [0]: valid, [1]: dirty, [2]: cmpt",
        }
      ]
    },
    { name:     "TAG_717",
      desc:     "Tag Address stored in cache line 717",
      swaccess: "rw",
      hwaccess: "hrw",
      hwext:    "true",
      hwqe:     "true", // enable `qe` latched signal of software write pulse
      hwre:     "true",
      fields: [
        { bits: "5-1:0",
          name: "CL_TAG",
          desc: "Tag Address"
        }
      ]
    },
    {
      name:     "STATUS_718",
      desc:     "Status register of cache line 718",
      swaccess: "rw",
      hwaccess: "hrw",
      hwext:    "true",
      hwqe:     "true", // enable `qe` latched signal of software write pulse
      hwre:     "true",
      fields: [
        {
          bits: "5+3:5", // 2 bits for status
          name: "CL_STATUS",
          desc: "Contain the current status of the corresponding cache line                [0]: valid, [1]: dirty, [2]: cmpt",
        }
      ]
    },
    { name:     "TAG_718",
      desc:     "Tag Address stored in cache line 718",
      swaccess: "rw",
      hwaccess: "hrw",
      hwext:    "true",
      hwqe:     "true", // enable `qe` latched signal of software write pulse
      hwre:     "true",
      fields: [
        { bits: "5-1:0",
          name: "CL_TAG",
          desc: "Tag Address"
        }
      ]
    },
    {
      name:     "STATUS_719",
      desc:     "Status register of cache line 719",
      swaccess: "rw",
      hwaccess: "hrw",
      hwext:    "true",
      hwqe:     "true", // enable `qe` latched signal of software write pulse
      hwre:     "true",
      fields: [
        {
          bits: "5+3:5", // 2 bits for status
          name: "CL_STATUS",
          desc: "Contain the current status of the corresponding cache line                [0]: valid, [1]: dirty, [2]: cmpt",
        }
      ]
    },
    { name:     "TAG_719",
      desc:     "Tag Address stored in cache line 719",
      swaccess: "rw",
      hwaccess: "hrw",
      hwext:    "true",
      hwqe:     "true", // enable `qe` latched signal of software write pulse
      hwre:     "true",
      fields: [
        { bits: "5-1:0",
          name: "CL_TAG",
          desc: "Tag Address"
        }
      ]
    },
    {
      name:     "STATUS_720",
      desc:     "Status register of cache line 720",
      swaccess: "rw",
      hwaccess: "hrw",
      hwext:    "true",
      hwqe:     "true", // enable `qe` latched signal of software write pulse
      hwre:     "true",
      fields: [
        {
          bits: "5+3:5", // 2 bits for status
          name: "CL_STATUS",
          desc: "Contain the current status of the corresponding cache line                [0]: valid, [1]: dirty, [2]: cmpt",
        }
      ]
    },
    { name:     "TAG_720",
      desc:     "Tag Address stored in cache line 720",
      swaccess: "rw",
      hwaccess: "hrw",
      hwext:    "true",
      hwqe:     "true", // enable `qe` latched signal of software write pulse
      hwre:     "true",
      fields: [
        { bits: "5-1:0",
          name: "CL_TAG",
          desc: "Tag Address"
        }
      ]
    },
    {
      name:     "STATUS_721",
      desc:     "Status register of cache line 721",
      swaccess: "rw",
      hwaccess: "hrw",
      hwext:    "true",
      hwqe:     "true", // enable `qe` latched signal of software write pulse
      hwre:     "true",
      fields: [
        {
          bits: "5+3:5", // 2 bits for status
          name: "CL_STATUS",
          desc: "Contain the current status of the corresponding cache line                [0]: valid, [1]: dirty, [2]: cmpt",
        }
      ]
    },
    { name:     "TAG_721",
      desc:     "Tag Address stored in cache line 721",
      swaccess: "rw",
      hwaccess: "hrw",
      hwext:    "true",
      hwqe:     "true", // enable `qe` latched signal of software write pulse
      hwre:     "true",
      fields: [
        { bits: "5-1:0",
          name: "CL_TAG",
          desc: "Tag Address"
        }
      ]
    },
    {
      name:     "STATUS_722",
      desc:     "Status register of cache line 722",
      swaccess: "rw",
      hwaccess: "hrw",
      hwext:    "true",
      hwqe:     "true", // enable `qe` latched signal of software write pulse
      hwre:     "true",
      fields: [
        {
          bits: "5+3:5", // 2 bits for status
          name: "CL_STATUS",
          desc: "Contain the current status of the corresponding cache line                [0]: valid, [1]: dirty, [2]: cmpt",
        }
      ]
    },
    { name:     "TAG_722",
      desc:     "Tag Address stored in cache line 722",
      swaccess: "rw",
      hwaccess: "hrw",
      hwext:    "true",
      hwqe:     "true", // enable `qe` latched signal of software write pulse
      hwre:     "true",
      fields: [
        { bits: "5-1:0",
          name: "CL_TAG",
          desc: "Tag Address"
        }
      ]
    },
    {
      name:     "STATUS_723",
      desc:     "Status register of cache line 723",
      swaccess: "rw",
      hwaccess: "hrw",
      hwext:    "true",
      hwqe:     "true", // enable `qe` latched signal of software write pulse
      hwre:     "true",
      fields: [
        {
          bits: "5+3:5", // 2 bits for status
          name: "CL_STATUS",
          desc: "Contain the current status of the corresponding cache line                [0]: valid, [1]: dirty, [2]: cmpt",
        }
      ]
    },
    { name:     "TAG_723",
      desc:     "Tag Address stored in cache line 723",
      swaccess: "rw",
      hwaccess: "hrw",
      hwext:    "true",
      hwqe:     "true", // enable `qe` latched signal of software write pulse
      hwre:     "true",
      fields: [
        { bits: "5-1:0",
          name: "CL_TAG",
          desc: "Tag Address"
        }
      ]
    },
    {
      name:     "STATUS_724",
      desc:     "Status register of cache line 724",
      swaccess: "rw",
      hwaccess: "hrw",
      hwext:    "true",
      hwqe:     "true", // enable `qe` latched signal of software write pulse
      hwre:     "true",
      fields: [
        {
          bits: "5+3:5", // 2 bits for status
          name: "CL_STATUS",
          desc: "Contain the current status of the corresponding cache line                [0]: valid, [1]: dirty, [2]: cmpt",
        }
      ]
    },
    { name:     "TAG_724",
      desc:     "Tag Address stored in cache line 724",
      swaccess: "rw",
      hwaccess: "hrw",
      hwext:    "true",
      hwqe:     "true", // enable `qe` latched signal of software write pulse
      hwre:     "true",
      fields: [
        { bits: "5-1:0",
          name: "CL_TAG",
          desc: "Tag Address"
        }
      ]
    },
    {
      name:     "STATUS_725",
      desc:     "Status register of cache line 725",
      swaccess: "rw",
      hwaccess: "hrw",
      hwext:    "true",
      hwqe:     "true", // enable `qe` latched signal of software write pulse
      hwre:     "true",
      fields: [
        {
          bits: "5+3:5", // 2 bits for status
          name: "CL_STATUS",
          desc: "Contain the current status of the corresponding cache line                [0]: valid, [1]: dirty, [2]: cmpt",
        }
      ]
    },
    { name:     "TAG_725",
      desc:     "Tag Address stored in cache line 725",
      swaccess: "rw",
      hwaccess: "hrw",
      hwext:    "true",
      hwqe:     "true", // enable `qe` latched signal of software write pulse
      hwre:     "true",
      fields: [
        { bits: "5-1:0",
          name: "CL_TAG",
          desc: "Tag Address"
        }
      ]
    },
    {
      name:     "STATUS_726",
      desc:     "Status register of cache line 726",
      swaccess: "rw",
      hwaccess: "hrw",
      hwext:    "true",
      hwqe:     "true", // enable `qe` latched signal of software write pulse
      hwre:     "true",
      fields: [
        {
          bits: "5+3:5", // 2 bits for status
          name: "CL_STATUS",
          desc: "Contain the current status of the corresponding cache line                [0]: valid, [1]: dirty, [2]: cmpt",
        }
      ]
    },
    { name:     "TAG_726",
      desc:     "Tag Address stored in cache line 726",
      swaccess: "rw",
      hwaccess: "hrw",
      hwext:    "true",
      hwqe:     "true", // enable `qe` latched signal of software write pulse
      hwre:     "true",
      fields: [
        { bits: "5-1:0",
          name: "CL_TAG",
          desc: "Tag Address"
        }
      ]
    },
    {
      name:     "STATUS_727",
      desc:     "Status register of cache line 727",
      swaccess: "rw",
      hwaccess: "hrw",
      hwext:    "true",
      hwqe:     "true", // enable `qe` latched signal of software write pulse
      hwre:     "true",
      fields: [
        {
          bits: "5+3:5", // 2 bits for status
          name: "CL_STATUS",
          desc: "Contain the current status of the corresponding cache line                [0]: valid, [1]: dirty, [2]: cmpt",
        }
      ]
    },
    { name:     "TAG_727",
      desc:     "Tag Address stored in cache line 727",
      swaccess: "rw",
      hwaccess: "hrw",
      hwext:    "true",
      hwqe:     "true", // enable `qe` latched signal of software write pulse
      hwre:     "true",
      fields: [
        { bits: "5-1:0",
          name: "CL_TAG",
          desc: "Tag Address"
        }
      ]
    },
    {
      name:     "STATUS_728",
      desc:     "Status register of cache line 728",
      swaccess: "rw",
      hwaccess: "hrw",
      hwext:    "true",
      hwqe:     "true", // enable `qe` latched signal of software write pulse
      hwre:     "true",
      fields: [
        {
          bits: "5+3:5", // 2 bits for status
          name: "CL_STATUS",
          desc: "Contain the current status of the corresponding cache line                [0]: valid, [1]: dirty, [2]: cmpt",
        }
      ]
    },
    { name:     "TAG_728",
      desc:     "Tag Address stored in cache line 728",
      swaccess: "rw",
      hwaccess: "hrw",
      hwext:    "true",
      hwqe:     "true", // enable `qe` latched signal of software write pulse
      hwre:     "true",
      fields: [
        { bits: "5-1:0",
          name: "CL_TAG",
          desc: "Tag Address"
        }
      ]
    },
    {
      name:     "STATUS_729",
      desc:     "Status register of cache line 729",
      swaccess: "rw",
      hwaccess: "hrw",
      hwext:    "true",
      hwqe:     "true", // enable `qe` latched signal of software write pulse
      hwre:     "true",
      fields: [
        {
          bits: "5+3:5", // 2 bits for status
          name: "CL_STATUS",
          desc: "Contain the current status of the corresponding cache line                [0]: valid, [1]: dirty, [2]: cmpt",
        }
      ]
    },
    { name:     "TAG_729",
      desc:     "Tag Address stored in cache line 729",
      swaccess: "rw",
      hwaccess: "hrw",
      hwext:    "true",
      hwqe:     "true", // enable `qe` latched signal of software write pulse
      hwre:     "true",
      fields: [
        { bits: "5-1:0",
          name: "CL_TAG",
          desc: "Tag Address"
        }
      ]
    },
    {
      name:     "STATUS_730",
      desc:     "Status register of cache line 730",
      swaccess: "rw",
      hwaccess: "hrw",
      hwext:    "true",
      hwqe:     "true", // enable `qe` latched signal of software write pulse
      hwre:     "true",
      fields: [
        {
          bits: "5+3:5", // 2 bits for status
          name: "CL_STATUS",
          desc: "Contain the current status of the corresponding cache line                [0]: valid, [1]: dirty, [2]: cmpt",
        }
      ]
    },
    { name:     "TAG_730",
      desc:     "Tag Address stored in cache line 730",
      swaccess: "rw",
      hwaccess: "hrw",
      hwext:    "true",
      hwqe:     "true", // enable `qe` latched signal of software write pulse
      hwre:     "true",
      fields: [
        { bits: "5-1:0",
          name: "CL_TAG",
          desc: "Tag Address"
        }
      ]
    },
    {
      name:     "STATUS_731",
      desc:     "Status register of cache line 731",
      swaccess: "rw",
      hwaccess: "hrw",
      hwext:    "true",
      hwqe:     "true", // enable `qe` latched signal of software write pulse
      hwre:     "true",
      fields: [
        {
          bits: "5+3:5", // 2 bits for status
          name: "CL_STATUS",
          desc: "Contain the current status of the corresponding cache line                [0]: valid, [1]: dirty, [2]: cmpt",
        }
      ]
    },
    { name:     "TAG_731",
      desc:     "Tag Address stored in cache line 731",
      swaccess: "rw",
      hwaccess: "hrw",
      hwext:    "true",
      hwqe:     "true", // enable `qe` latched signal of software write pulse
      hwre:     "true",
      fields: [
        { bits: "5-1:0",
          name: "CL_TAG",
          desc: "Tag Address"
        }
      ]
    },
    {
      name:     "STATUS_732",
      desc:     "Status register of cache line 732",
      swaccess: "rw",
      hwaccess: "hrw",
      hwext:    "true",
      hwqe:     "true", // enable `qe` latched signal of software write pulse
      hwre:     "true",
      fields: [
        {
          bits: "5+3:5", // 2 bits for status
          name: "CL_STATUS",
          desc: "Contain the current status of the corresponding cache line                [0]: valid, [1]: dirty, [2]: cmpt",
        }
      ]
    },
    { name:     "TAG_732",
      desc:     "Tag Address stored in cache line 732",
      swaccess: "rw",
      hwaccess: "hrw",
      hwext:    "true",
      hwqe:     "true", // enable `qe` latched signal of software write pulse
      hwre:     "true",
      fields: [
        { bits: "5-1:0",
          name: "CL_TAG",
          desc: "Tag Address"
        }
      ]
    },
    {
      name:     "STATUS_733",
      desc:     "Status register of cache line 733",
      swaccess: "rw",
      hwaccess: "hrw",
      hwext:    "true",
      hwqe:     "true", // enable `qe` latched signal of software write pulse
      hwre:     "true",
      fields: [
        {
          bits: "5+3:5", // 2 bits for status
          name: "CL_STATUS",
          desc: "Contain the current status of the corresponding cache line                [0]: valid, [1]: dirty, [2]: cmpt",
        }
      ]
    },
    { name:     "TAG_733",
      desc:     "Tag Address stored in cache line 733",
      swaccess: "rw",
      hwaccess: "hrw",
      hwext:    "true",
      hwqe:     "true", // enable `qe` latched signal of software write pulse
      hwre:     "true",
      fields: [
        { bits: "5-1:0",
          name: "CL_TAG",
          desc: "Tag Address"
        }
      ]
    },
    {
      name:     "STATUS_734",
      desc:     "Status register of cache line 734",
      swaccess: "rw",
      hwaccess: "hrw",
      hwext:    "true",
      hwqe:     "true", // enable `qe` latched signal of software write pulse
      hwre:     "true",
      fields: [
        {
          bits: "5+3:5", // 2 bits for status
          name: "CL_STATUS",
          desc: "Contain the current status of the corresponding cache line                [0]: valid, [1]: dirty, [2]: cmpt",
        }
      ]
    },
    { name:     "TAG_734",
      desc:     "Tag Address stored in cache line 734",
      swaccess: "rw",
      hwaccess: "hrw",
      hwext:    "true",
      hwqe:     "true", // enable `qe` latched signal of software write pulse
      hwre:     "true",
      fields: [
        { bits: "5-1:0",
          name: "CL_TAG",
          desc: "Tag Address"
        }
      ]
    },
    {
      name:     "STATUS_735",
      desc:     "Status register of cache line 735",
      swaccess: "rw",
      hwaccess: "hrw",
      hwext:    "true",
      hwqe:     "true", // enable `qe` latched signal of software write pulse
      hwre:     "true",
      fields: [
        {
          bits: "5+3:5", // 2 bits for status
          name: "CL_STATUS",
          desc: "Contain the current status of the corresponding cache line                [0]: valid, [1]: dirty, [2]: cmpt",
        }
      ]
    },
    { name:     "TAG_735",
      desc:     "Tag Address stored in cache line 735",
      swaccess: "rw",
      hwaccess: "hrw",
      hwext:    "true",
      hwqe:     "true", // enable `qe` latched signal of software write pulse
      hwre:     "true",
      fields: [
        { bits: "5-1:0",
          name: "CL_TAG",
          desc: "Tag Address"
        }
      ]
    },
    {
      name:     "STATUS_736",
      desc:     "Status register of cache line 736",
      swaccess: "rw",
      hwaccess: "hrw",
      hwext:    "true",
      hwqe:     "true", // enable `qe` latched signal of software write pulse
      hwre:     "true",
      fields: [
        {
          bits: "5+3:5", // 2 bits for status
          name: "CL_STATUS",
          desc: "Contain the current status of the corresponding cache line                [0]: valid, [1]: dirty, [2]: cmpt",
        }
      ]
    },
    { name:     "TAG_736",
      desc:     "Tag Address stored in cache line 736",
      swaccess: "rw",
      hwaccess: "hrw",
      hwext:    "true",
      hwqe:     "true", // enable `qe` latched signal of software write pulse
      hwre:     "true",
      fields: [
        { bits: "5-1:0",
          name: "CL_TAG",
          desc: "Tag Address"
        }
      ]
    },
    {
      name:     "STATUS_737",
      desc:     "Status register of cache line 737",
      swaccess: "rw",
      hwaccess: "hrw",
      hwext:    "true",
      hwqe:     "true", // enable `qe` latched signal of software write pulse
      hwre:     "true",
      fields: [
        {
          bits: "5+3:5", // 2 bits for status
          name: "CL_STATUS",
          desc: "Contain the current status of the corresponding cache line                [0]: valid, [1]: dirty, [2]: cmpt",
        }
      ]
    },
    { name:     "TAG_737",
      desc:     "Tag Address stored in cache line 737",
      swaccess: "rw",
      hwaccess: "hrw",
      hwext:    "true",
      hwqe:     "true", // enable `qe` latched signal of software write pulse
      hwre:     "true",
      fields: [
        { bits: "5-1:0",
          name: "CL_TAG",
          desc: "Tag Address"
        }
      ]
    },
    {
      name:     "STATUS_738",
      desc:     "Status register of cache line 738",
      swaccess: "rw",
      hwaccess: "hrw",
      hwext:    "true",
      hwqe:     "true", // enable `qe` latched signal of software write pulse
      hwre:     "true",
      fields: [
        {
          bits: "5+3:5", // 2 bits for status
          name: "CL_STATUS",
          desc: "Contain the current status of the corresponding cache line                [0]: valid, [1]: dirty, [2]: cmpt",
        }
      ]
    },
    { name:     "TAG_738",
      desc:     "Tag Address stored in cache line 738",
      swaccess: "rw",
      hwaccess: "hrw",
      hwext:    "true",
      hwqe:     "true", // enable `qe` latched signal of software write pulse
      hwre:     "true",
      fields: [
        { bits: "5-1:0",
          name: "CL_TAG",
          desc: "Tag Address"
        }
      ]
    },
    {
      name:     "STATUS_739",
      desc:     "Status register of cache line 739",
      swaccess: "rw",
      hwaccess: "hrw",
      hwext:    "true",
      hwqe:     "true", // enable `qe` latched signal of software write pulse
      hwre:     "true",
      fields: [
        {
          bits: "5+3:5", // 2 bits for status
          name: "CL_STATUS",
          desc: "Contain the current status of the corresponding cache line                [0]: valid, [1]: dirty, [2]: cmpt",
        }
      ]
    },
    { name:     "TAG_739",
      desc:     "Tag Address stored in cache line 739",
      swaccess: "rw",
      hwaccess: "hrw",
      hwext:    "true",
      hwqe:     "true", // enable `qe` latched signal of software write pulse
      hwre:     "true",
      fields: [
        { bits: "5-1:0",
          name: "CL_TAG",
          desc: "Tag Address"
        }
      ]
    },
    {
      name:     "STATUS_740",
      desc:     "Status register of cache line 740",
      swaccess: "rw",
      hwaccess: "hrw",
      hwext:    "true",
      hwqe:     "true", // enable `qe` latched signal of software write pulse
      hwre:     "true",
      fields: [
        {
          bits: "5+3:5", // 2 bits for status
          name: "CL_STATUS",
          desc: "Contain the current status of the corresponding cache line                [0]: valid, [1]: dirty, [2]: cmpt",
        }
      ]
    },
    { name:     "TAG_740",
      desc:     "Tag Address stored in cache line 740",
      swaccess: "rw",
      hwaccess: "hrw",
      hwext:    "true",
      hwqe:     "true", // enable `qe` latched signal of software write pulse
      hwre:     "true",
      fields: [
        { bits: "5-1:0",
          name: "CL_TAG",
          desc: "Tag Address"
        }
      ]
    },
    {
      name:     "STATUS_741",
      desc:     "Status register of cache line 741",
      swaccess: "rw",
      hwaccess: "hrw",
      hwext:    "true",
      hwqe:     "true", // enable `qe` latched signal of software write pulse
      hwre:     "true",
      fields: [
        {
          bits: "5+3:5", // 2 bits for status
          name: "CL_STATUS",
          desc: "Contain the current status of the corresponding cache line                [0]: valid, [1]: dirty, [2]: cmpt",
        }
      ]
    },
    { name:     "TAG_741",
      desc:     "Tag Address stored in cache line 741",
      swaccess: "rw",
      hwaccess: "hrw",
      hwext:    "true",
      hwqe:     "true", // enable `qe` latched signal of software write pulse
      hwre:     "true",
      fields: [
        { bits: "5-1:0",
          name: "CL_TAG",
          desc: "Tag Address"
        }
      ]
    },
    {
      name:     "STATUS_742",
      desc:     "Status register of cache line 742",
      swaccess: "rw",
      hwaccess: "hrw",
      hwext:    "true",
      hwqe:     "true", // enable `qe` latched signal of software write pulse
      hwre:     "true",
      fields: [
        {
          bits: "5+3:5", // 2 bits for status
          name: "CL_STATUS",
          desc: "Contain the current status of the corresponding cache line                [0]: valid, [1]: dirty, [2]: cmpt",
        }
      ]
    },
    { name:     "TAG_742",
      desc:     "Tag Address stored in cache line 742",
      swaccess: "rw",
      hwaccess: "hrw",
      hwext:    "true",
      hwqe:     "true", // enable `qe` latched signal of software write pulse
      hwre:     "true",
      fields: [
        { bits: "5-1:0",
          name: "CL_TAG",
          desc: "Tag Address"
        }
      ]
    },
    {
      name:     "STATUS_743",
      desc:     "Status register of cache line 743",
      swaccess: "rw",
      hwaccess: "hrw",
      hwext:    "true",
      hwqe:     "true", // enable `qe` latched signal of software write pulse
      hwre:     "true",
      fields: [
        {
          bits: "5+3:5", // 2 bits for status
          name: "CL_STATUS",
          desc: "Contain the current status of the corresponding cache line                [0]: valid, [1]: dirty, [2]: cmpt",
        }
      ]
    },
    { name:     "TAG_743",
      desc:     "Tag Address stored in cache line 743",
      swaccess: "rw",
      hwaccess: "hrw",
      hwext:    "true",
      hwqe:     "true", // enable `qe` latched signal of software write pulse
      hwre:     "true",
      fields: [
        { bits: "5-1:0",
          name: "CL_TAG",
          desc: "Tag Address"
        }
      ]
    },
    {
      name:     "STATUS_744",
      desc:     "Status register of cache line 744",
      swaccess: "rw",
      hwaccess: "hrw",
      hwext:    "true",
      hwqe:     "true", // enable `qe` latched signal of software write pulse
      hwre:     "true",
      fields: [
        {
          bits: "5+3:5", // 2 bits for status
          name: "CL_STATUS",
          desc: "Contain the current status of the corresponding cache line                [0]: valid, [1]: dirty, [2]: cmpt",
        }
      ]
    },
    { name:     "TAG_744",
      desc:     "Tag Address stored in cache line 744",
      swaccess: "rw",
      hwaccess: "hrw",
      hwext:    "true",
      hwqe:     "true", // enable `qe` latched signal of software write pulse
      hwre:     "true",
      fields: [
        { bits: "5-1:0",
          name: "CL_TAG",
          desc: "Tag Address"
        }
      ]
    },
    {
      name:     "STATUS_745",
      desc:     "Status register of cache line 745",
      swaccess: "rw",
      hwaccess: "hrw",
      hwext:    "true",
      hwqe:     "true", // enable `qe` latched signal of software write pulse
      hwre:     "true",
      fields: [
        {
          bits: "5+3:5", // 2 bits for status
          name: "CL_STATUS",
          desc: "Contain the current status of the corresponding cache line                [0]: valid, [1]: dirty, [2]: cmpt",
        }
      ]
    },
    { name:     "TAG_745",
      desc:     "Tag Address stored in cache line 745",
      swaccess: "rw",
      hwaccess: "hrw",
      hwext:    "true",
      hwqe:     "true", // enable `qe` latched signal of software write pulse
      hwre:     "true",
      fields: [
        { bits: "5-1:0",
          name: "CL_TAG",
          desc: "Tag Address"
        }
      ]
    },
    {
      name:     "STATUS_746",
      desc:     "Status register of cache line 746",
      swaccess: "rw",
      hwaccess: "hrw",
      hwext:    "true",
      hwqe:     "true", // enable `qe` latched signal of software write pulse
      hwre:     "true",
      fields: [
        {
          bits: "5+3:5", // 2 bits for status
          name: "CL_STATUS",
          desc: "Contain the current status of the corresponding cache line                [0]: valid, [1]: dirty, [2]: cmpt",
        }
      ]
    },
    { name:     "TAG_746",
      desc:     "Tag Address stored in cache line 746",
      swaccess: "rw",
      hwaccess: "hrw",
      hwext:    "true",
      hwqe:     "true", // enable `qe` latched signal of software write pulse
      hwre:     "true",
      fields: [
        { bits: "5-1:0",
          name: "CL_TAG",
          desc: "Tag Address"
        }
      ]
    },
    {
      name:     "STATUS_747",
      desc:     "Status register of cache line 747",
      swaccess: "rw",
      hwaccess: "hrw",
      hwext:    "true",
      hwqe:     "true", // enable `qe` latched signal of software write pulse
      hwre:     "true",
      fields: [
        {
          bits: "5+3:5", // 2 bits for status
          name: "CL_STATUS",
          desc: "Contain the current status of the corresponding cache line                [0]: valid, [1]: dirty, [2]: cmpt",
        }
      ]
    },
    { name:     "TAG_747",
      desc:     "Tag Address stored in cache line 747",
      swaccess: "rw",
      hwaccess: "hrw",
      hwext:    "true",
      hwqe:     "true", // enable `qe` latched signal of software write pulse
      hwre:     "true",
      fields: [
        { bits: "5-1:0",
          name: "CL_TAG",
          desc: "Tag Address"
        }
      ]
    },
    {
      name:     "STATUS_748",
      desc:     "Status register of cache line 748",
      swaccess: "rw",
      hwaccess: "hrw",
      hwext:    "true",
      hwqe:     "true", // enable `qe` latched signal of software write pulse
      hwre:     "true",
      fields: [
        {
          bits: "5+3:5", // 2 bits for status
          name: "CL_STATUS",
          desc: "Contain the current status of the corresponding cache line                [0]: valid, [1]: dirty, [2]: cmpt",
        }
      ]
    },
    { name:     "TAG_748",
      desc:     "Tag Address stored in cache line 748",
      swaccess: "rw",
      hwaccess: "hrw",
      hwext:    "true",
      hwqe:     "true", // enable `qe` latched signal of software write pulse
      hwre:     "true",
      fields: [
        { bits: "5-1:0",
          name: "CL_TAG",
          desc: "Tag Address"
        }
      ]
    },
    {
      name:     "STATUS_749",
      desc:     "Status register of cache line 749",
      swaccess: "rw",
      hwaccess: "hrw",
      hwext:    "true",
      hwqe:     "true", // enable `qe` latched signal of software write pulse
      hwre:     "true",
      fields: [
        {
          bits: "5+3:5", // 2 bits for status
          name: "CL_STATUS",
          desc: "Contain the current status of the corresponding cache line                [0]: valid, [1]: dirty, [2]: cmpt",
        }
      ]
    },
    { name:     "TAG_749",
      desc:     "Tag Address stored in cache line 749",
      swaccess: "rw",
      hwaccess: "hrw",
      hwext:    "true",
      hwqe:     "true", // enable `qe` latched signal of software write pulse
      hwre:     "true",
      fields: [
        { bits: "5-1:0",
          name: "CL_TAG",
          desc: "Tag Address"
        }
      ]
    },
    {
      name:     "STATUS_750",
      desc:     "Status register of cache line 750",
      swaccess: "rw",
      hwaccess: "hrw",
      hwext:    "true",
      hwqe:     "true", // enable `qe` latched signal of software write pulse
      hwre:     "true",
      fields: [
        {
          bits: "5+3:5", // 2 bits for status
          name: "CL_STATUS",
          desc: "Contain the current status of the corresponding cache line                [0]: valid, [1]: dirty, [2]: cmpt",
        }
      ]
    },
    { name:     "TAG_750",
      desc:     "Tag Address stored in cache line 750",
      swaccess: "rw",
      hwaccess: "hrw",
      hwext:    "true",
      hwqe:     "true", // enable `qe` latched signal of software write pulse
      hwre:     "true",
      fields: [
        { bits: "5-1:0",
          name: "CL_TAG",
          desc: "Tag Address"
        }
      ]
    },
    {
      name:     "STATUS_751",
      desc:     "Status register of cache line 751",
      swaccess: "rw",
      hwaccess: "hrw",
      hwext:    "true",
      hwqe:     "true", // enable `qe` latched signal of software write pulse
      hwre:     "true",
      fields: [
        {
          bits: "5+3:5", // 2 bits for status
          name: "CL_STATUS",
          desc: "Contain the current status of the corresponding cache line                [0]: valid, [1]: dirty, [2]: cmpt",
        }
      ]
    },
    { name:     "TAG_751",
      desc:     "Tag Address stored in cache line 751",
      swaccess: "rw",
      hwaccess: "hrw",
      hwext:    "true",
      hwqe:     "true", // enable `qe` latched signal of software write pulse
      hwre:     "true",
      fields: [
        { bits: "5-1:0",
          name: "CL_TAG",
          desc: "Tag Address"
        }
      ]
    },
    {
      name:     "STATUS_752",
      desc:     "Status register of cache line 752",
      swaccess: "rw",
      hwaccess: "hrw",
      hwext:    "true",
      hwqe:     "true", // enable `qe` latched signal of software write pulse
      hwre:     "true",
      fields: [
        {
          bits: "5+3:5", // 2 bits for status
          name: "CL_STATUS",
          desc: "Contain the current status of the corresponding cache line                [0]: valid, [1]: dirty, [2]: cmpt",
        }
      ]
    },
    { name:     "TAG_752",
      desc:     "Tag Address stored in cache line 752",
      swaccess: "rw",
      hwaccess: "hrw",
      hwext:    "true",
      hwqe:     "true", // enable `qe` latched signal of software write pulse
      hwre:     "true",
      fields: [
        { bits: "5-1:0",
          name: "CL_TAG",
          desc: "Tag Address"
        }
      ]
    },
    {
      name:     "STATUS_753",
      desc:     "Status register of cache line 753",
      swaccess: "rw",
      hwaccess: "hrw",
      hwext:    "true",
      hwqe:     "true", // enable `qe` latched signal of software write pulse
      hwre:     "true",
      fields: [
        {
          bits: "5+3:5", // 2 bits for status
          name: "CL_STATUS",
          desc: "Contain the current status of the corresponding cache line                [0]: valid, [1]: dirty, [2]: cmpt",
        }
      ]
    },
    { name:     "TAG_753",
      desc:     "Tag Address stored in cache line 753",
      swaccess: "rw",
      hwaccess: "hrw",
      hwext:    "true",
      hwqe:     "true", // enable `qe` latched signal of software write pulse
      hwre:     "true",
      fields: [
        { bits: "5-1:0",
          name: "CL_TAG",
          desc: "Tag Address"
        }
      ]
    },
    {
      name:     "STATUS_754",
      desc:     "Status register of cache line 754",
      swaccess: "rw",
      hwaccess: "hrw",
      hwext:    "true",
      hwqe:     "true", // enable `qe` latched signal of software write pulse
      hwre:     "true",
      fields: [
        {
          bits: "5+3:5", // 2 bits for status
          name: "CL_STATUS",
          desc: "Contain the current status of the corresponding cache line                [0]: valid, [1]: dirty, [2]: cmpt",
        }
      ]
    },
    { name:     "TAG_754",
      desc:     "Tag Address stored in cache line 754",
      swaccess: "rw",
      hwaccess: "hrw",
      hwext:    "true",
      hwqe:     "true", // enable `qe` latched signal of software write pulse
      hwre:     "true",
      fields: [
        { bits: "5-1:0",
          name: "CL_TAG",
          desc: "Tag Address"
        }
      ]
    },
    {
      name:     "STATUS_755",
      desc:     "Status register of cache line 755",
      swaccess: "rw",
      hwaccess: "hrw",
      hwext:    "true",
      hwqe:     "true", // enable `qe` latched signal of software write pulse
      hwre:     "true",
      fields: [
        {
          bits: "5+3:5", // 2 bits for status
          name: "CL_STATUS",
          desc: "Contain the current status of the corresponding cache line                [0]: valid, [1]: dirty, [2]: cmpt",
        }
      ]
    },
    { name:     "TAG_755",
      desc:     "Tag Address stored in cache line 755",
      swaccess: "rw",
      hwaccess: "hrw",
      hwext:    "true",
      hwqe:     "true", // enable `qe` latched signal of software write pulse
      hwre:     "true",
      fields: [
        { bits: "5-1:0",
          name: "CL_TAG",
          desc: "Tag Address"
        }
      ]
    },
    {
      name:     "STATUS_756",
      desc:     "Status register of cache line 756",
      swaccess: "rw",
      hwaccess: "hrw",
      hwext:    "true",
      hwqe:     "true", // enable `qe` latched signal of software write pulse
      hwre:     "true",
      fields: [
        {
          bits: "5+3:5", // 2 bits for status
          name: "CL_STATUS",
          desc: "Contain the current status of the corresponding cache line                [0]: valid, [1]: dirty, [2]: cmpt",
        }
      ]
    },
    { name:     "TAG_756",
      desc:     "Tag Address stored in cache line 756",
      swaccess: "rw",
      hwaccess: "hrw",
      hwext:    "true",
      hwqe:     "true", // enable `qe` latched signal of software write pulse
      hwre:     "true",
      fields: [
        { bits: "5-1:0",
          name: "CL_TAG",
          desc: "Tag Address"
        }
      ]
    },
    {
      name:     "STATUS_757",
      desc:     "Status register of cache line 757",
      swaccess: "rw",
      hwaccess: "hrw",
      hwext:    "true",
      hwqe:     "true", // enable `qe` latched signal of software write pulse
      hwre:     "true",
      fields: [
        {
          bits: "5+3:5", // 2 bits for status
          name: "CL_STATUS",
          desc: "Contain the current status of the corresponding cache line                [0]: valid, [1]: dirty, [2]: cmpt",
        }
      ]
    },
    { name:     "TAG_757",
      desc:     "Tag Address stored in cache line 757",
      swaccess: "rw",
      hwaccess: "hrw",
      hwext:    "true",
      hwqe:     "true", // enable `qe` latched signal of software write pulse
      hwre:     "true",
      fields: [
        { bits: "5-1:0",
          name: "CL_TAG",
          desc: "Tag Address"
        }
      ]
    },
    {
      name:     "STATUS_758",
      desc:     "Status register of cache line 758",
      swaccess: "rw",
      hwaccess: "hrw",
      hwext:    "true",
      hwqe:     "true", // enable `qe` latched signal of software write pulse
      hwre:     "true",
      fields: [
        {
          bits: "5+3:5", // 2 bits for status
          name: "CL_STATUS",
          desc: "Contain the current status of the corresponding cache line                [0]: valid, [1]: dirty, [2]: cmpt",
        }
      ]
    },
    { name:     "TAG_758",
      desc:     "Tag Address stored in cache line 758",
      swaccess: "rw",
      hwaccess: "hrw",
      hwext:    "true",
      hwqe:     "true", // enable `qe` latched signal of software write pulse
      hwre:     "true",
      fields: [
        { bits: "5-1:0",
          name: "CL_TAG",
          desc: "Tag Address"
        }
      ]
    },
    {
      name:     "STATUS_759",
      desc:     "Status register of cache line 759",
      swaccess: "rw",
      hwaccess: "hrw",
      hwext:    "true",
      hwqe:     "true", // enable `qe` latched signal of software write pulse
      hwre:     "true",
      fields: [
        {
          bits: "5+3:5", // 2 bits for status
          name: "CL_STATUS",
          desc: "Contain the current status of the corresponding cache line                [0]: valid, [1]: dirty, [2]: cmpt",
        }
      ]
    },
    { name:     "TAG_759",
      desc:     "Tag Address stored in cache line 759",
      swaccess: "rw",
      hwaccess: "hrw",
      hwext:    "true",
      hwqe:     "true", // enable `qe` latched signal of software write pulse
      hwre:     "true",
      fields: [
        { bits: "5-1:0",
          name: "CL_TAG",
          desc: "Tag Address"
        }
      ]
    },
    {
      name:     "STATUS_760",
      desc:     "Status register of cache line 760",
      swaccess: "rw",
      hwaccess: "hrw",
      hwext:    "true",
      hwqe:     "true", // enable `qe` latched signal of software write pulse
      hwre:     "true",
      fields: [
        {
          bits: "5+3:5", // 2 bits for status
          name: "CL_STATUS",
          desc: "Contain the current status of the corresponding cache line                [0]: valid, [1]: dirty, [2]: cmpt",
        }
      ]
    },
    { name:     "TAG_760",
      desc:     "Tag Address stored in cache line 760",
      swaccess: "rw",
      hwaccess: "hrw",
      hwext:    "true",
      hwqe:     "true", // enable `qe` latched signal of software write pulse
      hwre:     "true",
      fields: [
        { bits: "5-1:0",
          name: "CL_TAG",
          desc: "Tag Address"
        }
      ]
    },
    {
      name:     "STATUS_761",
      desc:     "Status register of cache line 761",
      swaccess: "rw",
      hwaccess: "hrw",
      hwext:    "true",
      hwqe:     "true", // enable `qe` latched signal of software write pulse
      hwre:     "true",
      fields: [
        {
          bits: "5+3:5", // 2 bits for status
          name: "CL_STATUS",
          desc: "Contain the current status of the corresponding cache line                [0]: valid, [1]: dirty, [2]: cmpt",
        }
      ]
    },
    { name:     "TAG_761",
      desc:     "Tag Address stored in cache line 761",
      swaccess: "rw",
      hwaccess: "hrw",
      hwext:    "true",
      hwqe:     "true", // enable `qe` latched signal of software write pulse
      hwre:     "true",
      fields: [
        { bits: "5-1:0",
          name: "CL_TAG",
          desc: "Tag Address"
        }
      ]
    },
    {
      name:     "STATUS_762",
      desc:     "Status register of cache line 762",
      swaccess: "rw",
      hwaccess: "hrw",
      hwext:    "true",
      hwqe:     "true", // enable `qe` latched signal of software write pulse
      hwre:     "true",
      fields: [
        {
          bits: "5+3:5", // 2 bits for status
          name: "CL_STATUS",
          desc: "Contain the current status of the corresponding cache line                [0]: valid, [1]: dirty, [2]: cmpt",
        }
      ]
    },
    { name:     "TAG_762",
      desc:     "Tag Address stored in cache line 762",
      swaccess: "rw",
      hwaccess: "hrw",
      hwext:    "true",
      hwqe:     "true", // enable `qe` latched signal of software write pulse
      hwre:     "true",
      fields: [
        { bits: "5-1:0",
          name: "CL_TAG",
          desc: "Tag Address"
        }
      ]
    },
    {
      name:     "STATUS_763",
      desc:     "Status register of cache line 763",
      swaccess: "rw",
      hwaccess: "hrw",
      hwext:    "true",
      hwqe:     "true", // enable `qe` latched signal of software write pulse
      hwre:     "true",
      fields: [
        {
          bits: "5+3:5", // 2 bits for status
          name: "CL_STATUS",
          desc: "Contain the current status of the corresponding cache line                [0]: valid, [1]: dirty, [2]: cmpt",
        }
      ]
    },
    { name:     "TAG_763",
      desc:     "Tag Address stored in cache line 763",
      swaccess: "rw",
      hwaccess: "hrw",
      hwext:    "true",
      hwqe:     "true", // enable `qe` latched signal of software write pulse
      hwre:     "true",
      fields: [
        { bits: "5-1:0",
          name: "CL_TAG",
          desc: "Tag Address"
        }
      ]
    },
    {
      name:     "STATUS_764",
      desc:     "Status register of cache line 764",
      swaccess: "rw",
      hwaccess: "hrw",
      hwext:    "true",
      hwqe:     "true", // enable `qe` latched signal of software write pulse
      hwre:     "true",
      fields: [
        {
          bits: "5+3:5", // 2 bits for status
          name: "CL_STATUS",
          desc: "Contain the current status of the corresponding cache line                [0]: valid, [1]: dirty, [2]: cmpt",
        }
      ]
    },
    { name:     "TAG_764",
      desc:     "Tag Address stored in cache line 764",
      swaccess: "rw",
      hwaccess: "hrw",
      hwext:    "true",
      hwqe:     "true", // enable `qe` latched signal of software write pulse
      hwre:     "true",
      fields: [
        { bits: "5-1:0",
          name: "CL_TAG",
          desc: "Tag Address"
        }
      ]
    },
    {
      name:     "STATUS_765",
      desc:     "Status register of cache line 765",
      swaccess: "rw",
      hwaccess: "hrw",
      hwext:    "true",
      hwqe:     "true", // enable `qe` latched signal of software write pulse
      hwre:     "true",
      fields: [
        {
          bits: "5+3:5", // 2 bits for status
          name: "CL_STATUS",
          desc: "Contain the current status of the corresponding cache line                [0]: valid, [1]: dirty, [2]: cmpt",
        }
      ]
    },
    { name:     "TAG_765",
      desc:     "Tag Address stored in cache line 765",
      swaccess: "rw",
      hwaccess: "hrw",
      hwext:    "true",
      hwqe:     "true", // enable `qe` latched signal of software write pulse
      hwre:     "true",
      fields: [
        { bits: "5-1:0",
          name: "CL_TAG",
          desc: "Tag Address"
        }
      ]
    },
    {
      name:     "STATUS_766",
      desc:     "Status register of cache line 766",
      swaccess: "rw",
      hwaccess: "hrw",
      hwext:    "true",
      hwqe:     "true", // enable `qe` latched signal of software write pulse
      hwre:     "true",
      fields: [
        {
          bits: "5+3:5", // 2 bits for status
          name: "CL_STATUS",
          desc: "Contain the current status of the corresponding cache line                [0]: valid, [1]: dirty, [2]: cmpt",
        }
      ]
    },
    { name:     "TAG_766",
      desc:     "Tag Address stored in cache line 766",
      swaccess: "rw",
      hwaccess: "hrw",
      hwext:    "true",
      hwqe:     "true", // enable `qe` latched signal of software write pulse
      hwre:     "true",
      fields: [
        { bits: "5-1:0",
          name: "CL_TAG",
          desc: "Tag Address"
        }
      ]
    },
    {
      name:     "STATUS_767",
      desc:     "Status register of cache line 767",
      swaccess: "rw",
      hwaccess: "hrw",
      hwext:    "true",
      hwqe:     "true", // enable `qe` latched signal of software write pulse
      hwre:     "true",
      fields: [
        {
          bits: "5+3:5", // 2 bits for status
          name: "CL_STATUS",
          desc: "Contain the current status of the corresponding cache line                [0]: valid, [1]: dirty, [2]: cmpt",
        }
      ]
    },
    { name:     "TAG_767",
      desc:     "Tag Address stored in cache line 767",
      swaccess: "rw",
      hwaccess: "hrw",
      hwext:    "true",
      hwqe:     "true", // enable `qe` latched signal of software write pulse
      hwre:     "true",
      fields: [
        { bits: "5-1:0",
          name: "CL_TAG",
          desc: "Tag Address"
        }
      ]
    },
    {
      name:     "STATUS_768",
      desc:     "Status register of cache line 768",
      swaccess: "rw",
      hwaccess: "hrw",
      hwext:    "true",
      hwqe:     "true", // enable `qe` latched signal of software write pulse
      hwre:     "true",
      fields: [
        {
          bits: "5+3:5", // 2 bits for status
          name: "CL_STATUS",
          desc: "Contain the current status of the corresponding cache line                [0]: valid, [1]: dirty, [2]: cmpt",
        }
      ]
    },
    { name:     "TAG_768",
      desc:     "Tag Address stored in cache line 768",
      swaccess: "rw",
      hwaccess: "hrw",
      hwext:    "true",
      hwqe:     "true", // enable `qe` latched signal of software write pulse
      hwre:     "true",
      fields: [
        { bits: "5-1:0",
          name: "CL_TAG",
          desc: "Tag Address"
        }
      ]
    },
    {
      name:     "STATUS_769",
      desc:     "Status register of cache line 769",
      swaccess: "rw",
      hwaccess: "hrw",
      hwext:    "true",
      hwqe:     "true", // enable `qe` latched signal of software write pulse
      hwre:     "true",
      fields: [
        {
          bits: "5+3:5", // 2 bits for status
          name: "CL_STATUS",
          desc: "Contain the current status of the corresponding cache line                [0]: valid, [1]: dirty, [2]: cmpt",
        }
      ]
    },
    { name:     "TAG_769",
      desc:     "Tag Address stored in cache line 769",
      swaccess: "rw",
      hwaccess: "hrw",
      hwext:    "true",
      hwqe:     "true", // enable `qe` latched signal of software write pulse
      hwre:     "true",
      fields: [
        { bits: "5-1:0",
          name: "CL_TAG",
          desc: "Tag Address"
        }
      ]
    },
    {
      name:     "STATUS_770",
      desc:     "Status register of cache line 770",
      swaccess: "rw",
      hwaccess: "hrw",
      hwext:    "true",
      hwqe:     "true", // enable `qe` latched signal of software write pulse
      hwre:     "true",
      fields: [
        {
          bits: "5+3:5", // 2 bits for status
          name: "CL_STATUS",
          desc: "Contain the current status of the corresponding cache line                [0]: valid, [1]: dirty, [2]: cmpt",
        }
      ]
    },
    { name:     "TAG_770",
      desc:     "Tag Address stored in cache line 770",
      swaccess: "rw",
      hwaccess: "hrw",
      hwext:    "true",
      hwqe:     "true", // enable `qe` latched signal of software write pulse
      hwre:     "true",
      fields: [
        { bits: "5-1:0",
          name: "CL_TAG",
          desc: "Tag Address"
        }
      ]
    },
    {
      name:     "STATUS_771",
      desc:     "Status register of cache line 771",
      swaccess: "rw",
      hwaccess: "hrw",
      hwext:    "true",
      hwqe:     "true", // enable `qe` latched signal of software write pulse
      hwre:     "true",
      fields: [
        {
          bits: "5+3:5", // 2 bits for status
          name: "CL_STATUS",
          desc: "Contain the current status of the corresponding cache line                [0]: valid, [1]: dirty, [2]: cmpt",
        }
      ]
    },
    { name:     "TAG_771",
      desc:     "Tag Address stored in cache line 771",
      swaccess: "rw",
      hwaccess: "hrw",
      hwext:    "true",
      hwqe:     "true", // enable `qe` latched signal of software write pulse
      hwre:     "true",
      fields: [
        { bits: "5-1:0",
          name: "CL_TAG",
          desc: "Tag Address"
        }
      ]
    },
    {
      name:     "STATUS_772",
      desc:     "Status register of cache line 772",
      swaccess: "rw",
      hwaccess: "hrw",
      hwext:    "true",
      hwqe:     "true", // enable `qe` latched signal of software write pulse
      hwre:     "true",
      fields: [
        {
          bits: "5+3:5", // 2 bits for status
          name: "CL_STATUS",
          desc: "Contain the current status of the corresponding cache line                [0]: valid, [1]: dirty, [2]: cmpt",
        }
      ]
    },
    { name:     "TAG_772",
      desc:     "Tag Address stored in cache line 772",
      swaccess: "rw",
      hwaccess: "hrw",
      hwext:    "true",
      hwqe:     "true", // enable `qe` latched signal of software write pulse
      hwre:     "true",
      fields: [
        { bits: "5-1:0",
          name: "CL_TAG",
          desc: "Tag Address"
        }
      ]
    },
    {
      name:     "STATUS_773",
      desc:     "Status register of cache line 773",
      swaccess: "rw",
      hwaccess: "hrw",
      hwext:    "true",
      hwqe:     "true", // enable `qe` latched signal of software write pulse
      hwre:     "true",
      fields: [
        {
          bits: "5+3:5", // 2 bits for status
          name: "CL_STATUS",
          desc: "Contain the current status of the corresponding cache line                [0]: valid, [1]: dirty, [2]: cmpt",
        }
      ]
    },
    { name:     "TAG_773",
      desc:     "Tag Address stored in cache line 773",
      swaccess: "rw",
      hwaccess: "hrw",
      hwext:    "true",
      hwqe:     "true", // enable `qe` latched signal of software write pulse
      hwre:     "true",
      fields: [
        { bits: "5-1:0",
          name: "CL_TAG",
          desc: "Tag Address"
        }
      ]
    },
    {
      name:     "STATUS_774",
      desc:     "Status register of cache line 774",
      swaccess: "rw",
      hwaccess: "hrw",
      hwext:    "true",
      hwqe:     "true", // enable `qe` latched signal of software write pulse
      hwre:     "true",
      fields: [
        {
          bits: "5+3:5", // 2 bits for status
          name: "CL_STATUS",
          desc: "Contain the current status of the corresponding cache line                [0]: valid, [1]: dirty, [2]: cmpt",
        }
      ]
    },
    { name:     "TAG_774",
      desc:     "Tag Address stored in cache line 774",
      swaccess: "rw",
      hwaccess: "hrw",
      hwext:    "true",
      hwqe:     "true", // enable `qe` latched signal of software write pulse
      hwre:     "true",
      fields: [
        { bits: "5-1:0",
          name: "CL_TAG",
          desc: "Tag Address"
        }
      ]
    },
    {
      name:     "STATUS_775",
      desc:     "Status register of cache line 775",
      swaccess: "rw",
      hwaccess: "hrw",
      hwext:    "true",
      hwqe:     "true", // enable `qe` latched signal of software write pulse
      hwre:     "true",
      fields: [
        {
          bits: "5+3:5", // 2 bits for status
          name: "CL_STATUS",
          desc: "Contain the current status of the corresponding cache line                [0]: valid, [1]: dirty, [2]: cmpt",
        }
      ]
    },
    { name:     "TAG_775",
      desc:     "Tag Address stored in cache line 775",
      swaccess: "rw",
      hwaccess: "hrw",
      hwext:    "true",
      hwqe:     "true", // enable `qe` latched signal of software write pulse
      hwre:     "true",
      fields: [
        { bits: "5-1:0",
          name: "CL_TAG",
          desc: "Tag Address"
        }
      ]
    },
    {
      name:     "STATUS_776",
      desc:     "Status register of cache line 776",
      swaccess: "rw",
      hwaccess: "hrw",
      hwext:    "true",
      hwqe:     "true", // enable `qe` latched signal of software write pulse
      hwre:     "true",
      fields: [
        {
          bits: "5+3:5", // 2 bits for status
          name: "CL_STATUS",
          desc: "Contain the current status of the corresponding cache line                [0]: valid, [1]: dirty, [2]: cmpt",
        }
      ]
    },
    { name:     "TAG_776",
      desc:     "Tag Address stored in cache line 776",
      swaccess: "rw",
      hwaccess: "hrw",
      hwext:    "true",
      hwqe:     "true", // enable `qe` latched signal of software write pulse
      hwre:     "true",
      fields: [
        { bits: "5-1:0",
          name: "CL_TAG",
          desc: "Tag Address"
        }
      ]
    },
    {
      name:     "STATUS_777",
      desc:     "Status register of cache line 777",
      swaccess: "rw",
      hwaccess: "hrw",
      hwext:    "true",
      hwqe:     "true", // enable `qe` latched signal of software write pulse
      hwre:     "true",
      fields: [
        {
          bits: "5+3:5", // 2 bits for status
          name: "CL_STATUS",
          desc: "Contain the current status of the corresponding cache line                [0]: valid, [1]: dirty, [2]: cmpt",
        }
      ]
    },
    { name:     "TAG_777",
      desc:     "Tag Address stored in cache line 777",
      swaccess: "rw",
      hwaccess: "hrw",
      hwext:    "true",
      hwqe:     "true", // enable `qe` latched signal of software write pulse
      hwre:     "true",
      fields: [
        { bits: "5-1:0",
          name: "CL_TAG",
          desc: "Tag Address"
        }
      ]
    },
    {
      name:     "STATUS_778",
      desc:     "Status register of cache line 778",
      swaccess: "rw",
      hwaccess: "hrw",
      hwext:    "true",
      hwqe:     "true", // enable `qe` latched signal of software write pulse
      hwre:     "true",
      fields: [
        {
          bits: "5+3:5", // 2 bits for status
          name: "CL_STATUS",
          desc: "Contain the current status of the corresponding cache line                [0]: valid, [1]: dirty, [2]: cmpt",
        }
      ]
    },
    { name:     "TAG_778",
      desc:     "Tag Address stored in cache line 778",
      swaccess: "rw",
      hwaccess: "hrw",
      hwext:    "true",
      hwqe:     "true", // enable `qe` latched signal of software write pulse
      hwre:     "true",
      fields: [
        { bits: "5-1:0",
          name: "CL_TAG",
          desc: "Tag Address"
        }
      ]
    },
    {
      name:     "STATUS_779",
      desc:     "Status register of cache line 779",
      swaccess: "rw",
      hwaccess: "hrw",
      hwext:    "true",
      hwqe:     "true", // enable `qe` latched signal of software write pulse
      hwre:     "true",
      fields: [
        {
          bits: "5+3:5", // 2 bits for status
          name: "CL_STATUS",
          desc: "Contain the current status of the corresponding cache line                [0]: valid, [1]: dirty, [2]: cmpt",
        }
      ]
    },
    { name:     "TAG_779",
      desc:     "Tag Address stored in cache line 779",
      swaccess: "rw",
      hwaccess: "hrw",
      hwext:    "true",
      hwqe:     "true", // enable `qe` latched signal of software write pulse
      hwre:     "true",
      fields: [
        { bits: "5-1:0",
          name: "CL_TAG",
          desc: "Tag Address"
        }
      ]
    },
    {
      name:     "STATUS_780",
      desc:     "Status register of cache line 780",
      swaccess: "rw",
      hwaccess: "hrw",
      hwext:    "true",
      hwqe:     "true", // enable `qe` latched signal of software write pulse
      hwre:     "true",
      fields: [
        {
          bits: "5+3:5", // 2 bits for status
          name: "CL_STATUS",
          desc: "Contain the current status of the corresponding cache line                [0]: valid, [1]: dirty, [2]: cmpt",
        }
      ]
    },
    { name:     "TAG_780",
      desc:     "Tag Address stored in cache line 780",
      swaccess: "rw",
      hwaccess: "hrw",
      hwext:    "true",
      hwqe:     "true", // enable `qe` latched signal of software write pulse
      hwre:     "true",
      fields: [
        { bits: "5-1:0",
          name: "CL_TAG",
          desc: "Tag Address"
        }
      ]
    },
    {
      name:     "STATUS_781",
      desc:     "Status register of cache line 781",
      swaccess: "rw",
      hwaccess: "hrw",
      hwext:    "true",
      hwqe:     "true", // enable `qe` latched signal of software write pulse
      hwre:     "true",
      fields: [
        {
          bits: "5+3:5", // 2 bits for status
          name: "CL_STATUS",
          desc: "Contain the current status of the corresponding cache line                [0]: valid, [1]: dirty, [2]: cmpt",
        }
      ]
    },
    { name:     "TAG_781",
      desc:     "Tag Address stored in cache line 781",
      swaccess: "rw",
      hwaccess: "hrw",
      hwext:    "true",
      hwqe:     "true", // enable `qe` latched signal of software write pulse
      hwre:     "true",
      fields: [
        { bits: "5-1:0",
          name: "CL_TAG",
          desc: "Tag Address"
        }
      ]
    },
    {
      name:     "STATUS_782",
      desc:     "Status register of cache line 782",
      swaccess: "rw",
      hwaccess: "hrw",
      hwext:    "true",
      hwqe:     "true", // enable `qe` latched signal of software write pulse
      hwre:     "true",
      fields: [
        {
          bits: "5+3:5", // 2 bits for status
          name: "CL_STATUS",
          desc: "Contain the current status of the corresponding cache line                [0]: valid, [1]: dirty, [2]: cmpt",
        }
      ]
    },
    { name:     "TAG_782",
      desc:     "Tag Address stored in cache line 782",
      swaccess: "rw",
      hwaccess: "hrw",
      hwext:    "true",
      hwqe:     "true", // enable `qe` latched signal of software write pulse
      hwre:     "true",
      fields: [
        { bits: "5-1:0",
          name: "CL_TAG",
          desc: "Tag Address"
        }
      ]
    },
    {
      name:     "STATUS_783",
      desc:     "Status register of cache line 783",
      swaccess: "rw",
      hwaccess: "hrw",
      hwext:    "true",
      hwqe:     "true", // enable `qe` latched signal of software write pulse
      hwre:     "true",
      fields: [
        {
          bits: "5+3:5", // 2 bits for status
          name: "CL_STATUS",
          desc: "Contain the current status of the corresponding cache line                [0]: valid, [1]: dirty, [2]: cmpt",
        }
      ]
    },
    { name:     "TAG_783",
      desc:     "Tag Address stored in cache line 783",
      swaccess: "rw",
      hwaccess: "hrw",
      hwext:    "true",
      hwqe:     "true", // enable `qe` latched signal of software write pulse
      hwre:     "true",
      fields: [
        { bits: "5-1:0",
          name: "CL_TAG",
          desc: "Tag Address"
        }
      ]
    },
    {
      name:     "STATUS_784",
      desc:     "Status register of cache line 784",
      swaccess: "rw",
      hwaccess: "hrw",
      hwext:    "true",
      hwqe:     "true", // enable `qe` latched signal of software write pulse
      hwre:     "true",
      fields: [
        {
          bits: "5+3:5", // 2 bits for status
          name: "CL_STATUS",
          desc: "Contain the current status of the corresponding cache line                [0]: valid, [1]: dirty, [2]: cmpt",
        }
      ]
    },
    { name:     "TAG_784",
      desc:     "Tag Address stored in cache line 784",
      swaccess: "rw",
      hwaccess: "hrw",
      hwext:    "true",
      hwqe:     "true", // enable `qe` latched signal of software write pulse
      hwre:     "true",
      fields: [
        { bits: "5-1:0",
          name: "CL_TAG",
          desc: "Tag Address"
        }
      ]
    },
    {
      name:     "STATUS_785",
      desc:     "Status register of cache line 785",
      swaccess: "rw",
      hwaccess: "hrw",
      hwext:    "true",
      hwqe:     "true", // enable `qe` latched signal of software write pulse
      hwre:     "true",
      fields: [
        {
          bits: "5+3:5", // 2 bits for status
          name: "CL_STATUS",
          desc: "Contain the current status of the corresponding cache line                [0]: valid, [1]: dirty, [2]: cmpt",
        }
      ]
    },
    { name:     "TAG_785",
      desc:     "Tag Address stored in cache line 785",
      swaccess: "rw",
      hwaccess: "hrw",
      hwext:    "true",
      hwqe:     "true", // enable `qe` latched signal of software write pulse
      hwre:     "true",
      fields: [
        { bits: "5-1:0",
          name: "CL_TAG",
          desc: "Tag Address"
        }
      ]
    },
    {
      name:     "STATUS_786",
      desc:     "Status register of cache line 786",
      swaccess: "rw",
      hwaccess: "hrw",
      hwext:    "true",
      hwqe:     "true", // enable `qe` latched signal of software write pulse
      hwre:     "true",
      fields: [
        {
          bits: "5+3:5", // 2 bits for status
          name: "CL_STATUS",
          desc: "Contain the current status of the corresponding cache line                [0]: valid, [1]: dirty, [2]: cmpt",
        }
      ]
    },
    { name:     "TAG_786",
      desc:     "Tag Address stored in cache line 786",
      swaccess: "rw",
      hwaccess: "hrw",
      hwext:    "true",
      hwqe:     "true", // enable `qe` latched signal of software write pulse
      hwre:     "true",
      fields: [
        { bits: "5-1:0",
          name: "CL_TAG",
          desc: "Tag Address"
        }
      ]
    },
    {
      name:     "STATUS_787",
      desc:     "Status register of cache line 787",
      swaccess: "rw",
      hwaccess: "hrw",
      hwext:    "true",
      hwqe:     "true", // enable `qe` latched signal of software write pulse
      hwre:     "true",
      fields: [
        {
          bits: "5+3:5", // 2 bits for status
          name: "CL_STATUS",
          desc: "Contain the current status of the corresponding cache line                [0]: valid, [1]: dirty, [2]: cmpt",
        }
      ]
    },
    { name:     "TAG_787",
      desc:     "Tag Address stored in cache line 787",
      swaccess: "rw",
      hwaccess: "hrw",
      hwext:    "true",
      hwqe:     "true", // enable `qe` latched signal of software write pulse
      hwre:     "true",
      fields: [
        { bits: "5-1:0",
          name: "CL_TAG",
          desc: "Tag Address"
        }
      ]
    },
    {
      name:     "STATUS_788",
      desc:     "Status register of cache line 788",
      swaccess: "rw",
      hwaccess: "hrw",
      hwext:    "true",
      hwqe:     "true", // enable `qe` latched signal of software write pulse
      hwre:     "true",
      fields: [
        {
          bits: "5+3:5", // 2 bits for status
          name: "CL_STATUS",
          desc: "Contain the current status of the corresponding cache line                [0]: valid, [1]: dirty, [2]: cmpt",
        }
      ]
    },
    { name:     "TAG_788",
      desc:     "Tag Address stored in cache line 788",
      swaccess: "rw",
      hwaccess: "hrw",
      hwext:    "true",
      hwqe:     "true", // enable `qe` latched signal of software write pulse
      hwre:     "true",
      fields: [
        { bits: "5-1:0",
          name: "CL_TAG",
          desc: "Tag Address"
        }
      ]
    },
    {
      name:     "STATUS_789",
      desc:     "Status register of cache line 789",
      swaccess: "rw",
      hwaccess: "hrw",
      hwext:    "true",
      hwqe:     "true", // enable `qe` latched signal of software write pulse
      hwre:     "true",
      fields: [
        {
          bits: "5+3:5", // 2 bits for status
          name: "CL_STATUS",
          desc: "Contain the current status of the corresponding cache line                [0]: valid, [1]: dirty, [2]: cmpt",
        }
      ]
    },
    { name:     "TAG_789",
      desc:     "Tag Address stored in cache line 789",
      swaccess: "rw",
      hwaccess: "hrw",
      hwext:    "true",
      hwqe:     "true", // enable `qe` latched signal of software write pulse
      hwre:     "true",
      fields: [
        { bits: "5-1:0",
          name: "CL_TAG",
          desc: "Tag Address"
        }
      ]
    },
    {
      name:     "STATUS_790",
      desc:     "Status register of cache line 790",
      swaccess: "rw",
      hwaccess: "hrw",
      hwext:    "true",
      hwqe:     "true", // enable `qe` latched signal of software write pulse
      hwre:     "true",
      fields: [
        {
          bits: "5+3:5", // 2 bits for status
          name: "CL_STATUS",
          desc: "Contain the current status of the corresponding cache line                [0]: valid, [1]: dirty, [2]: cmpt",
        }
      ]
    },
    { name:     "TAG_790",
      desc:     "Tag Address stored in cache line 790",
      swaccess: "rw",
      hwaccess: "hrw",
      hwext:    "true",
      hwqe:     "true", // enable `qe` latched signal of software write pulse
      hwre:     "true",
      fields: [
        { bits: "5-1:0",
          name: "CL_TAG",
          desc: "Tag Address"
        }
      ]
    },
    {
      name:     "STATUS_791",
      desc:     "Status register of cache line 791",
      swaccess: "rw",
      hwaccess: "hrw",
      hwext:    "true",
      hwqe:     "true", // enable `qe` latched signal of software write pulse
      hwre:     "true",
      fields: [
        {
          bits: "5+3:5", // 2 bits for status
          name: "CL_STATUS",
          desc: "Contain the current status of the corresponding cache line                [0]: valid, [1]: dirty, [2]: cmpt",
        }
      ]
    },
    { name:     "TAG_791",
      desc:     "Tag Address stored in cache line 791",
      swaccess: "rw",
      hwaccess: "hrw",
      hwext:    "true",
      hwqe:     "true", // enable `qe` latched signal of software write pulse
      hwre:     "true",
      fields: [
        { bits: "5-1:0",
          name: "CL_TAG",
          desc: "Tag Address"
        }
      ]
    },
    {
      name:     "STATUS_792",
      desc:     "Status register of cache line 792",
      swaccess: "rw",
      hwaccess: "hrw",
      hwext:    "true",
      hwqe:     "true", // enable `qe` latched signal of software write pulse
      hwre:     "true",
      fields: [
        {
          bits: "5+3:5", // 2 bits for status
          name: "CL_STATUS",
          desc: "Contain the current status of the corresponding cache line                [0]: valid, [1]: dirty, [2]: cmpt",
        }
      ]
    },
    { name:     "TAG_792",
      desc:     "Tag Address stored in cache line 792",
      swaccess: "rw",
      hwaccess: "hrw",
      hwext:    "true",
      hwqe:     "true", // enable `qe` latched signal of software write pulse
      hwre:     "true",
      fields: [
        { bits: "5-1:0",
          name: "CL_TAG",
          desc: "Tag Address"
        }
      ]
    },
    {
      name:     "STATUS_793",
      desc:     "Status register of cache line 793",
      swaccess: "rw",
      hwaccess: "hrw",
      hwext:    "true",
      hwqe:     "true", // enable `qe` latched signal of software write pulse
      hwre:     "true",
      fields: [
        {
          bits: "5+3:5", // 2 bits for status
          name: "CL_STATUS",
          desc: "Contain the current status of the corresponding cache line                [0]: valid, [1]: dirty, [2]: cmpt",
        }
      ]
    },
    { name:     "TAG_793",
      desc:     "Tag Address stored in cache line 793",
      swaccess: "rw",
      hwaccess: "hrw",
      hwext:    "true",
      hwqe:     "true", // enable `qe` latched signal of software write pulse
      hwre:     "true",
      fields: [
        { bits: "5-1:0",
          name: "CL_TAG",
          desc: "Tag Address"
        }
      ]
    },
    {
      name:     "STATUS_794",
      desc:     "Status register of cache line 794",
      swaccess: "rw",
      hwaccess: "hrw",
      hwext:    "true",
      hwqe:     "true", // enable `qe` latched signal of software write pulse
      hwre:     "true",
      fields: [
        {
          bits: "5+3:5", // 2 bits for status
          name: "CL_STATUS",
          desc: "Contain the current status of the corresponding cache line                [0]: valid, [1]: dirty, [2]: cmpt",
        }
      ]
    },
    { name:     "TAG_794",
      desc:     "Tag Address stored in cache line 794",
      swaccess: "rw",
      hwaccess: "hrw",
      hwext:    "true",
      hwqe:     "true", // enable `qe` latched signal of software write pulse
      hwre:     "true",
      fields: [
        { bits: "5-1:0",
          name: "CL_TAG",
          desc: "Tag Address"
        }
      ]
    },
    {
      name:     "STATUS_795",
      desc:     "Status register of cache line 795",
      swaccess: "rw",
      hwaccess: "hrw",
      hwext:    "true",
      hwqe:     "true", // enable `qe` latched signal of software write pulse
      hwre:     "true",
      fields: [
        {
          bits: "5+3:5", // 2 bits for status
          name: "CL_STATUS",
          desc: "Contain the current status of the corresponding cache line                [0]: valid, [1]: dirty, [2]: cmpt",
        }
      ]
    },
    { name:     "TAG_795",
      desc:     "Tag Address stored in cache line 795",
      swaccess: "rw",
      hwaccess: "hrw",
      hwext:    "true",
      hwqe:     "true", // enable `qe` latched signal of software write pulse
      hwre:     "true",
      fields: [
        { bits: "5-1:0",
          name: "CL_TAG",
          desc: "Tag Address"
        }
      ]
    },
    {
      name:     "STATUS_796",
      desc:     "Status register of cache line 796",
      swaccess: "rw",
      hwaccess: "hrw",
      hwext:    "true",
      hwqe:     "true", // enable `qe` latched signal of software write pulse
      hwre:     "true",
      fields: [
        {
          bits: "5+3:5", // 2 bits for status
          name: "CL_STATUS",
          desc: "Contain the current status of the corresponding cache line                [0]: valid, [1]: dirty, [2]: cmpt",
        }
      ]
    },
    { name:     "TAG_796",
      desc:     "Tag Address stored in cache line 796",
      swaccess: "rw",
      hwaccess: "hrw",
      hwext:    "true",
      hwqe:     "true", // enable `qe` latched signal of software write pulse
      hwre:     "true",
      fields: [
        { bits: "5-1:0",
          name: "CL_TAG",
          desc: "Tag Address"
        }
      ]
    },
    {
      name:     "STATUS_797",
      desc:     "Status register of cache line 797",
      swaccess: "rw",
      hwaccess: "hrw",
      hwext:    "true",
      hwqe:     "true", // enable `qe` latched signal of software write pulse
      hwre:     "true",
      fields: [
        {
          bits: "5+3:5", // 2 bits for status
          name: "CL_STATUS",
          desc: "Contain the current status of the corresponding cache line                [0]: valid, [1]: dirty, [2]: cmpt",
        }
      ]
    },
    { name:     "TAG_797",
      desc:     "Tag Address stored in cache line 797",
      swaccess: "rw",
      hwaccess: "hrw",
      hwext:    "true",
      hwqe:     "true", // enable `qe` latched signal of software write pulse
      hwre:     "true",
      fields: [
        { bits: "5-1:0",
          name: "CL_TAG",
          desc: "Tag Address"
        }
      ]
    },
    {
      name:     "STATUS_798",
      desc:     "Status register of cache line 798",
      swaccess: "rw",
      hwaccess: "hrw",
      hwext:    "true",
      hwqe:     "true", // enable `qe` latched signal of software write pulse
      hwre:     "true",
      fields: [
        {
          bits: "5+3:5", // 2 bits for status
          name: "CL_STATUS",
          desc: "Contain the current status of the corresponding cache line                [0]: valid, [1]: dirty, [2]: cmpt",
        }
      ]
    },
    { name:     "TAG_798",
      desc:     "Tag Address stored in cache line 798",
      swaccess: "rw",
      hwaccess: "hrw",
      hwext:    "true",
      hwqe:     "true", // enable `qe` latched signal of software write pulse
      hwre:     "true",
      fields: [
        { bits: "5-1:0",
          name: "CL_TAG",
          desc: "Tag Address"
        }
      ]
    },
    {
      name:     "STATUS_799",
      desc:     "Status register of cache line 799",
      swaccess: "rw",
      hwaccess: "hrw",
      hwext:    "true",
      hwqe:     "true", // enable `qe` latched signal of software write pulse
      hwre:     "true",
      fields: [
        {
          bits: "5+3:5", // 2 bits for status
          name: "CL_STATUS",
          desc: "Contain the current status of the corresponding cache line                [0]: valid, [1]: dirty, [2]: cmpt",
        }
      ]
    },
    { name:     "TAG_799",
      desc:     "Tag Address stored in cache line 799",
      swaccess: "rw",
      hwaccess: "hrw",
      hwext:    "true",
      hwqe:     "true", // enable `qe` latched signal of software write pulse
      hwre:     "true",
      fields: [
        { bits: "5-1:0",
          name: "CL_TAG",
          desc: "Tag Address"
        }
      ]
    },
    {
      name:     "STATUS_800",
      desc:     "Status register of cache line 800",
      swaccess: "rw",
      hwaccess: "hrw",
      hwext:    "true",
      hwqe:     "true", // enable `qe` latched signal of software write pulse
      hwre:     "true",
      fields: [
        {
          bits: "5+3:5", // 2 bits for status
          name: "CL_STATUS",
          desc: "Contain the current status of the corresponding cache line                [0]: valid, [1]: dirty, [2]: cmpt",
        }
      ]
    },
    { name:     "TAG_800",
      desc:     "Tag Address stored in cache line 800",
      swaccess: "rw",
      hwaccess: "hrw",
      hwext:    "true",
      hwqe:     "true", // enable `qe` latched signal of software write pulse
      hwre:     "true",
      fields: [
        { bits: "5-1:0",
          name: "CL_TAG",
          desc: "Tag Address"
        }
      ]
    },
    {
      name:     "STATUS_801",
      desc:     "Status register of cache line 801",
      swaccess: "rw",
      hwaccess: "hrw",
      hwext:    "true",
      hwqe:     "true", // enable `qe` latched signal of software write pulse
      hwre:     "true",
      fields: [
        {
          bits: "5+3:5", // 2 bits for status
          name: "CL_STATUS",
          desc: "Contain the current status of the corresponding cache line                [0]: valid, [1]: dirty, [2]: cmpt",
        }
      ]
    },
    { name:     "TAG_801",
      desc:     "Tag Address stored in cache line 801",
      swaccess: "rw",
      hwaccess: "hrw",
      hwext:    "true",
      hwqe:     "true", // enable `qe` latched signal of software write pulse
      hwre:     "true",
      fields: [
        { bits: "5-1:0",
          name: "CL_TAG",
          desc: "Tag Address"
        }
      ]
    },
    {
      name:     "STATUS_802",
      desc:     "Status register of cache line 802",
      swaccess: "rw",
      hwaccess: "hrw",
      hwext:    "true",
      hwqe:     "true", // enable `qe` latched signal of software write pulse
      hwre:     "true",
      fields: [
        {
          bits: "5+3:5", // 2 bits for status
          name: "CL_STATUS",
          desc: "Contain the current status of the corresponding cache line                [0]: valid, [1]: dirty, [2]: cmpt",
        }
      ]
    },
    { name:     "TAG_802",
      desc:     "Tag Address stored in cache line 802",
      swaccess: "rw",
      hwaccess: "hrw",
      hwext:    "true",
      hwqe:     "true", // enable `qe` latched signal of software write pulse
      hwre:     "true",
      fields: [
        { bits: "5-1:0",
          name: "CL_TAG",
          desc: "Tag Address"
        }
      ]
    },
    {
      name:     "STATUS_803",
      desc:     "Status register of cache line 803",
      swaccess: "rw",
      hwaccess: "hrw",
      hwext:    "true",
      hwqe:     "true", // enable `qe` latched signal of software write pulse
      hwre:     "true",
      fields: [
        {
          bits: "5+3:5", // 2 bits for status
          name: "CL_STATUS",
          desc: "Contain the current status of the corresponding cache line                [0]: valid, [1]: dirty, [2]: cmpt",
        }
      ]
    },
    { name:     "TAG_803",
      desc:     "Tag Address stored in cache line 803",
      swaccess: "rw",
      hwaccess: "hrw",
      hwext:    "true",
      hwqe:     "true", // enable `qe` latched signal of software write pulse
      hwre:     "true",
      fields: [
        { bits: "5-1:0",
          name: "CL_TAG",
          desc: "Tag Address"
        }
      ]
    },
    {
      name:     "STATUS_804",
      desc:     "Status register of cache line 804",
      swaccess: "rw",
      hwaccess: "hrw",
      hwext:    "true",
      hwqe:     "true", // enable `qe` latched signal of software write pulse
      hwre:     "true",
      fields: [
        {
          bits: "5+3:5", // 2 bits for status
          name: "CL_STATUS",
          desc: "Contain the current status of the corresponding cache line                [0]: valid, [1]: dirty, [2]: cmpt",
        }
      ]
    },
    { name:     "TAG_804",
      desc:     "Tag Address stored in cache line 804",
      swaccess: "rw",
      hwaccess: "hrw",
      hwext:    "true",
      hwqe:     "true", // enable `qe` latched signal of software write pulse
      hwre:     "true",
      fields: [
        { bits: "5-1:0",
          name: "CL_TAG",
          desc: "Tag Address"
        }
      ]
    },
    {
      name:     "STATUS_805",
      desc:     "Status register of cache line 805",
      swaccess: "rw",
      hwaccess: "hrw",
      hwext:    "true",
      hwqe:     "true", // enable `qe` latched signal of software write pulse
      hwre:     "true",
      fields: [
        {
          bits: "5+3:5", // 2 bits for status
          name: "CL_STATUS",
          desc: "Contain the current status of the corresponding cache line                [0]: valid, [1]: dirty, [2]: cmpt",
        }
      ]
    },
    { name:     "TAG_805",
      desc:     "Tag Address stored in cache line 805",
      swaccess: "rw",
      hwaccess: "hrw",
      hwext:    "true",
      hwqe:     "true", // enable `qe` latched signal of software write pulse
      hwre:     "true",
      fields: [
        { bits: "5-1:0",
          name: "CL_TAG",
          desc: "Tag Address"
        }
      ]
    },
    {
      name:     "STATUS_806",
      desc:     "Status register of cache line 806",
      swaccess: "rw",
      hwaccess: "hrw",
      hwext:    "true",
      hwqe:     "true", // enable `qe` latched signal of software write pulse
      hwre:     "true",
      fields: [
        {
          bits: "5+3:5", // 2 bits for status
          name: "CL_STATUS",
          desc: "Contain the current status of the corresponding cache line                [0]: valid, [1]: dirty, [2]: cmpt",
        }
      ]
    },
    { name:     "TAG_806",
      desc:     "Tag Address stored in cache line 806",
      swaccess: "rw",
      hwaccess: "hrw",
      hwext:    "true",
      hwqe:     "true", // enable `qe` latched signal of software write pulse
      hwre:     "true",
      fields: [
        { bits: "5-1:0",
          name: "CL_TAG",
          desc: "Tag Address"
        }
      ]
    },
    {
      name:     "STATUS_807",
      desc:     "Status register of cache line 807",
      swaccess: "rw",
      hwaccess: "hrw",
      hwext:    "true",
      hwqe:     "true", // enable `qe` latched signal of software write pulse
      hwre:     "true",
      fields: [
        {
          bits: "5+3:5", // 2 bits for status
          name: "CL_STATUS",
          desc: "Contain the current status of the corresponding cache line                [0]: valid, [1]: dirty, [2]: cmpt",
        }
      ]
    },
    { name:     "TAG_807",
      desc:     "Tag Address stored in cache line 807",
      swaccess: "rw",
      hwaccess: "hrw",
      hwext:    "true",
      hwqe:     "true", // enable `qe` latched signal of software write pulse
      hwre:     "true",
      fields: [
        { bits: "5-1:0",
          name: "CL_TAG",
          desc: "Tag Address"
        }
      ]
    },
    {
      name:     "STATUS_808",
      desc:     "Status register of cache line 808",
      swaccess: "rw",
      hwaccess: "hrw",
      hwext:    "true",
      hwqe:     "true", // enable `qe` latched signal of software write pulse
      hwre:     "true",
      fields: [
        {
          bits: "5+3:5", // 2 bits for status
          name: "CL_STATUS",
          desc: "Contain the current status of the corresponding cache line                [0]: valid, [1]: dirty, [2]: cmpt",
        }
      ]
    },
    { name:     "TAG_808",
      desc:     "Tag Address stored in cache line 808",
      swaccess: "rw",
      hwaccess: "hrw",
      hwext:    "true",
      hwqe:     "true", // enable `qe` latched signal of software write pulse
      hwre:     "true",
      fields: [
        { bits: "5-1:0",
          name: "CL_TAG",
          desc: "Tag Address"
        }
      ]
    },
    {
      name:     "STATUS_809",
      desc:     "Status register of cache line 809",
      swaccess: "rw",
      hwaccess: "hrw",
      hwext:    "true",
      hwqe:     "true", // enable `qe` latched signal of software write pulse
      hwre:     "true",
      fields: [
        {
          bits: "5+3:5", // 2 bits for status
          name: "CL_STATUS",
          desc: "Contain the current status of the corresponding cache line                [0]: valid, [1]: dirty, [2]: cmpt",
        }
      ]
    },
    { name:     "TAG_809",
      desc:     "Tag Address stored in cache line 809",
      swaccess: "rw",
      hwaccess: "hrw",
      hwext:    "true",
      hwqe:     "true", // enable `qe` latched signal of software write pulse
      hwre:     "true",
      fields: [
        { bits: "5-1:0",
          name: "CL_TAG",
          desc: "Tag Address"
        }
      ]
    },
    {
      name:     "STATUS_810",
      desc:     "Status register of cache line 810",
      swaccess: "rw",
      hwaccess: "hrw",
      hwext:    "true",
      hwqe:     "true", // enable `qe` latched signal of software write pulse
      hwre:     "true",
      fields: [
        {
          bits: "5+3:5", // 2 bits for status
          name: "CL_STATUS",
          desc: "Contain the current status of the corresponding cache line                [0]: valid, [1]: dirty, [2]: cmpt",
        }
      ]
    },
    { name:     "TAG_810",
      desc:     "Tag Address stored in cache line 810",
      swaccess: "rw",
      hwaccess: "hrw",
      hwext:    "true",
      hwqe:     "true", // enable `qe` latched signal of software write pulse
      hwre:     "true",
      fields: [
        { bits: "5-1:0",
          name: "CL_TAG",
          desc: "Tag Address"
        }
      ]
    },
    {
      name:     "STATUS_811",
      desc:     "Status register of cache line 811",
      swaccess: "rw",
      hwaccess: "hrw",
      hwext:    "true",
      hwqe:     "true", // enable `qe` latched signal of software write pulse
      hwre:     "true",
      fields: [
        {
          bits: "5+3:5", // 2 bits for status
          name: "CL_STATUS",
          desc: "Contain the current status of the corresponding cache line                [0]: valid, [1]: dirty, [2]: cmpt",
        }
      ]
    },
    { name:     "TAG_811",
      desc:     "Tag Address stored in cache line 811",
      swaccess: "rw",
      hwaccess: "hrw",
      hwext:    "true",
      hwqe:     "true", // enable `qe` latched signal of software write pulse
      hwre:     "true",
      fields: [
        { bits: "5-1:0",
          name: "CL_TAG",
          desc: "Tag Address"
        }
      ]
    },
    {
      name:     "STATUS_812",
      desc:     "Status register of cache line 812",
      swaccess: "rw",
      hwaccess: "hrw",
      hwext:    "true",
      hwqe:     "true", // enable `qe` latched signal of software write pulse
      hwre:     "true",
      fields: [
        {
          bits: "5+3:5", // 2 bits for status
          name: "CL_STATUS",
          desc: "Contain the current status of the corresponding cache line                [0]: valid, [1]: dirty, [2]: cmpt",
        }
      ]
    },
    { name:     "TAG_812",
      desc:     "Tag Address stored in cache line 812",
      swaccess: "rw",
      hwaccess: "hrw",
      hwext:    "true",
      hwqe:     "true", // enable `qe` latched signal of software write pulse
      hwre:     "true",
      fields: [
        { bits: "5-1:0",
          name: "CL_TAG",
          desc: "Tag Address"
        }
      ]
    },
    {
      name:     "STATUS_813",
      desc:     "Status register of cache line 813",
      swaccess: "rw",
      hwaccess: "hrw",
      hwext:    "true",
      hwqe:     "true", // enable `qe` latched signal of software write pulse
      hwre:     "true",
      fields: [
        {
          bits: "5+3:5", // 2 bits for status
          name: "CL_STATUS",
          desc: "Contain the current status of the corresponding cache line                [0]: valid, [1]: dirty, [2]: cmpt",
        }
      ]
    },
    { name:     "TAG_813",
      desc:     "Tag Address stored in cache line 813",
      swaccess: "rw",
      hwaccess: "hrw",
      hwext:    "true",
      hwqe:     "true", // enable `qe` latched signal of software write pulse
      hwre:     "true",
      fields: [
        { bits: "5-1:0",
          name: "CL_TAG",
          desc: "Tag Address"
        }
      ]
    },
    {
      name:     "STATUS_814",
      desc:     "Status register of cache line 814",
      swaccess: "rw",
      hwaccess: "hrw",
      hwext:    "true",
      hwqe:     "true", // enable `qe` latched signal of software write pulse
      hwre:     "true",
      fields: [
        {
          bits: "5+3:5", // 2 bits for status
          name: "CL_STATUS",
          desc: "Contain the current status of the corresponding cache line                [0]: valid, [1]: dirty, [2]: cmpt",
        }
      ]
    },
    { name:     "TAG_814",
      desc:     "Tag Address stored in cache line 814",
      swaccess: "rw",
      hwaccess: "hrw",
      hwext:    "true",
      hwqe:     "true", // enable `qe` latched signal of software write pulse
      hwre:     "true",
      fields: [
        { bits: "5-1:0",
          name: "CL_TAG",
          desc: "Tag Address"
        }
      ]
    },
    {
      name:     "STATUS_815",
      desc:     "Status register of cache line 815",
      swaccess: "rw",
      hwaccess: "hrw",
      hwext:    "true",
      hwqe:     "true", // enable `qe` latched signal of software write pulse
      hwre:     "true",
      fields: [
        {
          bits: "5+3:5", // 2 bits for status
          name: "CL_STATUS",
          desc: "Contain the current status of the corresponding cache line                [0]: valid, [1]: dirty, [2]: cmpt",
        }
      ]
    },
    { name:     "TAG_815",
      desc:     "Tag Address stored in cache line 815",
      swaccess: "rw",
      hwaccess: "hrw",
      hwext:    "true",
      hwqe:     "true", // enable `qe` latched signal of software write pulse
      hwre:     "true",
      fields: [
        { bits: "5-1:0",
          name: "CL_TAG",
          desc: "Tag Address"
        }
      ]
    },
    {
      name:     "STATUS_816",
      desc:     "Status register of cache line 816",
      swaccess: "rw",
      hwaccess: "hrw",
      hwext:    "true",
      hwqe:     "true", // enable `qe` latched signal of software write pulse
      hwre:     "true",
      fields: [
        {
          bits: "5+3:5", // 2 bits for status
          name: "CL_STATUS",
          desc: "Contain the current status of the corresponding cache line                [0]: valid, [1]: dirty, [2]: cmpt",
        }
      ]
    },
    { name:     "TAG_816",
      desc:     "Tag Address stored in cache line 816",
      swaccess: "rw",
      hwaccess: "hrw",
      hwext:    "true",
      hwqe:     "true", // enable `qe` latched signal of software write pulse
      hwre:     "true",
      fields: [
        { bits: "5-1:0",
          name: "CL_TAG",
          desc: "Tag Address"
        }
      ]
    },
    {
      name:     "STATUS_817",
      desc:     "Status register of cache line 817",
      swaccess: "rw",
      hwaccess: "hrw",
      hwext:    "true",
      hwqe:     "true", // enable `qe` latched signal of software write pulse
      hwre:     "true",
      fields: [
        {
          bits: "5+3:5", // 2 bits for status
          name: "CL_STATUS",
          desc: "Contain the current status of the corresponding cache line                [0]: valid, [1]: dirty, [2]: cmpt",
        }
      ]
    },
    { name:     "TAG_817",
      desc:     "Tag Address stored in cache line 817",
      swaccess: "rw",
      hwaccess: "hrw",
      hwext:    "true",
      hwqe:     "true", // enable `qe` latched signal of software write pulse
      hwre:     "true",
      fields: [
        { bits: "5-1:0",
          name: "CL_TAG",
          desc: "Tag Address"
        }
      ]
    },
    {
      name:     "STATUS_818",
      desc:     "Status register of cache line 818",
      swaccess: "rw",
      hwaccess: "hrw",
      hwext:    "true",
      hwqe:     "true", // enable `qe` latched signal of software write pulse
      hwre:     "true",
      fields: [
        {
          bits: "5+3:5", // 2 bits for status
          name: "CL_STATUS",
          desc: "Contain the current status of the corresponding cache line                [0]: valid, [1]: dirty, [2]: cmpt",
        }
      ]
    },
    { name:     "TAG_818",
      desc:     "Tag Address stored in cache line 818",
      swaccess: "rw",
      hwaccess: "hrw",
      hwext:    "true",
      hwqe:     "true", // enable `qe` latched signal of software write pulse
      hwre:     "true",
      fields: [
        { bits: "5-1:0",
          name: "CL_TAG",
          desc: "Tag Address"
        }
      ]
    },
    {
      name:     "STATUS_819",
      desc:     "Status register of cache line 819",
      swaccess: "rw",
      hwaccess: "hrw",
      hwext:    "true",
      hwqe:     "true", // enable `qe` latched signal of software write pulse
      hwre:     "true",
      fields: [
        {
          bits: "5+3:5", // 2 bits for status
          name: "CL_STATUS",
          desc: "Contain the current status of the corresponding cache line                [0]: valid, [1]: dirty, [2]: cmpt",
        }
      ]
    },
    { name:     "TAG_819",
      desc:     "Tag Address stored in cache line 819",
      swaccess: "rw",
      hwaccess: "hrw",
      hwext:    "true",
      hwqe:     "true", // enable `qe` latched signal of software write pulse
      hwre:     "true",
      fields: [
        { bits: "5-1:0",
          name: "CL_TAG",
          desc: "Tag Address"
        }
      ]
    },
    {
      name:     "STATUS_820",
      desc:     "Status register of cache line 820",
      swaccess: "rw",
      hwaccess: "hrw",
      hwext:    "true",
      hwqe:     "true", // enable `qe` latched signal of software write pulse
      hwre:     "true",
      fields: [
        {
          bits: "5+3:5", // 2 bits for status
          name: "CL_STATUS",
          desc: "Contain the current status of the corresponding cache line                [0]: valid, [1]: dirty, [2]: cmpt",
        }
      ]
    },
    { name:     "TAG_820",
      desc:     "Tag Address stored in cache line 820",
      swaccess: "rw",
      hwaccess: "hrw",
      hwext:    "true",
      hwqe:     "true", // enable `qe` latched signal of software write pulse
      hwre:     "true",
      fields: [
        { bits: "5-1:0",
          name: "CL_TAG",
          desc: "Tag Address"
        }
      ]
    },
    {
      name:     "STATUS_821",
      desc:     "Status register of cache line 821",
      swaccess: "rw",
      hwaccess: "hrw",
      hwext:    "true",
      hwqe:     "true", // enable `qe` latched signal of software write pulse
      hwre:     "true",
      fields: [
        {
          bits: "5+3:5", // 2 bits for status
          name: "CL_STATUS",
          desc: "Contain the current status of the corresponding cache line                [0]: valid, [1]: dirty, [2]: cmpt",
        }
      ]
    },
    { name:     "TAG_821",
      desc:     "Tag Address stored in cache line 821",
      swaccess: "rw",
      hwaccess: "hrw",
      hwext:    "true",
      hwqe:     "true", // enable `qe` latched signal of software write pulse
      hwre:     "true",
      fields: [
        { bits: "5-1:0",
          name: "CL_TAG",
          desc: "Tag Address"
        }
      ]
    },
    {
      name:     "STATUS_822",
      desc:     "Status register of cache line 822",
      swaccess: "rw",
      hwaccess: "hrw",
      hwext:    "true",
      hwqe:     "true", // enable `qe` latched signal of software write pulse
      hwre:     "true",
      fields: [
        {
          bits: "5+3:5", // 2 bits for status
          name: "CL_STATUS",
          desc: "Contain the current status of the corresponding cache line                [0]: valid, [1]: dirty, [2]: cmpt",
        }
      ]
    },
    { name:     "TAG_822",
      desc:     "Tag Address stored in cache line 822",
      swaccess: "rw",
      hwaccess: "hrw",
      hwext:    "true",
      hwqe:     "true", // enable `qe` latched signal of software write pulse
      hwre:     "true",
      fields: [
        { bits: "5-1:0",
          name: "CL_TAG",
          desc: "Tag Address"
        }
      ]
    },
    {
      name:     "STATUS_823",
      desc:     "Status register of cache line 823",
      swaccess: "rw",
      hwaccess: "hrw",
      hwext:    "true",
      hwqe:     "true", // enable `qe` latched signal of software write pulse
      hwre:     "true",
      fields: [
        {
          bits: "5+3:5", // 2 bits for status
          name: "CL_STATUS",
          desc: "Contain the current status of the corresponding cache line                [0]: valid, [1]: dirty, [2]: cmpt",
        }
      ]
    },
    { name:     "TAG_823",
      desc:     "Tag Address stored in cache line 823",
      swaccess: "rw",
      hwaccess: "hrw",
      hwext:    "true",
      hwqe:     "true", // enable `qe` latched signal of software write pulse
      hwre:     "true",
      fields: [
        { bits: "5-1:0",
          name: "CL_TAG",
          desc: "Tag Address"
        }
      ]
    },
    {
      name:     "STATUS_824",
      desc:     "Status register of cache line 824",
      swaccess: "rw",
      hwaccess: "hrw",
      hwext:    "true",
      hwqe:     "true", // enable `qe` latched signal of software write pulse
      hwre:     "true",
      fields: [
        {
          bits: "5+3:5", // 2 bits for status
          name: "CL_STATUS",
          desc: "Contain the current status of the corresponding cache line                [0]: valid, [1]: dirty, [2]: cmpt",
        }
      ]
    },
    { name:     "TAG_824",
      desc:     "Tag Address stored in cache line 824",
      swaccess: "rw",
      hwaccess: "hrw",
      hwext:    "true",
      hwqe:     "true", // enable `qe` latched signal of software write pulse
      hwre:     "true",
      fields: [
        { bits: "5-1:0",
          name: "CL_TAG",
          desc: "Tag Address"
        }
      ]
    },
    {
      name:     "STATUS_825",
      desc:     "Status register of cache line 825",
      swaccess: "rw",
      hwaccess: "hrw",
      hwext:    "true",
      hwqe:     "true", // enable `qe` latched signal of software write pulse
      hwre:     "true",
      fields: [
        {
          bits: "5+3:5", // 2 bits for status
          name: "CL_STATUS",
          desc: "Contain the current status of the corresponding cache line                [0]: valid, [1]: dirty, [2]: cmpt",
        }
      ]
    },
    { name:     "TAG_825",
      desc:     "Tag Address stored in cache line 825",
      swaccess: "rw",
      hwaccess: "hrw",
      hwext:    "true",
      hwqe:     "true", // enable `qe` latched signal of software write pulse
      hwre:     "true",
      fields: [
        { bits: "5-1:0",
          name: "CL_TAG",
          desc: "Tag Address"
        }
      ]
    },
    {
      name:     "STATUS_826",
      desc:     "Status register of cache line 826",
      swaccess: "rw",
      hwaccess: "hrw",
      hwext:    "true",
      hwqe:     "true", // enable `qe` latched signal of software write pulse
      hwre:     "true",
      fields: [
        {
          bits: "5+3:5", // 2 bits for status
          name: "CL_STATUS",
          desc: "Contain the current status of the corresponding cache line                [0]: valid, [1]: dirty, [2]: cmpt",
        }
      ]
    },
    { name:     "TAG_826",
      desc:     "Tag Address stored in cache line 826",
      swaccess: "rw",
      hwaccess: "hrw",
      hwext:    "true",
      hwqe:     "true", // enable `qe` latched signal of software write pulse
      hwre:     "true",
      fields: [
        { bits: "5-1:0",
          name: "CL_TAG",
          desc: "Tag Address"
        }
      ]
    },
    {
      name:     "STATUS_827",
      desc:     "Status register of cache line 827",
      swaccess: "rw",
      hwaccess: "hrw",
      hwext:    "true",
      hwqe:     "true", // enable `qe` latched signal of software write pulse
      hwre:     "true",
      fields: [
        {
          bits: "5+3:5", // 2 bits for status
          name: "CL_STATUS",
          desc: "Contain the current status of the corresponding cache line                [0]: valid, [1]: dirty, [2]: cmpt",
        }
      ]
    },
    { name:     "TAG_827",
      desc:     "Tag Address stored in cache line 827",
      swaccess: "rw",
      hwaccess: "hrw",
      hwext:    "true",
      hwqe:     "true", // enable `qe` latched signal of software write pulse
      hwre:     "true",
      fields: [
        { bits: "5-1:0",
          name: "CL_TAG",
          desc: "Tag Address"
        }
      ]
    },
    {
      name:     "STATUS_828",
      desc:     "Status register of cache line 828",
      swaccess: "rw",
      hwaccess: "hrw",
      hwext:    "true",
      hwqe:     "true", // enable `qe` latched signal of software write pulse
      hwre:     "true",
      fields: [
        {
          bits: "5+3:5", // 2 bits for status
          name: "CL_STATUS",
          desc: "Contain the current status of the corresponding cache line                [0]: valid, [1]: dirty, [2]: cmpt",
        }
      ]
    },
    { name:     "TAG_828",
      desc:     "Tag Address stored in cache line 828",
      swaccess: "rw",
      hwaccess: "hrw",
      hwext:    "true",
      hwqe:     "true", // enable `qe` latched signal of software write pulse
      hwre:     "true",
      fields: [
        { bits: "5-1:0",
          name: "CL_TAG",
          desc: "Tag Address"
        }
      ]
    },
    {
      name:     "STATUS_829",
      desc:     "Status register of cache line 829",
      swaccess: "rw",
      hwaccess: "hrw",
      hwext:    "true",
      hwqe:     "true", // enable `qe` latched signal of software write pulse
      hwre:     "true",
      fields: [
        {
          bits: "5+3:5", // 2 bits for status
          name: "CL_STATUS",
          desc: "Contain the current status of the corresponding cache line                [0]: valid, [1]: dirty, [2]: cmpt",
        }
      ]
    },
    { name:     "TAG_829",
      desc:     "Tag Address stored in cache line 829",
      swaccess: "rw",
      hwaccess: "hrw",
      hwext:    "true",
      hwqe:     "true", // enable `qe` latched signal of software write pulse
      hwre:     "true",
      fields: [
        { bits: "5-1:0",
          name: "CL_TAG",
          desc: "Tag Address"
        }
      ]
    },
    {
      name:     "STATUS_830",
      desc:     "Status register of cache line 830",
      swaccess: "rw",
      hwaccess: "hrw",
      hwext:    "true",
      hwqe:     "true", // enable `qe` latched signal of software write pulse
      hwre:     "true",
      fields: [
        {
          bits: "5+3:5", // 2 bits for status
          name: "CL_STATUS",
          desc: "Contain the current status of the corresponding cache line                [0]: valid, [1]: dirty, [2]: cmpt",
        }
      ]
    },
    { name:     "TAG_830",
      desc:     "Tag Address stored in cache line 830",
      swaccess: "rw",
      hwaccess: "hrw",
      hwext:    "true",
      hwqe:     "true", // enable `qe` latched signal of software write pulse
      hwre:     "true",
      fields: [
        { bits: "5-1:0",
          name: "CL_TAG",
          desc: "Tag Address"
        }
      ]
    },
    {
      name:     "STATUS_831",
      desc:     "Status register of cache line 831",
      swaccess: "rw",
      hwaccess: "hrw",
      hwext:    "true",
      hwqe:     "true", // enable `qe` latched signal of software write pulse
      hwre:     "true",
      fields: [
        {
          bits: "5+3:5", // 2 bits for status
          name: "CL_STATUS",
          desc: "Contain the current status of the corresponding cache line                [0]: valid, [1]: dirty, [2]: cmpt",
        }
      ]
    },
    { name:     "TAG_831",
      desc:     "Tag Address stored in cache line 831",
      swaccess: "rw",
      hwaccess: "hrw",
      hwext:    "true",
      hwqe:     "true", // enable `qe` latched signal of software write pulse
      hwre:     "true",
      fields: [
        { bits: "5-1:0",
          name: "CL_TAG",
          desc: "Tag Address"
        }
      ]
    },
    {
      name:     "STATUS_832",
      desc:     "Status register of cache line 832",
      swaccess: "rw",
      hwaccess: "hrw",
      hwext:    "true",
      hwqe:     "true", // enable `qe` latched signal of software write pulse
      hwre:     "true",
      fields: [
        {
          bits: "5+3:5", // 2 bits for status
          name: "CL_STATUS",
          desc: "Contain the current status of the corresponding cache line                [0]: valid, [1]: dirty, [2]: cmpt",
        }
      ]
    },
    { name:     "TAG_832",
      desc:     "Tag Address stored in cache line 832",
      swaccess: "rw",
      hwaccess: "hrw",
      hwext:    "true",
      hwqe:     "true", // enable `qe` latched signal of software write pulse
      hwre:     "true",
      fields: [
        { bits: "5-1:0",
          name: "CL_TAG",
          desc: "Tag Address"
        }
      ]
    },
    {
      name:     "STATUS_833",
      desc:     "Status register of cache line 833",
      swaccess: "rw",
      hwaccess: "hrw",
      hwext:    "true",
      hwqe:     "true", // enable `qe` latched signal of software write pulse
      hwre:     "true",
      fields: [
        {
          bits: "5+3:5", // 2 bits for status
          name: "CL_STATUS",
          desc: "Contain the current status of the corresponding cache line                [0]: valid, [1]: dirty, [2]: cmpt",
        }
      ]
    },
    { name:     "TAG_833",
      desc:     "Tag Address stored in cache line 833",
      swaccess: "rw",
      hwaccess: "hrw",
      hwext:    "true",
      hwqe:     "true", // enable `qe` latched signal of software write pulse
      hwre:     "true",
      fields: [
        { bits: "5-1:0",
          name: "CL_TAG",
          desc: "Tag Address"
        }
      ]
    },
    {
      name:     "STATUS_834",
      desc:     "Status register of cache line 834",
      swaccess: "rw",
      hwaccess: "hrw",
      hwext:    "true",
      hwqe:     "true", // enable `qe` latched signal of software write pulse
      hwre:     "true",
      fields: [
        {
          bits: "5+3:5", // 2 bits for status
          name: "CL_STATUS",
          desc: "Contain the current status of the corresponding cache line                [0]: valid, [1]: dirty, [2]: cmpt",
        }
      ]
    },
    { name:     "TAG_834",
      desc:     "Tag Address stored in cache line 834",
      swaccess: "rw",
      hwaccess: "hrw",
      hwext:    "true",
      hwqe:     "true", // enable `qe` latched signal of software write pulse
      hwre:     "true",
      fields: [
        { bits: "5-1:0",
          name: "CL_TAG",
          desc: "Tag Address"
        }
      ]
    },
    {
      name:     "STATUS_835",
      desc:     "Status register of cache line 835",
      swaccess: "rw",
      hwaccess: "hrw",
      hwext:    "true",
      hwqe:     "true", // enable `qe` latched signal of software write pulse
      hwre:     "true",
      fields: [
        {
          bits: "5+3:5", // 2 bits for status
          name: "CL_STATUS",
          desc: "Contain the current status of the corresponding cache line                [0]: valid, [1]: dirty, [2]: cmpt",
        }
      ]
    },
    { name:     "TAG_835",
      desc:     "Tag Address stored in cache line 835",
      swaccess: "rw",
      hwaccess: "hrw",
      hwext:    "true",
      hwqe:     "true", // enable `qe` latched signal of software write pulse
      hwre:     "true",
      fields: [
        { bits: "5-1:0",
          name: "CL_TAG",
          desc: "Tag Address"
        }
      ]
    },
    {
      name:     "STATUS_836",
      desc:     "Status register of cache line 836",
      swaccess: "rw",
      hwaccess: "hrw",
      hwext:    "true",
      hwqe:     "true", // enable `qe` latched signal of software write pulse
      hwre:     "true",
      fields: [
        {
          bits: "5+3:5", // 2 bits for status
          name: "CL_STATUS",
          desc: "Contain the current status of the corresponding cache line                [0]: valid, [1]: dirty, [2]: cmpt",
        }
      ]
    },
    { name:     "TAG_836",
      desc:     "Tag Address stored in cache line 836",
      swaccess: "rw",
      hwaccess: "hrw",
      hwext:    "true",
      hwqe:     "true", // enable `qe` latched signal of software write pulse
      hwre:     "true",
      fields: [
        { bits: "5-1:0",
          name: "CL_TAG",
          desc: "Tag Address"
        }
      ]
    },
    {
      name:     "STATUS_837",
      desc:     "Status register of cache line 837",
      swaccess: "rw",
      hwaccess: "hrw",
      hwext:    "true",
      hwqe:     "true", // enable `qe` latched signal of software write pulse
      hwre:     "true",
      fields: [
        {
          bits: "5+3:5", // 2 bits for status
          name: "CL_STATUS",
          desc: "Contain the current status of the corresponding cache line                [0]: valid, [1]: dirty, [2]: cmpt",
        }
      ]
    },
    { name:     "TAG_837",
      desc:     "Tag Address stored in cache line 837",
      swaccess: "rw",
      hwaccess: "hrw",
      hwext:    "true",
      hwqe:     "true", // enable `qe` latched signal of software write pulse
      hwre:     "true",
      fields: [
        { bits: "5-1:0",
          name: "CL_TAG",
          desc: "Tag Address"
        }
      ]
    },
    {
      name:     "STATUS_838",
      desc:     "Status register of cache line 838",
      swaccess: "rw",
      hwaccess: "hrw",
      hwext:    "true",
      hwqe:     "true", // enable `qe` latched signal of software write pulse
      hwre:     "true",
      fields: [
        {
          bits: "5+3:5", // 2 bits for status
          name: "CL_STATUS",
          desc: "Contain the current status of the corresponding cache line                [0]: valid, [1]: dirty, [2]: cmpt",
        }
      ]
    },
    { name:     "TAG_838",
      desc:     "Tag Address stored in cache line 838",
      swaccess: "rw",
      hwaccess: "hrw",
      hwext:    "true",
      hwqe:     "true", // enable `qe` latched signal of software write pulse
      hwre:     "true",
      fields: [
        { bits: "5-1:0",
          name: "CL_TAG",
          desc: "Tag Address"
        }
      ]
    },
    {
      name:     "STATUS_839",
      desc:     "Status register of cache line 839",
      swaccess: "rw",
      hwaccess: "hrw",
      hwext:    "true",
      hwqe:     "true", // enable `qe` latched signal of software write pulse
      hwre:     "true",
      fields: [
        {
          bits: "5+3:5", // 2 bits for status
          name: "CL_STATUS",
          desc: "Contain the current status of the corresponding cache line                [0]: valid, [1]: dirty, [2]: cmpt",
        }
      ]
    },
    { name:     "TAG_839",
      desc:     "Tag Address stored in cache line 839",
      swaccess: "rw",
      hwaccess: "hrw",
      hwext:    "true",
      hwqe:     "true", // enable `qe` latched signal of software write pulse
      hwre:     "true",
      fields: [
        { bits: "5-1:0",
          name: "CL_TAG",
          desc: "Tag Address"
        }
      ]
    },
    {
      name:     "STATUS_840",
      desc:     "Status register of cache line 840",
      swaccess: "rw",
      hwaccess: "hrw",
      hwext:    "true",
      hwqe:     "true", // enable `qe` latched signal of software write pulse
      hwre:     "true",
      fields: [
        {
          bits: "5+3:5", // 2 bits for status
          name: "CL_STATUS",
          desc: "Contain the current status of the corresponding cache line                [0]: valid, [1]: dirty, [2]: cmpt",
        }
      ]
    },
    { name:     "TAG_840",
      desc:     "Tag Address stored in cache line 840",
      swaccess: "rw",
      hwaccess: "hrw",
      hwext:    "true",
      hwqe:     "true", // enable `qe` latched signal of software write pulse
      hwre:     "true",
      fields: [
        { bits: "5-1:0",
          name: "CL_TAG",
          desc: "Tag Address"
        }
      ]
    },
    {
      name:     "STATUS_841",
      desc:     "Status register of cache line 841",
      swaccess: "rw",
      hwaccess: "hrw",
      hwext:    "true",
      hwqe:     "true", // enable `qe` latched signal of software write pulse
      hwre:     "true",
      fields: [
        {
          bits: "5+3:5", // 2 bits for status
          name: "CL_STATUS",
          desc: "Contain the current status of the corresponding cache line                [0]: valid, [1]: dirty, [2]: cmpt",
        }
      ]
    },
    { name:     "TAG_841",
      desc:     "Tag Address stored in cache line 841",
      swaccess: "rw",
      hwaccess: "hrw",
      hwext:    "true",
      hwqe:     "true", // enable `qe` latched signal of software write pulse
      hwre:     "true",
      fields: [
        { bits: "5-1:0",
          name: "CL_TAG",
          desc: "Tag Address"
        }
      ]
    },
    {
      name:     "STATUS_842",
      desc:     "Status register of cache line 842",
      swaccess: "rw",
      hwaccess: "hrw",
      hwext:    "true",
      hwqe:     "true", // enable `qe` latched signal of software write pulse
      hwre:     "true",
      fields: [
        {
          bits: "5+3:5", // 2 bits for status
          name: "CL_STATUS",
          desc: "Contain the current status of the corresponding cache line                [0]: valid, [1]: dirty, [2]: cmpt",
        }
      ]
    },
    { name:     "TAG_842",
      desc:     "Tag Address stored in cache line 842",
      swaccess: "rw",
      hwaccess: "hrw",
      hwext:    "true",
      hwqe:     "true", // enable `qe` latched signal of software write pulse
      hwre:     "true",
      fields: [
        { bits: "5-1:0",
          name: "CL_TAG",
          desc: "Tag Address"
        }
      ]
    },
    {
      name:     "STATUS_843",
      desc:     "Status register of cache line 843",
      swaccess: "rw",
      hwaccess: "hrw",
      hwext:    "true",
      hwqe:     "true", // enable `qe` latched signal of software write pulse
      hwre:     "true",
      fields: [
        {
          bits: "5+3:5", // 2 bits for status
          name: "CL_STATUS",
          desc: "Contain the current status of the corresponding cache line                [0]: valid, [1]: dirty, [2]: cmpt",
        }
      ]
    },
    { name:     "TAG_843",
      desc:     "Tag Address stored in cache line 843",
      swaccess: "rw",
      hwaccess: "hrw",
      hwext:    "true",
      hwqe:     "true", // enable `qe` latched signal of software write pulse
      hwre:     "true",
      fields: [
        { bits: "5-1:0",
          name: "CL_TAG",
          desc: "Tag Address"
        }
      ]
    },
    {
      name:     "STATUS_844",
      desc:     "Status register of cache line 844",
      swaccess: "rw",
      hwaccess: "hrw",
      hwext:    "true",
      hwqe:     "true", // enable `qe` latched signal of software write pulse
      hwre:     "true",
      fields: [
        {
          bits: "5+3:5", // 2 bits for status
          name: "CL_STATUS",
          desc: "Contain the current status of the corresponding cache line                [0]: valid, [1]: dirty, [2]: cmpt",
        }
      ]
    },
    { name:     "TAG_844",
      desc:     "Tag Address stored in cache line 844",
      swaccess: "rw",
      hwaccess: "hrw",
      hwext:    "true",
      hwqe:     "true", // enable `qe` latched signal of software write pulse
      hwre:     "true",
      fields: [
        { bits: "5-1:0",
          name: "CL_TAG",
          desc: "Tag Address"
        }
      ]
    },
    {
      name:     "STATUS_845",
      desc:     "Status register of cache line 845",
      swaccess: "rw",
      hwaccess: "hrw",
      hwext:    "true",
      hwqe:     "true", // enable `qe` latched signal of software write pulse
      hwre:     "true",
      fields: [
        {
          bits: "5+3:5", // 2 bits for status
          name: "CL_STATUS",
          desc: "Contain the current status of the corresponding cache line                [0]: valid, [1]: dirty, [2]: cmpt",
        }
      ]
    },
    { name:     "TAG_845",
      desc:     "Tag Address stored in cache line 845",
      swaccess: "rw",
      hwaccess: "hrw",
      hwext:    "true",
      hwqe:     "true", // enable `qe` latched signal of software write pulse
      hwre:     "true",
      fields: [
        { bits: "5-1:0",
          name: "CL_TAG",
          desc: "Tag Address"
        }
      ]
    },
    {
      name:     "STATUS_846",
      desc:     "Status register of cache line 846",
      swaccess: "rw",
      hwaccess: "hrw",
      hwext:    "true",
      hwqe:     "true", // enable `qe` latched signal of software write pulse
      hwre:     "true",
      fields: [
        {
          bits: "5+3:5", // 2 bits for status
          name: "CL_STATUS",
          desc: "Contain the current status of the corresponding cache line                [0]: valid, [1]: dirty, [2]: cmpt",
        }
      ]
    },
    { name:     "TAG_846",
      desc:     "Tag Address stored in cache line 846",
      swaccess: "rw",
      hwaccess: "hrw",
      hwext:    "true",
      hwqe:     "true", // enable `qe` latched signal of software write pulse
      hwre:     "true",
      fields: [
        { bits: "5-1:0",
          name: "CL_TAG",
          desc: "Tag Address"
        }
      ]
    },
    {
      name:     "STATUS_847",
      desc:     "Status register of cache line 847",
      swaccess: "rw",
      hwaccess: "hrw",
      hwext:    "true",
      hwqe:     "true", // enable `qe` latched signal of software write pulse
      hwre:     "true",
      fields: [
        {
          bits: "5+3:5", // 2 bits for status
          name: "CL_STATUS",
          desc: "Contain the current status of the corresponding cache line                [0]: valid, [1]: dirty, [2]: cmpt",
        }
      ]
    },
    { name:     "TAG_847",
      desc:     "Tag Address stored in cache line 847",
      swaccess: "rw",
      hwaccess: "hrw",
      hwext:    "true",
      hwqe:     "true", // enable `qe` latched signal of software write pulse
      hwre:     "true",
      fields: [
        { bits: "5-1:0",
          name: "CL_TAG",
          desc: "Tag Address"
        }
      ]
    },
    {
      name:     "STATUS_848",
      desc:     "Status register of cache line 848",
      swaccess: "rw",
      hwaccess: "hrw",
      hwext:    "true",
      hwqe:     "true", // enable `qe` latched signal of software write pulse
      hwre:     "true",
      fields: [
        {
          bits: "5+3:5", // 2 bits for status
          name: "CL_STATUS",
          desc: "Contain the current status of the corresponding cache line                [0]: valid, [1]: dirty, [2]: cmpt",
        }
      ]
    },
    { name:     "TAG_848",
      desc:     "Tag Address stored in cache line 848",
      swaccess: "rw",
      hwaccess: "hrw",
      hwext:    "true",
      hwqe:     "true", // enable `qe` latched signal of software write pulse
      hwre:     "true",
      fields: [
        { bits: "5-1:0",
          name: "CL_TAG",
          desc: "Tag Address"
        }
      ]
    },
    {
      name:     "STATUS_849",
      desc:     "Status register of cache line 849",
      swaccess: "rw",
      hwaccess: "hrw",
      hwext:    "true",
      hwqe:     "true", // enable `qe` latched signal of software write pulse
      hwre:     "true",
      fields: [
        {
          bits: "5+3:5", // 2 bits for status
          name: "CL_STATUS",
          desc: "Contain the current status of the corresponding cache line                [0]: valid, [1]: dirty, [2]: cmpt",
        }
      ]
    },
    { name:     "TAG_849",
      desc:     "Tag Address stored in cache line 849",
      swaccess: "rw",
      hwaccess: "hrw",
      hwext:    "true",
      hwqe:     "true", // enable `qe` latched signal of software write pulse
      hwre:     "true",
      fields: [
        { bits: "5-1:0",
          name: "CL_TAG",
          desc: "Tag Address"
        }
      ]
    },
    {
      name:     "STATUS_850",
      desc:     "Status register of cache line 850",
      swaccess: "rw",
      hwaccess: "hrw",
      hwext:    "true",
      hwqe:     "true", // enable `qe` latched signal of software write pulse
      hwre:     "true",
      fields: [
        {
          bits: "5+3:5", // 2 bits for status
          name: "CL_STATUS",
          desc: "Contain the current status of the corresponding cache line                [0]: valid, [1]: dirty, [2]: cmpt",
        }
      ]
    },
    { name:     "TAG_850",
      desc:     "Tag Address stored in cache line 850",
      swaccess: "rw",
      hwaccess: "hrw",
      hwext:    "true",
      hwqe:     "true", // enable `qe` latched signal of software write pulse
      hwre:     "true",
      fields: [
        { bits: "5-1:0",
          name: "CL_TAG",
          desc: "Tag Address"
        }
      ]
    },
    {
      name:     "STATUS_851",
      desc:     "Status register of cache line 851",
      swaccess: "rw",
      hwaccess: "hrw",
      hwext:    "true",
      hwqe:     "true", // enable `qe` latched signal of software write pulse
      hwre:     "true",
      fields: [
        {
          bits: "5+3:5", // 2 bits for status
          name: "CL_STATUS",
          desc: "Contain the current status of the corresponding cache line                [0]: valid, [1]: dirty, [2]: cmpt",
        }
      ]
    },
    { name:     "TAG_851",
      desc:     "Tag Address stored in cache line 851",
      swaccess: "rw",
      hwaccess: "hrw",
      hwext:    "true",
      hwqe:     "true", // enable `qe` latched signal of software write pulse
      hwre:     "true",
      fields: [
        { bits: "5-1:0",
          name: "CL_TAG",
          desc: "Tag Address"
        }
      ]
    },
    {
      name:     "STATUS_852",
      desc:     "Status register of cache line 852",
      swaccess: "rw",
      hwaccess: "hrw",
      hwext:    "true",
      hwqe:     "true", // enable `qe` latched signal of software write pulse
      hwre:     "true",
      fields: [
        {
          bits: "5+3:5", // 2 bits for status
          name: "CL_STATUS",
          desc: "Contain the current status of the corresponding cache line                [0]: valid, [1]: dirty, [2]: cmpt",
        }
      ]
    },
    { name:     "TAG_852",
      desc:     "Tag Address stored in cache line 852",
      swaccess: "rw",
      hwaccess: "hrw",
      hwext:    "true",
      hwqe:     "true", // enable `qe` latched signal of software write pulse
      hwre:     "true",
      fields: [
        { bits: "5-1:0",
          name: "CL_TAG",
          desc: "Tag Address"
        }
      ]
    },
    {
      name:     "STATUS_853",
      desc:     "Status register of cache line 853",
      swaccess: "rw",
      hwaccess: "hrw",
      hwext:    "true",
      hwqe:     "true", // enable `qe` latched signal of software write pulse
      hwre:     "true",
      fields: [
        {
          bits: "5+3:5", // 2 bits for status
          name: "CL_STATUS",
          desc: "Contain the current status of the corresponding cache line                [0]: valid, [1]: dirty, [2]: cmpt",
        }
      ]
    },
    { name:     "TAG_853",
      desc:     "Tag Address stored in cache line 853",
      swaccess: "rw",
      hwaccess: "hrw",
      hwext:    "true",
      hwqe:     "true", // enable `qe` latched signal of software write pulse
      hwre:     "true",
      fields: [
        { bits: "5-1:0",
          name: "CL_TAG",
          desc: "Tag Address"
        }
      ]
    },
    {
      name:     "STATUS_854",
      desc:     "Status register of cache line 854",
      swaccess: "rw",
      hwaccess: "hrw",
      hwext:    "true",
      hwqe:     "true", // enable `qe` latched signal of software write pulse
      hwre:     "true",
      fields: [
        {
          bits: "5+3:5", // 2 bits for status
          name: "CL_STATUS",
          desc: "Contain the current status of the corresponding cache line                [0]: valid, [1]: dirty, [2]: cmpt",
        }
      ]
    },
    { name:     "TAG_854",
      desc:     "Tag Address stored in cache line 854",
      swaccess: "rw",
      hwaccess: "hrw",
      hwext:    "true",
      hwqe:     "true", // enable `qe` latched signal of software write pulse
      hwre:     "true",
      fields: [
        { bits: "5-1:0",
          name: "CL_TAG",
          desc: "Tag Address"
        }
      ]
    },
    {
      name:     "STATUS_855",
      desc:     "Status register of cache line 855",
      swaccess: "rw",
      hwaccess: "hrw",
      hwext:    "true",
      hwqe:     "true", // enable `qe` latched signal of software write pulse
      hwre:     "true",
      fields: [
        {
          bits: "5+3:5", // 2 bits for status
          name: "CL_STATUS",
          desc: "Contain the current status of the corresponding cache line                [0]: valid, [1]: dirty, [2]: cmpt",
        }
      ]
    },
    { name:     "TAG_855",
      desc:     "Tag Address stored in cache line 855",
      swaccess: "rw",
      hwaccess: "hrw",
      hwext:    "true",
      hwqe:     "true", // enable `qe` latched signal of software write pulse
      hwre:     "true",
      fields: [
        { bits: "5-1:0",
          name: "CL_TAG",
          desc: "Tag Address"
        }
      ]
    },
    {
      name:     "STATUS_856",
      desc:     "Status register of cache line 856",
      swaccess: "rw",
      hwaccess: "hrw",
      hwext:    "true",
      hwqe:     "true", // enable `qe` latched signal of software write pulse
      hwre:     "true",
      fields: [
        {
          bits: "5+3:5", // 2 bits for status
          name: "CL_STATUS",
          desc: "Contain the current status of the corresponding cache line                [0]: valid, [1]: dirty, [2]: cmpt",
        }
      ]
    },
    { name:     "TAG_856",
      desc:     "Tag Address stored in cache line 856",
      swaccess: "rw",
      hwaccess: "hrw",
      hwext:    "true",
      hwqe:     "true", // enable `qe` latched signal of software write pulse
      hwre:     "true",
      fields: [
        { bits: "5-1:0",
          name: "CL_TAG",
          desc: "Tag Address"
        }
      ]
    },
    {
      name:     "STATUS_857",
      desc:     "Status register of cache line 857",
      swaccess: "rw",
      hwaccess: "hrw",
      hwext:    "true",
      hwqe:     "true", // enable `qe` latched signal of software write pulse
      hwre:     "true",
      fields: [
        {
          bits: "5+3:5", // 2 bits for status
          name: "CL_STATUS",
          desc: "Contain the current status of the corresponding cache line                [0]: valid, [1]: dirty, [2]: cmpt",
        }
      ]
    },
    { name:     "TAG_857",
      desc:     "Tag Address stored in cache line 857",
      swaccess: "rw",
      hwaccess: "hrw",
      hwext:    "true",
      hwqe:     "true", // enable `qe` latched signal of software write pulse
      hwre:     "true",
      fields: [
        { bits: "5-1:0",
          name: "CL_TAG",
          desc: "Tag Address"
        }
      ]
    },
    {
      name:     "STATUS_858",
      desc:     "Status register of cache line 858",
      swaccess: "rw",
      hwaccess: "hrw",
      hwext:    "true",
      hwqe:     "true", // enable `qe` latched signal of software write pulse
      hwre:     "true",
      fields: [
        {
          bits: "5+3:5", // 2 bits for status
          name: "CL_STATUS",
          desc: "Contain the current status of the corresponding cache line                [0]: valid, [1]: dirty, [2]: cmpt",
        }
      ]
    },
    { name:     "TAG_858",
      desc:     "Tag Address stored in cache line 858",
      swaccess: "rw",
      hwaccess: "hrw",
      hwext:    "true",
      hwqe:     "true", // enable `qe` latched signal of software write pulse
      hwre:     "true",
      fields: [
        { bits: "5-1:0",
          name: "CL_TAG",
          desc: "Tag Address"
        }
      ]
    },
    {
      name:     "STATUS_859",
      desc:     "Status register of cache line 859",
      swaccess: "rw",
      hwaccess: "hrw",
      hwext:    "true",
      hwqe:     "true", // enable `qe` latched signal of software write pulse
      hwre:     "true",
      fields: [
        {
          bits: "5+3:5", // 2 bits for status
          name: "CL_STATUS",
          desc: "Contain the current status of the corresponding cache line                [0]: valid, [1]: dirty, [2]: cmpt",
        }
      ]
    },
    { name:     "TAG_859",
      desc:     "Tag Address stored in cache line 859",
      swaccess: "rw",
      hwaccess: "hrw",
      hwext:    "true",
      hwqe:     "true", // enable `qe` latched signal of software write pulse
      hwre:     "true",
      fields: [
        { bits: "5-1:0",
          name: "CL_TAG",
          desc: "Tag Address"
        }
      ]
    },
    {
      name:     "STATUS_860",
      desc:     "Status register of cache line 860",
      swaccess: "rw",
      hwaccess: "hrw",
      hwext:    "true",
      hwqe:     "true", // enable `qe` latched signal of software write pulse
      hwre:     "true",
      fields: [
        {
          bits: "5+3:5", // 2 bits for status
          name: "CL_STATUS",
          desc: "Contain the current status of the corresponding cache line                [0]: valid, [1]: dirty, [2]: cmpt",
        }
      ]
    },
    { name:     "TAG_860",
      desc:     "Tag Address stored in cache line 860",
      swaccess: "rw",
      hwaccess: "hrw",
      hwext:    "true",
      hwqe:     "true", // enable `qe` latched signal of software write pulse
      hwre:     "true",
      fields: [
        { bits: "5-1:0",
          name: "CL_TAG",
          desc: "Tag Address"
        }
      ]
    },
    {
      name:     "STATUS_861",
      desc:     "Status register of cache line 861",
      swaccess: "rw",
      hwaccess: "hrw",
      hwext:    "true",
      hwqe:     "true", // enable `qe` latched signal of software write pulse
      hwre:     "true",
      fields: [
        {
          bits: "5+3:5", // 2 bits for status
          name: "CL_STATUS",
          desc: "Contain the current status of the corresponding cache line                [0]: valid, [1]: dirty, [2]: cmpt",
        }
      ]
    },
    { name:     "TAG_861",
      desc:     "Tag Address stored in cache line 861",
      swaccess: "rw",
      hwaccess: "hrw",
      hwext:    "true",
      hwqe:     "true", // enable `qe` latched signal of software write pulse
      hwre:     "true",
      fields: [
        { bits: "5-1:0",
          name: "CL_TAG",
          desc: "Tag Address"
        }
      ]
    },
    {
      name:     "STATUS_862",
      desc:     "Status register of cache line 862",
      swaccess: "rw",
      hwaccess: "hrw",
      hwext:    "true",
      hwqe:     "true", // enable `qe` latched signal of software write pulse
      hwre:     "true",
      fields: [
        {
          bits: "5+3:5", // 2 bits for status
          name: "CL_STATUS",
          desc: "Contain the current status of the corresponding cache line                [0]: valid, [1]: dirty, [2]: cmpt",
        }
      ]
    },
    { name:     "TAG_862",
      desc:     "Tag Address stored in cache line 862",
      swaccess: "rw",
      hwaccess: "hrw",
      hwext:    "true",
      hwqe:     "true", // enable `qe` latched signal of software write pulse
      hwre:     "true",
      fields: [
        { bits: "5-1:0",
          name: "CL_TAG",
          desc: "Tag Address"
        }
      ]
    },
    {
      name:     "STATUS_863",
      desc:     "Status register of cache line 863",
      swaccess: "rw",
      hwaccess: "hrw",
      hwext:    "true",
      hwqe:     "true", // enable `qe` latched signal of software write pulse
      hwre:     "true",
      fields: [
        {
          bits: "5+3:5", // 2 bits for status
          name: "CL_STATUS",
          desc: "Contain the current status of the corresponding cache line                [0]: valid, [1]: dirty, [2]: cmpt",
        }
      ]
    },
    { name:     "TAG_863",
      desc:     "Tag Address stored in cache line 863",
      swaccess: "rw",
      hwaccess: "hrw",
      hwext:    "true",
      hwqe:     "true", // enable `qe` latched signal of software write pulse
      hwre:     "true",
      fields: [
        { bits: "5-1:0",
          name: "CL_TAG",
          desc: "Tag Address"
        }
      ]
    },
    {
      name:     "STATUS_864",
      desc:     "Status register of cache line 864",
      swaccess: "rw",
      hwaccess: "hrw",
      hwext:    "true",
      hwqe:     "true", // enable `qe` latched signal of software write pulse
      hwre:     "true",
      fields: [
        {
          bits: "5+3:5", // 2 bits for status
          name: "CL_STATUS",
          desc: "Contain the current status of the corresponding cache line                [0]: valid, [1]: dirty, [2]: cmpt",
        }
      ]
    },
    { name:     "TAG_864",
      desc:     "Tag Address stored in cache line 864",
      swaccess: "rw",
      hwaccess: "hrw",
      hwext:    "true",
      hwqe:     "true", // enable `qe` latched signal of software write pulse
      hwre:     "true",
      fields: [
        { bits: "5-1:0",
          name: "CL_TAG",
          desc: "Tag Address"
        }
      ]
    },
    {
      name:     "STATUS_865",
      desc:     "Status register of cache line 865",
      swaccess: "rw",
      hwaccess: "hrw",
      hwext:    "true",
      hwqe:     "true", // enable `qe` latched signal of software write pulse
      hwre:     "true",
      fields: [
        {
          bits: "5+3:5", // 2 bits for status
          name: "CL_STATUS",
          desc: "Contain the current status of the corresponding cache line                [0]: valid, [1]: dirty, [2]: cmpt",
        }
      ]
    },
    { name:     "TAG_865",
      desc:     "Tag Address stored in cache line 865",
      swaccess: "rw",
      hwaccess: "hrw",
      hwext:    "true",
      hwqe:     "true", // enable `qe` latched signal of software write pulse
      hwre:     "true",
      fields: [
        { bits: "5-1:0",
          name: "CL_TAG",
          desc: "Tag Address"
        }
      ]
    },
    {
      name:     "STATUS_866",
      desc:     "Status register of cache line 866",
      swaccess: "rw",
      hwaccess: "hrw",
      hwext:    "true",
      hwqe:     "true", // enable `qe` latched signal of software write pulse
      hwre:     "true",
      fields: [
        {
          bits: "5+3:5", // 2 bits for status
          name: "CL_STATUS",
          desc: "Contain the current status of the corresponding cache line                [0]: valid, [1]: dirty, [2]: cmpt",
        }
      ]
    },
    { name:     "TAG_866",
      desc:     "Tag Address stored in cache line 866",
      swaccess: "rw",
      hwaccess: "hrw",
      hwext:    "true",
      hwqe:     "true", // enable `qe` latched signal of software write pulse
      hwre:     "true",
      fields: [
        { bits: "5-1:0",
          name: "CL_TAG",
          desc: "Tag Address"
        }
      ]
    },
    {
      name:     "STATUS_867",
      desc:     "Status register of cache line 867",
      swaccess: "rw",
      hwaccess: "hrw",
      hwext:    "true",
      hwqe:     "true", // enable `qe` latched signal of software write pulse
      hwre:     "true",
      fields: [
        {
          bits: "5+3:5", // 2 bits for status
          name: "CL_STATUS",
          desc: "Contain the current status of the corresponding cache line                [0]: valid, [1]: dirty, [2]: cmpt",
        }
      ]
    },
    { name:     "TAG_867",
      desc:     "Tag Address stored in cache line 867",
      swaccess: "rw",
      hwaccess: "hrw",
      hwext:    "true",
      hwqe:     "true", // enable `qe` latched signal of software write pulse
      hwre:     "true",
      fields: [
        { bits: "5-1:0",
          name: "CL_TAG",
          desc: "Tag Address"
        }
      ]
    },
    {
      name:     "STATUS_868",
      desc:     "Status register of cache line 868",
      swaccess: "rw",
      hwaccess: "hrw",
      hwext:    "true",
      hwqe:     "true", // enable `qe` latched signal of software write pulse
      hwre:     "true",
      fields: [
        {
          bits: "5+3:5", // 2 bits for status
          name: "CL_STATUS",
          desc: "Contain the current status of the corresponding cache line                [0]: valid, [1]: dirty, [2]: cmpt",
        }
      ]
    },
    { name:     "TAG_868",
      desc:     "Tag Address stored in cache line 868",
      swaccess: "rw",
      hwaccess: "hrw",
      hwext:    "true",
      hwqe:     "true", // enable `qe` latched signal of software write pulse
      hwre:     "true",
      fields: [
        { bits: "5-1:0",
          name: "CL_TAG",
          desc: "Tag Address"
        }
      ]
    },
    {
      name:     "STATUS_869",
      desc:     "Status register of cache line 869",
      swaccess: "rw",
      hwaccess: "hrw",
      hwext:    "true",
      hwqe:     "true", // enable `qe` latched signal of software write pulse
      hwre:     "true",
      fields: [
        {
          bits: "5+3:5", // 2 bits for status
          name: "CL_STATUS",
          desc: "Contain the current status of the corresponding cache line                [0]: valid, [1]: dirty, [2]: cmpt",
        }
      ]
    },
    { name:     "TAG_869",
      desc:     "Tag Address stored in cache line 869",
      swaccess: "rw",
      hwaccess: "hrw",
      hwext:    "true",
      hwqe:     "true", // enable `qe` latched signal of software write pulse
      hwre:     "true",
      fields: [
        { bits: "5-1:0",
          name: "CL_TAG",
          desc: "Tag Address"
        }
      ]
    },
    {
      name:     "STATUS_870",
      desc:     "Status register of cache line 870",
      swaccess: "rw",
      hwaccess: "hrw",
      hwext:    "true",
      hwqe:     "true", // enable `qe` latched signal of software write pulse
      hwre:     "true",
      fields: [
        {
          bits: "5+3:5", // 2 bits for status
          name: "CL_STATUS",
          desc: "Contain the current status of the corresponding cache line                [0]: valid, [1]: dirty, [2]: cmpt",
        }
      ]
    },
    { name:     "TAG_870",
      desc:     "Tag Address stored in cache line 870",
      swaccess: "rw",
      hwaccess: "hrw",
      hwext:    "true",
      hwqe:     "true", // enable `qe` latched signal of software write pulse
      hwre:     "true",
      fields: [
        { bits: "5-1:0",
          name: "CL_TAG",
          desc: "Tag Address"
        }
      ]
    },
    {
      name:     "STATUS_871",
      desc:     "Status register of cache line 871",
      swaccess: "rw",
      hwaccess: "hrw",
      hwext:    "true",
      hwqe:     "true", // enable `qe` latched signal of software write pulse
      hwre:     "true",
      fields: [
        {
          bits: "5+3:5", // 2 bits for status
          name: "CL_STATUS",
          desc: "Contain the current status of the corresponding cache line                [0]: valid, [1]: dirty, [2]: cmpt",
        }
      ]
    },
    { name:     "TAG_871",
      desc:     "Tag Address stored in cache line 871",
      swaccess: "rw",
      hwaccess: "hrw",
      hwext:    "true",
      hwqe:     "true", // enable `qe` latched signal of software write pulse
      hwre:     "true",
      fields: [
        { bits: "5-1:0",
          name: "CL_TAG",
          desc: "Tag Address"
        }
      ]
    },
    {
      name:     "STATUS_872",
      desc:     "Status register of cache line 872",
      swaccess: "rw",
      hwaccess: "hrw",
      hwext:    "true",
      hwqe:     "true", // enable `qe` latched signal of software write pulse
      hwre:     "true",
      fields: [
        {
          bits: "5+3:5", // 2 bits for status
          name: "CL_STATUS",
          desc: "Contain the current status of the corresponding cache line                [0]: valid, [1]: dirty, [2]: cmpt",
        }
      ]
    },
    { name:     "TAG_872",
      desc:     "Tag Address stored in cache line 872",
      swaccess: "rw",
      hwaccess: "hrw",
      hwext:    "true",
      hwqe:     "true", // enable `qe` latched signal of software write pulse
      hwre:     "true",
      fields: [
        { bits: "5-1:0",
          name: "CL_TAG",
          desc: "Tag Address"
        }
      ]
    },
    {
      name:     "STATUS_873",
      desc:     "Status register of cache line 873",
      swaccess: "rw",
      hwaccess: "hrw",
      hwext:    "true",
      hwqe:     "true", // enable `qe` latched signal of software write pulse
      hwre:     "true",
      fields: [
        {
          bits: "5+3:5", // 2 bits for status
          name: "CL_STATUS",
          desc: "Contain the current status of the corresponding cache line                [0]: valid, [1]: dirty, [2]: cmpt",
        }
      ]
    },
    { name:     "TAG_873",
      desc:     "Tag Address stored in cache line 873",
      swaccess: "rw",
      hwaccess: "hrw",
      hwext:    "true",
      hwqe:     "true", // enable `qe` latched signal of software write pulse
      hwre:     "true",
      fields: [
        { bits: "5-1:0",
          name: "CL_TAG",
          desc: "Tag Address"
        }
      ]
    },
    {
      name:     "STATUS_874",
      desc:     "Status register of cache line 874",
      swaccess: "rw",
      hwaccess: "hrw",
      hwext:    "true",
      hwqe:     "true", // enable `qe` latched signal of software write pulse
      hwre:     "true",
      fields: [
        {
          bits: "5+3:5", // 2 bits for status
          name: "CL_STATUS",
          desc: "Contain the current status of the corresponding cache line                [0]: valid, [1]: dirty, [2]: cmpt",
        }
      ]
    },
    { name:     "TAG_874",
      desc:     "Tag Address stored in cache line 874",
      swaccess: "rw",
      hwaccess: "hrw",
      hwext:    "true",
      hwqe:     "true", // enable `qe` latched signal of software write pulse
      hwre:     "true",
      fields: [
        { bits: "5-1:0",
          name: "CL_TAG",
          desc: "Tag Address"
        }
      ]
    },
    {
      name:     "STATUS_875",
      desc:     "Status register of cache line 875",
      swaccess: "rw",
      hwaccess: "hrw",
      hwext:    "true",
      hwqe:     "true", // enable `qe` latched signal of software write pulse
      hwre:     "true",
      fields: [
        {
          bits: "5+3:5", // 2 bits for status
          name: "CL_STATUS",
          desc: "Contain the current status of the corresponding cache line                [0]: valid, [1]: dirty, [2]: cmpt",
        }
      ]
    },
    { name:     "TAG_875",
      desc:     "Tag Address stored in cache line 875",
      swaccess: "rw",
      hwaccess: "hrw",
      hwext:    "true",
      hwqe:     "true", // enable `qe` latched signal of software write pulse
      hwre:     "true",
      fields: [
        { bits: "5-1:0",
          name: "CL_TAG",
          desc: "Tag Address"
        }
      ]
    },
    {
      name:     "STATUS_876",
      desc:     "Status register of cache line 876",
      swaccess: "rw",
      hwaccess: "hrw",
      hwext:    "true",
      hwqe:     "true", // enable `qe` latched signal of software write pulse
      hwre:     "true",
      fields: [
        {
          bits: "5+3:5", // 2 bits for status
          name: "CL_STATUS",
          desc: "Contain the current status of the corresponding cache line                [0]: valid, [1]: dirty, [2]: cmpt",
        }
      ]
    },
    { name:     "TAG_876",
      desc:     "Tag Address stored in cache line 876",
      swaccess: "rw",
      hwaccess: "hrw",
      hwext:    "true",
      hwqe:     "true", // enable `qe` latched signal of software write pulse
      hwre:     "true",
      fields: [
        { bits: "5-1:0",
          name: "CL_TAG",
          desc: "Tag Address"
        }
      ]
    },
    {
      name:     "STATUS_877",
      desc:     "Status register of cache line 877",
      swaccess: "rw",
      hwaccess: "hrw",
      hwext:    "true",
      hwqe:     "true", // enable `qe` latched signal of software write pulse
      hwre:     "true",
      fields: [
        {
          bits: "5+3:5", // 2 bits for status
          name: "CL_STATUS",
          desc: "Contain the current status of the corresponding cache line                [0]: valid, [1]: dirty, [2]: cmpt",
        }
      ]
    },
    { name:     "TAG_877",
      desc:     "Tag Address stored in cache line 877",
      swaccess: "rw",
      hwaccess: "hrw",
      hwext:    "true",
      hwqe:     "true", // enable `qe` latched signal of software write pulse
      hwre:     "true",
      fields: [
        { bits: "5-1:0",
          name: "CL_TAG",
          desc: "Tag Address"
        }
      ]
    },
    {
      name:     "STATUS_878",
      desc:     "Status register of cache line 878",
      swaccess: "rw",
      hwaccess: "hrw",
      hwext:    "true",
      hwqe:     "true", // enable `qe` latched signal of software write pulse
      hwre:     "true",
      fields: [
        {
          bits: "5+3:5", // 2 bits for status
          name: "CL_STATUS",
          desc: "Contain the current status of the corresponding cache line                [0]: valid, [1]: dirty, [2]: cmpt",
        }
      ]
    },
    { name:     "TAG_878",
      desc:     "Tag Address stored in cache line 878",
      swaccess: "rw",
      hwaccess: "hrw",
      hwext:    "true",
      hwqe:     "true", // enable `qe` latched signal of software write pulse
      hwre:     "true",
      fields: [
        { bits: "5-1:0",
          name: "CL_TAG",
          desc: "Tag Address"
        }
      ]
    },
    {
      name:     "STATUS_879",
      desc:     "Status register of cache line 879",
      swaccess: "rw",
      hwaccess: "hrw",
      hwext:    "true",
      hwqe:     "true", // enable `qe` latched signal of software write pulse
      hwre:     "true",
      fields: [
        {
          bits: "5+3:5", // 2 bits for status
          name: "CL_STATUS",
          desc: "Contain the current status of the corresponding cache line                [0]: valid, [1]: dirty, [2]: cmpt",
        }
      ]
    },
    { name:     "TAG_879",
      desc:     "Tag Address stored in cache line 879",
      swaccess: "rw",
      hwaccess: "hrw",
      hwext:    "true",
      hwqe:     "true", // enable `qe` latched signal of software write pulse
      hwre:     "true",
      fields: [
        { bits: "5-1:0",
          name: "CL_TAG",
          desc: "Tag Address"
        }
      ]
    },
    {
      name:     "STATUS_880",
      desc:     "Status register of cache line 880",
      swaccess: "rw",
      hwaccess: "hrw",
      hwext:    "true",
      hwqe:     "true", // enable `qe` latched signal of software write pulse
      hwre:     "true",
      fields: [
        {
          bits: "5+3:5", // 2 bits for status
          name: "CL_STATUS",
          desc: "Contain the current status of the corresponding cache line                [0]: valid, [1]: dirty, [2]: cmpt",
        }
      ]
    },
    { name:     "TAG_880",
      desc:     "Tag Address stored in cache line 880",
      swaccess: "rw",
      hwaccess: "hrw",
      hwext:    "true",
      hwqe:     "true", // enable `qe` latched signal of software write pulse
      hwre:     "true",
      fields: [
        { bits: "5-1:0",
          name: "CL_TAG",
          desc: "Tag Address"
        }
      ]
    },
    {
      name:     "STATUS_881",
      desc:     "Status register of cache line 881",
      swaccess: "rw",
      hwaccess: "hrw",
      hwext:    "true",
      hwqe:     "true", // enable `qe` latched signal of software write pulse
      hwre:     "true",
      fields: [
        {
          bits: "5+3:5", // 2 bits for status
          name: "CL_STATUS",
          desc: "Contain the current status of the corresponding cache line                [0]: valid, [1]: dirty, [2]: cmpt",
        }
      ]
    },
    { name:     "TAG_881",
      desc:     "Tag Address stored in cache line 881",
      swaccess: "rw",
      hwaccess: "hrw",
      hwext:    "true",
      hwqe:     "true", // enable `qe` latched signal of software write pulse
      hwre:     "true",
      fields: [
        { bits: "5-1:0",
          name: "CL_TAG",
          desc: "Tag Address"
        }
      ]
    },
    {
      name:     "STATUS_882",
      desc:     "Status register of cache line 882",
      swaccess: "rw",
      hwaccess: "hrw",
      hwext:    "true",
      hwqe:     "true", // enable `qe` latched signal of software write pulse
      hwre:     "true",
      fields: [
        {
          bits: "5+3:5", // 2 bits for status
          name: "CL_STATUS",
          desc: "Contain the current status of the corresponding cache line                [0]: valid, [1]: dirty, [2]: cmpt",
        }
      ]
    },
    { name:     "TAG_882",
      desc:     "Tag Address stored in cache line 882",
      swaccess: "rw",
      hwaccess: "hrw",
      hwext:    "true",
      hwqe:     "true", // enable `qe` latched signal of software write pulse
      hwre:     "true",
      fields: [
        { bits: "5-1:0",
          name: "CL_TAG",
          desc: "Tag Address"
        }
      ]
    },
    {
      name:     "STATUS_883",
      desc:     "Status register of cache line 883",
      swaccess: "rw",
      hwaccess: "hrw",
      hwext:    "true",
      hwqe:     "true", // enable `qe` latched signal of software write pulse
      hwre:     "true",
      fields: [
        {
          bits: "5+3:5", // 2 bits for status
          name: "CL_STATUS",
          desc: "Contain the current status of the corresponding cache line                [0]: valid, [1]: dirty, [2]: cmpt",
        }
      ]
    },
    { name:     "TAG_883",
      desc:     "Tag Address stored in cache line 883",
      swaccess: "rw",
      hwaccess: "hrw",
      hwext:    "true",
      hwqe:     "true", // enable `qe` latched signal of software write pulse
      hwre:     "true",
      fields: [
        { bits: "5-1:0",
          name: "CL_TAG",
          desc: "Tag Address"
        }
      ]
    },
    {
      name:     "STATUS_884",
      desc:     "Status register of cache line 884",
      swaccess: "rw",
      hwaccess: "hrw",
      hwext:    "true",
      hwqe:     "true", // enable `qe` latched signal of software write pulse
      hwre:     "true",
      fields: [
        {
          bits: "5+3:5", // 2 bits for status
          name: "CL_STATUS",
          desc: "Contain the current status of the corresponding cache line                [0]: valid, [1]: dirty, [2]: cmpt",
        }
      ]
    },
    { name:     "TAG_884",
      desc:     "Tag Address stored in cache line 884",
      swaccess: "rw",
      hwaccess: "hrw",
      hwext:    "true",
      hwqe:     "true", // enable `qe` latched signal of software write pulse
      hwre:     "true",
      fields: [
        { bits: "5-1:0",
          name: "CL_TAG",
          desc: "Tag Address"
        }
      ]
    },
    {
      name:     "STATUS_885",
      desc:     "Status register of cache line 885",
      swaccess: "rw",
      hwaccess: "hrw",
      hwext:    "true",
      hwqe:     "true", // enable `qe` latched signal of software write pulse
      hwre:     "true",
      fields: [
        {
          bits: "5+3:5", // 2 bits for status
          name: "CL_STATUS",
          desc: "Contain the current status of the corresponding cache line                [0]: valid, [1]: dirty, [2]: cmpt",
        }
      ]
    },
    { name:     "TAG_885",
      desc:     "Tag Address stored in cache line 885",
      swaccess: "rw",
      hwaccess: "hrw",
      hwext:    "true",
      hwqe:     "true", // enable `qe` latched signal of software write pulse
      hwre:     "true",
      fields: [
        { bits: "5-1:0",
          name: "CL_TAG",
          desc: "Tag Address"
        }
      ]
    },
    {
      name:     "STATUS_886",
      desc:     "Status register of cache line 886",
      swaccess: "rw",
      hwaccess: "hrw",
      hwext:    "true",
      hwqe:     "true", // enable `qe` latched signal of software write pulse
      hwre:     "true",
      fields: [
        {
          bits: "5+3:5", // 2 bits for status
          name: "CL_STATUS",
          desc: "Contain the current status of the corresponding cache line                [0]: valid, [1]: dirty, [2]: cmpt",
        }
      ]
    },
    { name:     "TAG_886",
      desc:     "Tag Address stored in cache line 886",
      swaccess: "rw",
      hwaccess: "hrw",
      hwext:    "true",
      hwqe:     "true", // enable `qe` latched signal of software write pulse
      hwre:     "true",
      fields: [
        { bits: "5-1:0",
          name: "CL_TAG",
          desc: "Tag Address"
        }
      ]
    },
    {
      name:     "STATUS_887",
      desc:     "Status register of cache line 887",
      swaccess: "rw",
      hwaccess: "hrw",
      hwext:    "true",
      hwqe:     "true", // enable `qe` latched signal of software write pulse
      hwre:     "true",
      fields: [
        {
          bits: "5+3:5", // 2 bits for status
          name: "CL_STATUS",
          desc: "Contain the current status of the corresponding cache line                [0]: valid, [1]: dirty, [2]: cmpt",
        }
      ]
    },
    { name:     "TAG_887",
      desc:     "Tag Address stored in cache line 887",
      swaccess: "rw",
      hwaccess: "hrw",
      hwext:    "true",
      hwqe:     "true", // enable `qe` latched signal of software write pulse
      hwre:     "true",
      fields: [
        { bits: "5-1:0",
          name: "CL_TAG",
          desc: "Tag Address"
        }
      ]
    },
    {
      name:     "STATUS_888",
      desc:     "Status register of cache line 888",
      swaccess: "rw",
      hwaccess: "hrw",
      hwext:    "true",
      hwqe:     "true", // enable `qe` latched signal of software write pulse
      hwre:     "true",
      fields: [
        {
          bits: "5+3:5", // 2 bits for status
          name: "CL_STATUS",
          desc: "Contain the current status of the corresponding cache line                [0]: valid, [1]: dirty, [2]: cmpt",
        }
      ]
    },
    { name:     "TAG_888",
      desc:     "Tag Address stored in cache line 888",
      swaccess: "rw",
      hwaccess: "hrw",
      hwext:    "true",
      hwqe:     "true", // enable `qe` latched signal of software write pulse
      hwre:     "true",
      fields: [
        { bits: "5-1:0",
          name: "CL_TAG",
          desc: "Tag Address"
        }
      ]
    },
    {
      name:     "STATUS_889",
      desc:     "Status register of cache line 889",
      swaccess: "rw",
      hwaccess: "hrw",
      hwext:    "true",
      hwqe:     "true", // enable `qe` latched signal of software write pulse
      hwre:     "true",
      fields: [
        {
          bits: "5+3:5", // 2 bits for status
          name: "CL_STATUS",
          desc: "Contain the current status of the corresponding cache line                [0]: valid, [1]: dirty, [2]: cmpt",
        }
      ]
    },
    { name:     "TAG_889",
      desc:     "Tag Address stored in cache line 889",
      swaccess: "rw",
      hwaccess: "hrw",
      hwext:    "true",
      hwqe:     "true", // enable `qe` latched signal of software write pulse
      hwre:     "true",
      fields: [
        { bits: "5-1:0",
          name: "CL_TAG",
          desc: "Tag Address"
        }
      ]
    },
    {
      name:     "STATUS_890",
      desc:     "Status register of cache line 890",
      swaccess: "rw",
      hwaccess: "hrw",
      hwext:    "true",
      hwqe:     "true", // enable `qe` latched signal of software write pulse
      hwre:     "true",
      fields: [
        {
          bits: "5+3:5", // 2 bits for status
          name: "CL_STATUS",
          desc: "Contain the current status of the corresponding cache line                [0]: valid, [1]: dirty, [2]: cmpt",
        }
      ]
    },
    { name:     "TAG_890",
      desc:     "Tag Address stored in cache line 890",
      swaccess: "rw",
      hwaccess: "hrw",
      hwext:    "true",
      hwqe:     "true", // enable `qe` latched signal of software write pulse
      hwre:     "true",
      fields: [
        { bits: "5-1:0",
          name: "CL_TAG",
          desc: "Tag Address"
        }
      ]
    },
    {
      name:     "STATUS_891",
      desc:     "Status register of cache line 891",
      swaccess: "rw",
      hwaccess: "hrw",
      hwext:    "true",
      hwqe:     "true", // enable `qe` latched signal of software write pulse
      hwre:     "true",
      fields: [
        {
          bits: "5+3:5", // 2 bits for status
          name: "CL_STATUS",
          desc: "Contain the current status of the corresponding cache line                [0]: valid, [1]: dirty, [2]: cmpt",
        }
      ]
    },
    { name:     "TAG_891",
      desc:     "Tag Address stored in cache line 891",
      swaccess: "rw",
      hwaccess: "hrw",
      hwext:    "true",
      hwqe:     "true", // enable `qe` latched signal of software write pulse
      hwre:     "true",
      fields: [
        { bits: "5-1:0",
          name: "CL_TAG",
          desc: "Tag Address"
        }
      ]
    },
    {
      name:     "STATUS_892",
      desc:     "Status register of cache line 892",
      swaccess: "rw",
      hwaccess: "hrw",
      hwext:    "true",
      hwqe:     "true", // enable `qe` latched signal of software write pulse
      hwre:     "true",
      fields: [
        {
          bits: "5+3:5", // 2 bits for status
          name: "CL_STATUS",
          desc: "Contain the current status of the corresponding cache line                [0]: valid, [1]: dirty, [2]: cmpt",
        }
      ]
    },
    { name:     "TAG_892",
      desc:     "Tag Address stored in cache line 892",
      swaccess: "rw",
      hwaccess: "hrw",
      hwext:    "true",
      hwqe:     "true", // enable `qe` latched signal of software write pulse
      hwre:     "true",
      fields: [
        { bits: "5-1:0",
          name: "CL_TAG",
          desc: "Tag Address"
        }
      ]
    },
    {
      name:     "STATUS_893",
      desc:     "Status register of cache line 893",
      swaccess: "rw",
      hwaccess: "hrw",
      hwext:    "true",
      hwqe:     "true", // enable `qe` latched signal of software write pulse
      hwre:     "true",
      fields: [
        {
          bits: "5+3:5", // 2 bits for status
          name: "CL_STATUS",
          desc: "Contain the current status of the corresponding cache line                [0]: valid, [1]: dirty, [2]: cmpt",
        }
      ]
    },
    { name:     "TAG_893",
      desc:     "Tag Address stored in cache line 893",
      swaccess: "rw",
      hwaccess: "hrw",
      hwext:    "true",
      hwqe:     "true", // enable `qe` latched signal of software write pulse
      hwre:     "true",
      fields: [
        { bits: "5-1:0",
          name: "CL_TAG",
          desc: "Tag Address"
        }
      ]
    },
    {
      name:     "STATUS_894",
      desc:     "Status register of cache line 894",
      swaccess: "rw",
      hwaccess: "hrw",
      hwext:    "true",
      hwqe:     "true", // enable `qe` latched signal of software write pulse
      hwre:     "true",
      fields: [
        {
          bits: "5+3:5", // 2 bits for status
          name: "CL_STATUS",
          desc: "Contain the current status of the corresponding cache line                [0]: valid, [1]: dirty, [2]: cmpt",
        }
      ]
    },
    { name:     "TAG_894",
      desc:     "Tag Address stored in cache line 894",
      swaccess: "rw",
      hwaccess: "hrw",
      hwext:    "true",
      hwqe:     "true", // enable `qe` latched signal of software write pulse
      hwre:     "true",
      fields: [
        { bits: "5-1:0",
          name: "CL_TAG",
          desc: "Tag Address"
        }
      ]
    },
    {
      name:     "STATUS_895",
      desc:     "Status register of cache line 895",
      swaccess: "rw",
      hwaccess: "hrw",
      hwext:    "true",
      hwqe:     "true", // enable `qe` latched signal of software write pulse
      hwre:     "true",
      fields: [
        {
          bits: "5+3:5", // 2 bits for status
          name: "CL_STATUS",
          desc: "Contain the current status of the corresponding cache line                [0]: valid, [1]: dirty, [2]: cmpt",
        }
      ]
    },
    { name:     "TAG_895",
      desc:     "Tag Address stored in cache line 895",
      swaccess: "rw",
      hwaccess: "hrw",
      hwext:    "true",
      hwqe:     "true", // enable `qe` latched signal of software write pulse
      hwre:     "true",
      fields: [
        { bits: "5-1:0",
          name: "CL_TAG",
          desc: "Tag Address"
        }
      ]
    },
    {
      name:     "STATUS_896",
      desc:     "Status register of cache line 896",
      swaccess: "rw",
      hwaccess: "hrw",
      hwext:    "true",
      hwqe:     "true", // enable `qe` latched signal of software write pulse
      hwre:     "true",
      fields: [
        {
          bits: "5+3:5", // 2 bits for status
          name: "CL_STATUS",
          desc: "Contain the current status of the corresponding cache line                [0]: valid, [1]: dirty, [2]: cmpt",
        }
      ]
    },
    { name:     "TAG_896",
      desc:     "Tag Address stored in cache line 896",
      swaccess: "rw",
      hwaccess: "hrw",
      hwext:    "true",
      hwqe:     "true", // enable `qe` latched signal of software write pulse
      hwre:     "true",
      fields: [
        { bits: "5-1:0",
          name: "CL_TAG",
          desc: "Tag Address"
        }
      ]
    },
    {
      name:     "STATUS_897",
      desc:     "Status register of cache line 897",
      swaccess: "rw",
      hwaccess: "hrw",
      hwext:    "true",
      hwqe:     "true", // enable `qe` latched signal of software write pulse
      hwre:     "true",
      fields: [
        {
          bits: "5+3:5", // 2 bits for status
          name: "CL_STATUS",
          desc: "Contain the current status of the corresponding cache line                [0]: valid, [1]: dirty, [2]: cmpt",
        }
      ]
    },
    { name:     "TAG_897",
      desc:     "Tag Address stored in cache line 897",
      swaccess: "rw",
      hwaccess: "hrw",
      hwext:    "true",
      hwqe:     "true", // enable `qe` latched signal of software write pulse
      hwre:     "true",
      fields: [
        { bits: "5-1:0",
          name: "CL_TAG",
          desc: "Tag Address"
        }
      ]
    },
    {
      name:     "STATUS_898",
      desc:     "Status register of cache line 898",
      swaccess: "rw",
      hwaccess: "hrw",
      hwext:    "true",
      hwqe:     "true", // enable `qe` latched signal of software write pulse
      hwre:     "true",
      fields: [
        {
          bits: "5+3:5", // 2 bits for status
          name: "CL_STATUS",
          desc: "Contain the current status of the corresponding cache line                [0]: valid, [1]: dirty, [2]: cmpt",
        }
      ]
    },
    { name:     "TAG_898",
      desc:     "Tag Address stored in cache line 898",
      swaccess: "rw",
      hwaccess: "hrw",
      hwext:    "true",
      hwqe:     "true", // enable `qe` latched signal of software write pulse
      hwre:     "true",
      fields: [
        { bits: "5-1:0",
          name: "CL_TAG",
          desc: "Tag Address"
        }
      ]
    },
    {
      name:     "STATUS_899",
      desc:     "Status register of cache line 899",
      swaccess: "rw",
      hwaccess: "hrw",
      hwext:    "true",
      hwqe:     "true", // enable `qe` latched signal of software write pulse
      hwre:     "true",
      fields: [
        {
          bits: "5+3:5", // 2 bits for status
          name: "CL_STATUS",
          desc: "Contain the current status of the corresponding cache line                [0]: valid, [1]: dirty, [2]: cmpt",
        }
      ]
    },
    { name:     "TAG_899",
      desc:     "Tag Address stored in cache line 899",
      swaccess: "rw",
      hwaccess: "hrw",
      hwext:    "true",
      hwqe:     "true", // enable `qe` latched signal of software write pulse
      hwre:     "true",
      fields: [
        { bits: "5-1:0",
          name: "CL_TAG",
          desc: "Tag Address"
        }
      ]
    },
    {
      name:     "STATUS_900",
      desc:     "Status register of cache line 900",
      swaccess: "rw",
      hwaccess: "hrw",
      hwext:    "true",
      hwqe:     "true", // enable `qe` latched signal of software write pulse
      hwre:     "true",
      fields: [
        {
          bits: "5+3:5", // 2 bits for status
          name: "CL_STATUS",
          desc: "Contain the current status of the corresponding cache line                [0]: valid, [1]: dirty, [2]: cmpt",
        }
      ]
    },
    { name:     "TAG_900",
      desc:     "Tag Address stored in cache line 900",
      swaccess: "rw",
      hwaccess: "hrw",
      hwext:    "true",
      hwqe:     "true", // enable `qe` latched signal of software write pulse
      hwre:     "true",
      fields: [
        { bits: "5-1:0",
          name: "CL_TAG",
          desc: "Tag Address"
        }
      ]
    },
    {
      name:     "STATUS_901",
      desc:     "Status register of cache line 901",
      swaccess: "rw",
      hwaccess: "hrw",
      hwext:    "true",
      hwqe:     "true", // enable `qe` latched signal of software write pulse
      hwre:     "true",
      fields: [
        {
          bits: "5+3:5", // 2 bits for status
          name: "CL_STATUS",
          desc: "Contain the current status of the corresponding cache line                [0]: valid, [1]: dirty, [2]: cmpt",
        }
      ]
    },
    { name:     "TAG_901",
      desc:     "Tag Address stored in cache line 901",
      swaccess: "rw",
      hwaccess: "hrw",
      hwext:    "true",
      hwqe:     "true", // enable `qe` latched signal of software write pulse
      hwre:     "true",
      fields: [
        { bits: "5-1:0",
          name: "CL_TAG",
          desc: "Tag Address"
        }
      ]
    },
    {
      name:     "STATUS_902",
      desc:     "Status register of cache line 902",
      swaccess: "rw",
      hwaccess: "hrw",
      hwext:    "true",
      hwqe:     "true", // enable `qe` latched signal of software write pulse
      hwre:     "true",
      fields: [
        {
          bits: "5+3:5", // 2 bits for status
          name: "CL_STATUS",
          desc: "Contain the current status of the corresponding cache line                [0]: valid, [1]: dirty, [2]: cmpt",
        }
      ]
    },
    { name:     "TAG_902",
      desc:     "Tag Address stored in cache line 902",
      swaccess: "rw",
      hwaccess: "hrw",
      hwext:    "true",
      hwqe:     "true", // enable `qe` latched signal of software write pulse
      hwre:     "true",
      fields: [
        { bits: "5-1:0",
          name: "CL_TAG",
          desc: "Tag Address"
        }
      ]
    },
    {
      name:     "STATUS_903",
      desc:     "Status register of cache line 903",
      swaccess: "rw",
      hwaccess: "hrw",
      hwext:    "true",
      hwqe:     "true", // enable `qe` latched signal of software write pulse
      hwre:     "true",
      fields: [
        {
          bits: "5+3:5", // 2 bits for status
          name: "CL_STATUS",
          desc: "Contain the current status of the corresponding cache line                [0]: valid, [1]: dirty, [2]: cmpt",
        }
      ]
    },
    { name:     "TAG_903",
      desc:     "Tag Address stored in cache line 903",
      swaccess: "rw",
      hwaccess: "hrw",
      hwext:    "true",
      hwqe:     "true", // enable `qe` latched signal of software write pulse
      hwre:     "true",
      fields: [
        { bits: "5-1:0",
          name: "CL_TAG",
          desc: "Tag Address"
        }
      ]
    },
    {
      name:     "STATUS_904",
      desc:     "Status register of cache line 904",
      swaccess: "rw",
      hwaccess: "hrw",
      hwext:    "true",
      hwqe:     "true", // enable `qe` latched signal of software write pulse
      hwre:     "true",
      fields: [
        {
          bits: "5+3:5", // 2 bits for status
          name: "CL_STATUS",
          desc: "Contain the current status of the corresponding cache line                [0]: valid, [1]: dirty, [2]: cmpt",
        }
      ]
    },
    { name:     "TAG_904",
      desc:     "Tag Address stored in cache line 904",
      swaccess: "rw",
      hwaccess: "hrw",
      hwext:    "true",
      hwqe:     "true", // enable `qe` latched signal of software write pulse
      hwre:     "true",
      fields: [
        { bits: "5-1:0",
          name: "CL_TAG",
          desc: "Tag Address"
        }
      ]
    },
    {
      name:     "STATUS_905",
      desc:     "Status register of cache line 905",
      swaccess: "rw",
      hwaccess: "hrw",
      hwext:    "true",
      hwqe:     "true", // enable `qe` latched signal of software write pulse
      hwre:     "true",
      fields: [
        {
          bits: "5+3:5", // 2 bits for status
          name: "CL_STATUS",
          desc: "Contain the current status of the corresponding cache line                [0]: valid, [1]: dirty, [2]: cmpt",
        }
      ]
    },
    { name:     "TAG_905",
      desc:     "Tag Address stored in cache line 905",
      swaccess: "rw",
      hwaccess: "hrw",
      hwext:    "true",
      hwqe:     "true", // enable `qe` latched signal of software write pulse
      hwre:     "true",
      fields: [
        { bits: "5-1:0",
          name: "CL_TAG",
          desc: "Tag Address"
        }
      ]
    },
    {
      name:     "STATUS_906",
      desc:     "Status register of cache line 906",
      swaccess: "rw",
      hwaccess: "hrw",
      hwext:    "true",
      hwqe:     "true", // enable `qe` latched signal of software write pulse
      hwre:     "true",
      fields: [
        {
          bits: "5+3:5", // 2 bits for status
          name: "CL_STATUS",
          desc: "Contain the current status of the corresponding cache line                [0]: valid, [1]: dirty, [2]: cmpt",
        }
      ]
    },
    { name:     "TAG_906",
      desc:     "Tag Address stored in cache line 906",
      swaccess: "rw",
      hwaccess: "hrw",
      hwext:    "true",
      hwqe:     "true", // enable `qe` latched signal of software write pulse
      hwre:     "true",
      fields: [
        { bits: "5-1:0",
          name: "CL_TAG",
          desc: "Tag Address"
        }
      ]
    },
    {
      name:     "STATUS_907",
      desc:     "Status register of cache line 907",
      swaccess: "rw",
      hwaccess: "hrw",
      hwext:    "true",
      hwqe:     "true", // enable `qe` latched signal of software write pulse
      hwre:     "true",
      fields: [
        {
          bits: "5+3:5", // 2 bits for status
          name: "CL_STATUS",
          desc: "Contain the current status of the corresponding cache line                [0]: valid, [1]: dirty, [2]: cmpt",
        }
      ]
    },
    { name:     "TAG_907",
      desc:     "Tag Address stored in cache line 907",
      swaccess: "rw",
      hwaccess: "hrw",
      hwext:    "true",
      hwqe:     "true", // enable `qe` latched signal of software write pulse
      hwre:     "true",
      fields: [
        { bits: "5-1:0",
          name: "CL_TAG",
          desc: "Tag Address"
        }
      ]
    },
    {
      name:     "STATUS_908",
      desc:     "Status register of cache line 908",
      swaccess: "rw",
      hwaccess: "hrw",
      hwext:    "true",
      hwqe:     "true", // enable `qe` latched signal of software write pulse
      hwre:     "true",
      fields: [
        {
          bits: "5+3:5", // 2 bits for status
          name: "CL_STATUS",
          desc: "Contain the current status of the corresponding cache line                [0]: valid, [1]: dirty, [2]: cmpt",
        }
      ]
    },
    { name:     "TAG_908",
      desc:     "Tag Address stored in cache line 908",
      swaccess: "rw",
      hwaccess: "hrw",
      hwext:    "true",
      hwqe:     "true", // enable `qe` latched signal of software write pulse
      hwre:     "true",
      fields: [
        { bits: "5-1:0",
          name: "CL_TAG",
          desc: "Tag Address"
        }
      ]
    },
    {
      name:     "STATUS_909",
      desc:     "Status register of cache line 909",
      swaccess: "rw",
      hwaccess: "hrw",
      hwext:    "true",
      hwqe:     "true", // enable `qe` latched signal of software write pulse
      hwre:     "true",
      fields: [
        {
          bits: "5+3:5", // 2 bits for status
          name: "CL_STATUS",
          desc: "Contain the current status of the corresponding cache line                [0]: valid, [1]: dirty, [2]: cmpt",
        }
      ]
    },
    { name:     "TAG_909",
      desc:     "Tag Address stored in cache line 909",
      swaccess: "rw",
      hwaccess: "hrw",
      hwext:    "true",
      hwqe:     "true", // enable `qe` latched signal of software write pulse
      hwre:     "true",
      fields: [
        { bits: "5-1:0",
          name: "CL_TAG",
          desc: "Tag Address"
        }
      ]
    },
    {
      name:     "STATUS_910",
      desc:     "Status register of cache line 910",
      swaccess: "rw",
      hwaccess: "hrw",
      hwext:    "true",
      hwqe:     "true", // enable `qe` latched signal of software write pulse
      hwre:     "true",
      fields: [
        {
          bits: "5+3:5", // 2 bits for status
          name: "CL_STATUS",
          desc: "Contain the current status of the corresponding cache line                [0]: valid, [1]: dirty, [2]: cmpt",
        }
      ]
    },
    { name:     "TAG_910",
      desc:     "Tag Address stored in cache line 910",
      swaccess: "rw",
      hwaccess: "hrw",
      hwext:    "true",
      hwqe:     "true", // enable `qe` latched signal of software write pulse
      hwre:     "true",
      fields: [
        { bits: "5-1:0",
          name: "CL_TAG",
          desc: "Tag Address"
        }
      ]
    },
    {
      name:     "STATUS_911",
      desc:     "Status register of cache line 911",
      swaccess: "rw",
      hwaccess: "hrw",
      hwext:    "true",
      hwqe:     "true", // enable `qe` latched signal of software write pulse
      hwre:     "true",
      fields: [
        {
          bits: "5+3:5", // 2 bits for status
          name: "CL_STATUS",
          desc: "Contain the current status of the corresponding cache line                [0]: valid, [1]: dirty, [2]: cmpt",
        }
      ]
    },
    { name:     "TAG_911",
      desc:     "Tag Address stored in cache line 911",
      swaccess: "rw",
      hwaccess: "hrw",
      hwext:    "true",
      hwqe:     "true", // enable `qe` latched signal of software write pulse
      hwre:     "true",
      fields: [
        { bits: "5-1:0",
          name: "CL_TAG",
          desc: "Tag Address"
        }
      ]
    },
    {
      name:     "STATUS_912",
      desc:     "Status register of cache line 912",
      swaccess: "rw",
      hwaccess: "hrw",
      hwext:    "true",
      hwqe:     "true", // enable `qe` latched signal of software write pulse
      hwre:     "true",
      fields: [
        {
          bits: "5+3:5", // 2 bits for status
          name: "CL_STATUS",
          desc: "Contain the current status of the corresponding cache line                [0]: valid, [1]: dirty, [2]: cmpt",
        }
      ]
    },
    { name:     "TAG_912",
      desc:     "Tag Address stored in cache line 912",
      swaccess: "rw",
      hwaccess: "hrw",
      hwext:    "true",
      hwqe:     "true", // enable `qe` latched signal of software write pulse
      hwre:     "true",
      fields: [
        { bits: "5-1:0",
          name: "CL_TAG",
          desc: "Tag Address"
        }
      ]
    },
    {
      name:     "STATUS_913",
      desc:     "Status register of cache line 913",
      swaccess: "rw",
      hwaccess: "hrw",
      hwext:    "true",
      hwqe:     "true", // enable `qe` latched signal of software write pulse
      hwre:     "true",
      fields: [
        {
          bits: "5+3:5", // 2 bits for status
          name: "CL_STATUS",
          desc: "Contain the current status of the corresponding cache line                [0]: valid, [1]: dirty, [2]: cmpt",
        }
      ]
    },
    { name:     "TAG_913",
      desc:     "Tag Address stored in cache line 913",
      swaccess: "rw",
      hwaccess: "hrw",
      hwext:    "true",
      hwqe:     "true", // enable `qe` latched signal of software write pulse
      hwre:     "true",
      fields: [
        { bits: "5-1:0",
          name: "CL_TAG",
          desc: "Tag Address"
        }
      ]
    },
    {
      name:     "STATUS_914",
      desc:     "Status register of cache line 914",
      swaccess: "rw",
      hwaccess: "hrw",
      hwext:    "true",
      hwqe:     "true", // enable `qe` latched signal of software write pulse
      hwre:     "true",
      fields: [
        {
          bits: "5+3:5", // 2 bits for status
          name: "CL_STATUS",
          desc: "Contain the current status of the corresponding cache line                [0]: valid, [1]: dirty, [2]: cmpt",
        }
      ]
    },
    { name:     "TAG_914",
      desc:     "Tag Address stored in cache line 914",
      swaccess: "rw",
      hwaccess: "hrw",
      hwext:    "true",
      hwqe:     "true", // enable `qe` latched signal of software write pulse
      hwre:     "true",
      fields: [
        { bits: "5-1:0",
          name: "CL_TAG",
          desc: "Tag Address"
        }
      ]
    },
    {
      name:     "STATUS_915",
      desc:     "Status register of cache line 915",
      swaccess: "rw",
      hwaccess: "hrw",
      hwext:    "true",
      hwqe:     "true", // enable `qe` latched signal of software write pulse
      hwre:     "true",
      fields: [
        {
          bits: "5+3:5", // 2 bits for status
          name: "CL_STATUS",
          desc: "Contain the current status of the corresponding cache line                [0]: valid, [1]: dirty, [2]: cmpt",
        }
      ]
    },
    { name:     "TAG_915",
      desc:     "Tag Address stored in cache line 915",
      swaccess: "rw",
      hwaccess: "hrw",
      hwext:    "true",
      hwqe:     "true", // enable `qe` latched signal of software write pulse
      hwre:     "true",
      fields: [
        { bits: "5-1:0",
          name: "CL_TAG",
          desc: "Tag Address"
        }
      ]
    },
    {
      name:     "STATUS_916",
      desc:     "Status register of cache line 916",
      swaccess: "rw",
      hwaccess: "hrw",
      hwext:    "true",
      hwqe:     "true", // enable `qe` latched signal of software write pulse
      hwre:     "true",
      fields: [
        {
          bits: "5+3:5", // 2 bits for status
          name: "CL_STATUS",
          desc: "Contain the current status of the corresponding cache line                [0]: valid, [1]: dirty, [2]: cmpt",
        }
      ]
    },
    { name:     "TAG_916",
      desc:     "Tag Address stored in cache line 916",
      swaccess: "rw",
      hwaccess: "hrw",
      hwext:    "true",
      hwqe:     "true", // enable `qe` latched signal of software write pulse
      hwre:     "true",
      fields: [
        { bits: "5-1:0",
          name: "CL_TAG",
          desc: "Tag Address"
        }
      ]
    },
    {
      name:     "STATUS_917",
      desc:     "Status register of cache line 917",
      swaccess: "rw",
      hwaccess: "hrw",
      hwext:    "true",
      hwqe:     "true", // enable `qe` latched signal of software write pulse
      hwre:     "true",
      fields: [
        {
          bits: "5+3:5", // 2 bits for status
          name: "CL_STATUS",
          desc: "Contain the current status of the corresponding cache line                [0]: valid, [1]: dirty, [2]: cmpt",
        }
      ]
    },
    { name:     "TAG_917",
      desc:     "Tag Address stored in cache line 917",
      swaccess: "rw",
      hwaccess: "hrw",
      hwext:    "true",
      hwqe:     "true", // enable `qe` latched signal of software write pulse
      hwre:     "true",
      fields: [
        { bits: "5-1:0",
          name: "CL_TAG",
          desc: "Tag Address"
        }
      ]
    },
    {
      name:     "STATUS_918",
      desc:     "Status register of cache line 918",
      swaccess: "rw",
      hwaccess: "hrw",
      hwext:    "true",
      hwqe:     "true", // enable `qe` latched signal of software write pulse
      hwre:     "true",
      fields: [
        {
          bits: "5+3:5", // 2 bits for status
          name: "CL_STATUS",
          desc: "Contain the current status of the corresponding cache line                [0]: valid, [1]: dirty, [2]: cmpt",
        }
      ]
    },
    { name:     "TAG_918",
      desc:     "Tag Address stored in cache line 918",
      swaccess: "rw",
      hwaccess: "hrw",
      hwext:    "true",
      hwqe:     "true", // enable `qe` latched signal of software write pulse
      hwre:     "true",
      fields: [
        { bits: "5-1:0",
          name: "CL_TAG",
          desc: "Tag Address"
        }
      ]
    },
    {
      name:     "STATUS_919",
      desc:     "Status register of cache line 919",
      swaccess: "rw",
      hwaccess: "hrw",
      hwext:    "true",
      hwqe:     "true", // enable `qe` latched signal of software write pulse
      hwre:     "true",
      fields: [
        {
          bits: "5+3:5", // 2 bits for status
          name: "CL_STATUS",
          desc: "Contain the current status of the corresponding cache line                [0]: valid, [1]: dirty, [2]: cmpt",
        }
      ]
    },
    { name:     "TAG_919",
      desc:     "Tag Address stored in cache line 919",
      swaccess: "rw",
      hwaccess: "hrw",
      hwext:    "true",
      hwqe:     "true", // enable `qe` latched signal of software write pulse
      hwre:     "true",
      fields: [
        { bits: "5-1:0",
          name: "CL_TAG",
          desc: "Tag Address"
        }
      ]
    },
    {
      name:     "STATUS_920",
      desc:     "Status register of cache line 920",
      swaccess: "rw",
      hwaccess: "hrw",
      hwext:    "true",
      hwqe:     "true", // enable `qe` latched signal of software write pulse
      hwre:     "true",
      fields: [
        {
          bits: "5+3:5", // 2 bits for status
          name: "CL_STATUS",
          desc: "Contain the current status of the corresponding cache line                [0]: valid, [1]: dirty, [2]: cmpt",
        }
      ]
    },
    { name:     "TAG_920",
      desc:     "Tag Address stored in cache line 920",
      swaccess: "rw",
      hwaccess: "hrw",
      hwext:    "true",
      hwqe:     "true", // enable `qe` latched signal of software write pulse
      hwre:     "true",
      fields: [
        { bits: "5-1:0",
          name: "CL_TAG",
          desc: "Tag Address"
        }
      ]
    },
    {
      name:     "STATUS_921",
      desc:     "Status register of cache line 921",
      swaccess: "rw",
      hwaccess: "hrw",
      hwext:    "true",
      hwqe:     "true", // enable `qe` latched signal of software write pulse
      hwre:     "true",
      fields: [
        {
          bits: "5+3:5", // 2 bits for status
          name: "CL_STATUS",
          desc: "Contain the current status of the corresponding cache line                [0]: valid, [1]: dirty, [2]: cmpt",
        }
      ]
    },
    { name:     "TAG_921",
      desc:     "Tag Address stored in cache line 921",
      swaccess: "rw",
      hwaccess: "hrw",
      hwext:    "true",
      hwqe:     "true", // enable `qe` latched signal of software write pulse
      hwre:     "true",
      fields: [
        { bits: "5-1:0",
          name: "CL_TAG",
          desc: "Tag Address"
        }
      ]
    },
    {
      name:     "STATUS_922",
      desc:     "Status register of cache line 922",
      swaccess: "rw",
      hwaccess: "hrw",
      hwext:    "true",
      hwqe:     "true", // enable `qe` latched signal of software write pulse
      hwre:     "true",
      fields: [
        {
          bits: "5+3:5", // 2 bits for status
          name: "CL_STATUS",
          desc: "Contain the current status of the corresponding cache line                [0]: valid, [1]: dirty, [2]: cmpt",
        }
      ]
    },
    { name:     "TAG_922",
      desc:     "Tag Address stored in cache line 922",
      swaccess: "rw",
      hwaccess: "hrw",
      hwext:    "true",
      hwqe:     "true", // enable `qe` latched signal of software write pulse
      hwre:     "true",
      fields: [
        { bits: "5-1:0",
          name: "CL_TAG",
          desc: "Tag Address"
        }
      ]
    },
    {
      name:     "STATUS_923",
      desc:     "Status register of cache line 923",
      swaccess: "rw",
      hwaccess: "hrw",
      hwext:    "true",
      hwqe:     "true", // enable `qe` latched signal of software write pulse
      hwre:     "true",
      fields: [
        {
          bits: "5+3:5", // 2 bits for status
          name: "CL_STATUS",
          desc: "Contain the current status of the corresponding cache line                [0]: valid, [1]: dirty, [2]: cmpt",
        }
      ]
    },
    { name:     "TAG_923",
      desc:     "Tag Address stored in cache line 923",
      swaccess: "rw",
      hwaccess: "hrw",
      hwext:    "true",
      hwqe:     "true", // enable `qe` latched signal of software write pulse
      hwre:     "true",
      fields: [
        { bits: "5-1:0",
          name: "CL_TAG",
          desc: "Tag Address"
        }
      ]
    },
    {
      name:     "STATUS_924",
      desc:     "Status register of cache line 924",
      swaccess: "rw",
      hwaccess: "hrw",
      hwext:    "true",
      hwqe:     "true", // enable `qe` latched signal of software write pulse
      hwre:     "true",
      fields: [
        {
          bits: "5+3:5", // 2 bits for status
          name: "CL_STATUS",
          desc: "Contain the current status of the corresponding cache line                [0]: valid, [1]: dirty, [2]: cmpt",
        }
      ]
    },
    { name:     "TAG_924",
      desc:     "Tag Address stored in cache line 924",
      swaccess: "rw",
      hwaccess: "hrw",
      hwext:    "true",
      hwqe:     "true", // enable `qe` latched signal of software write pulse
      hwre:     "true",
      fields: [
        { bits: "5-1:0",
          name: "CL_TAG",
          desc: "Tag Address"
        }
      ]
    },
    {
      name:     "STATUS_925",
      desc:     "Status register of cache line 925",
      swaccess: "rw",
      hwaccess: "hrw",
      hwext:    "true",
      hwqe:     "true", // enable `qe` latched signal of software write pulse
      hwre:     "true",
      fields: [
        {
          bits: "5+3:5", // 2 bits for status
          name: "CL_STATUS",
          desc: "Contain the current status of the corresponding cache line                [0]: valid, [1]: dirty, [2]: cmpt",
        }
      ]
    },
    { name:     "TAG_925",
      desc:     "Tag Address stored in cache line 925",
      swaccess: "rw",
      hwaccess: "hrw",
      hwext:    "true",
      hwqe:     "true", // enable `qe` latched signal of software write pulse
      hwre:     "true",
      fields: [
        { bits: "5-1:0",
          name: "CL_TAG",
          desc: "Tag Address"
        }
      ]
    },
    {
      name:     "STATUS_926",
      desc:     "Status register of cache line 926",
      swaccess: "rw",
      hwaccess: "hrw",
      hwext:    "true",
      hwqe:     "true", // enable `qe` latched signal of software write pulse
      hwre:     "true",
      fields: [
        {
          bits: "5+3:5", // 2 bits for status
          name: "CL_STATUS",
          desc: "Contain the current status of the corresponding cache line                [0]: valid, [1]: dirty, [2]: cmpt",
        }
      ]
    },
    { name:     "TAG_926",
      desc:     "Tag Address stored in cache line 926",
      swaccess: "rw",
      hwaccess: "hrw",
      hwext:    "true",
      hwqe:     "true", // enable `qe` latched signal of software write pulse
      hwre:     "true",
      fields: [
        { bits: "5-1:0",
          name: "CL_TAG",
          desc: "Tag Address"
        }
      ]
    },
    {
      name:     "STATUS_927",
      desc:     "Status register of cache line 927",
      swaccess: "rw",
      hwaccess: "hrw",
      hwext:    "true",
      hwqe:     "true", // enable `qe` latched signal of software write pulse
      hwre:     "true",
      fields: [
        {
          bits: "5+3:5", // 2 bits for status
          name: "CL_STATUS",
          desc: "Contain the current status of the corresponding cache line                [0]: valid, [1]: dirty, [2]: cmpt",
        }
      ]
    },
    { name:     "TAG_927",
      desc:     "Tag Address stored in cache line 927",
      swaccess: "rw",
      hwaccess: "hrw",
      hwext:    "true",
      hwqe:     "true", // enable `qe` latched signal of software write pulse
      hwre:     "true",
      fields: [
        { bits: "5-1:0",
          name: "CL_TAG",
          desc: "Tag Address"
        }
      ]
    },
    {
      name:     "STATUS_928",
      desc:     "Status register of cache line 928",
      swaccess: "rw",
      hwaccess: "hrw",
      hwext:    "true",
      hwqe:     "true", // enable `qe` latched signal of software write pulse
      hwre:     "true",
      fields: [
        {
          bits: "5+3:5", // 2 bits for status
          name: "CL_STATUS",
          desc: "Contain the current status of the corresponding cache line                [0]: valid, [1]: dirty, [2]: cmpt",
        }
      ]
    },
    { name:     "TAG_928",
      desc:     "Tag Address stored in cache line 928",
      swaccess: "rw",
      hwaccess: "hrw",
      hwext:    "true",
      hwqe:     "true", // enable `qe` latched signal of software write pulse
      hwre:     "true",
      fields: [
        { bits: "5-1:0",
          name: "CL_TAG",
          desc: "Tag Address"
        }
      ]
    },
    {
      name:     "STATUS_929",
      desc:     "Status register of cache line 929",
      swaccess: "rw",
      hwaccess: "hrw",
      hwext:    "true",
      hwqe:     "true", // enable `qe` latched signal of software write pulse
      hwre:     "true",
      fields: [
        {
          bits: "5+3:5", // 2 bits for status
          name: "CL_STATUS",
          desc: "Contain the current status of the corresponding cache line                [0]: valid, [1]: dirty, [2]: cmpt",
        }
      ]
    },
    { name:     "TAG_929",
      desc:     "Tag Address stored in cache line 929",
      swaccess: "rw",
      hwaccess: "hrw",
      hwext:    "true",
      hwqe:     "true", // enable `qe` latched signal of software write pulse
      hwre:     "true",
      fields: [
        { bits: "5-1:0",
          name: "CL_TAG",
          desc: "Tag Address"
        }
      ]
    },
    {
      name:     "STATUS_930",
      desc:     "Status register of cache line 930",
      swaccess: "rw",
      hwaccess: "hrw",
      hwext:    "true",
      hwqe:     "true", // enable `qe` latched signal of software write pulse
      hwre:     "true",
      fields: [
        {
          bits: "5+3:5", // 2 bits for status
          name: "CL_STATUS",
          desc: "Contain the current status of the corresponding cache line                [0]: valid, [1]: dirty, [2]: cmpt",
        }
      ]
    },
    { name:     "TAG_930",
      desc:     "Tag Address stored in cache line 930",
      swaccess: "rw",
      hwaccess: "hrw",
      hwext:    "true",
      hwqe:     "true", // enable `qe` latched signal of software write pulse
      hwre:     "true",
      fields: [
        { bits: "5-1:0",
          name: "CL_TAG",
          desc: "Tag Address"
        }
      ]
    },
    {
      name:     "STATUS_931",
      desc:     "Status register of cache line 931",
      swaccess: "rw",
      hwaccess: "hrw",
      hwext:    "true",
      hwqe:     "true", // enable `qe` latched signal of software write pulse
      hwre:     "true",
      fields: [
        {
          bits: "5+3:5", // 2 bits for status
          name: "CL_STATUS",
          desc: "Contain the current status of the corresponding cache line                [0]: valid, [1]: dirty, [2]: cmpt",
        }
      ]
    },
    { name:     "TAG_931",
      desc:     "Tag Address stored in cache line 931",
      swaccess: "rw",
      hwaccess: "hrw",
      hwext:    "true",
      hwqe:     "true", // enable `qe` latched signal of software write pulse
      hwre:     "true",
      fields: [
        { bits: "5-1:0",
          name: "CL_TAG",
          desc: "Tag Address"
        }
      ]
    },
    {
      name:     "STATUS_932",
      desc:     "Status register of cache line 932",
      swaccess: "rw",
      hwaccess: "hrw",
      hwext:    "true",
      hwqe:     "true", // enable `qe` latched signal of software write pulse
      hwre:     "true",
      fields: [
        {
          bits: "5+3:5", // 2 bits for status
          name: "CL_STATUS",
          desc: "Contain the current status of the corresponding cache line                [0]: valid, [1]: dirty, [2]: cmpt",
        }
      ]
    },
    { name:     "TAG_932",
      desc:     "Tag Address stored in cache line 932",
      swaccess: "rw",
      hwaccess: "hrw",
      hwext:    "true",
      hwqe:     "true", // enable `qe` latched signal of software write pulse
      hwre:     "true",
      fields: [
        { bits: "5-1:0",
          name: "CL_TAG",
          desc: "Tag Address"
        }
      ]
    },
    {
      name:     "STATUS_933",
      desc:     "Status register of cache line 933",
      swaccess: "rw",
      hwaccess: "hrw",
      hwext:    "true",
      hwqe:     "true", // enable `qe` latched signal of software write pulse
      hwre:     "true",
      fields: [
        {
          bits: "5+3:5", // 2 bits for status
          name: "CL_STATUS",
          desc: "Contain the current status of the corresponding cache line                [0]: valid, [1]: dirty, [2]: cmpt",
        }
      ]
    },
    { name:     "TAG_933",
      desc:     "Tag Address stored in cache line 933",
      swaccess: "rw",
      hwaccess: "hrw",
      hwext:    "true",
      hwqe:     "true", // enable `qe` latched signal of software write pulse
      hwre:     "true",
      fields: [
        { bits: "5-1:0",
          name: "CL_TAG",
          desc: "Tag Address"
        }
      ]
    },
    {
      name:     "STATUS_934",
      desc:     "Status register of cache line 934",
      swaccess: "rw",
      hwaccess: "hrw",
      hwext:    "true",
      hwqe:     "true", // enable `qe` latched signal of software write pulse
      hwre:     "true",
      fields: [
        {
          bits: "5+3:5", // 2 bits for status
          name: "CL_STATUS",
          desc: "Contain the current status of the corresponding cache line                [0]: valid, [1]: dirty, [2]: cmpt",
        }
      ]
    },
    { name:     "TAG_934",
      desc:     "Tag Address stored in cache line 934",
      swaccess: "rw",
      hwaccess: "hrw",
      hwext:    "true",
      hwqe:     "true", // enable `qe` latched signal of software write pulse
      hwre:     "true",
      fields: [
        { bits: "5-1:0",
          name: "CL_TAG",
          desc: "Tag Address"
        }
      ]
    },
    {
      name:     "STATUS_935",
      desc:     "Status register of cache line 935",
      swaccess: "rw",
      hwaccess: "hrw",
      hwext:    "true",
      hwqe:     "true", // enable `qe` latched signal of software write pulse
      hwre:     "true",
      fields: [
        {
          bits: "5+3:5", // 2 bits for status
          name: "CL_STATUS",
          desc: "Contain the current status of the corresponding cache line                [0]: valid, [1]: dirty, [2]: cmpt",
        }
      ]
    },
    { name:     "TAG_935",
      desc:     "Tag Address stored in cache line 935",
      swaccess: "rw",
      hwaccess: "hrw",
      hwext:    "true",
      hwqe:     "true", // enable `qe` latched signal of software write pulse
      hwre:     "true",
      fields: [
        { bits: "5-1:0",
          name: "CL_TAG",
          desc: "Tag Address"
        }
      ]
    },
    {
      name:     "STATUS_936",
      desc:     "Status register of cache line 936",
      swaccess: "rw",
      hwaccess: "hrw",
      hwext:    "true",
      hwqe:     "true", // enable `qe` latched signal of software write pulse
      hwre:     "true",
      fields: [
        {
          bits: "5+3:5", // 2 bits for status
          name: "CL_STATUS",
          desc: "Contain the current status of the corresponding cache line                [0]: valid, [1]: dirty, [2]: cmpt",
        }
      ]
    },
    { name:     "TAG_936",
      desc:     "Tag Address stored in cache line 936",
      swaccess: "rw",
      hwaccess: "hrw",
      hwext:    "true",
      hwqe:     "true", // enable `qe` latched signal of software write pulse
      hwre:     "true",
      fields: [
        { bits: "5-1:0",
          name: "CL_TAG",
          desc: "Tag Address"
        }
      ]
    },
    {
      name:     "STATUS_937",
      desc:     "Status register of cache line 937",
      swaccess: "rw",
      hwaccess: "hrw",
      hwext:    "true",
      hwqe:     "true", // enable `qe` latched signal of software write pulse
      hwre:     "true",
      fields: [
        {
          bits: "5+3:5", // 2 bits for status
          name: "CL_STATUS",
          desc: "Contain the current status of the corresponding cache line                [0]: valid, [1]: dirty, [2]: cmpt",
        }
      ]
    },
    { name:     "TAG_937",
      desc:     "Tag Address stored in cache line 937",
      swaccess: "rw",
      hwaccess: "hrw",
      hwext:    "true",
      hwqe:     "true", // enable `qe` latched signal of software write pulse
      hwre:     "true",
      fields: [
        { bits: "5-1:0",
          name: "CL_TAG",
          desc: "Tag Address"
        }
      ]
    },
    {
      name:     "STATUS_938",
      desc:     "Status register of cache line 938",
      swaccess: "rw",
      hwaccess: "hrw",
      hwext:    "true",
      hwqe:     "true", // enable `qe` latched signal of software write pulse
      hwre:     "true",
      fields: [
        {
          bits: "5+3:5", // 2 bits for status
          name: "CL_STATUS",
          desc: "Contain the current status of the corresponding cache line                [0]: valid, [1]: dirty, [2]: cmpt",
        }
      ]
    },
    { name:     "TAG_938",
      desc:     "Tag Address stored in cache line 938",
      swaccess: "rw",
      hwaccess: "hrw",
      hwext:    "true",
      hwqe:     "true", // enable `qe` latched signal of software write pulse
      hwre:     "true",
      fields: [
        { bits: "5-1:0",
          name: "CL_TAG",
          desc: "Tag Address"
        }
      ]
    },
    {
      name:     "STATUS_939",
      desc:     "Status register of cache line 939",
      swaccess: "rw",
      hwaccess: "hrw",
      hwext:    "true",
      hwqe:     "true", // enable `qe` latched signal of software write pulse
      hwre:     "true",
      fields: [
        {
          bits: "5+3:5", // 2 bits for status
          name: "CL_STATUS",
          desc: "Contain the current status of the corresponding cache line                [0]: valid, [1]: dirty, [2]: cmpt",
        }
      ]
    },
    { name:     "TAG_939",
      desc:     "Tag Address stored in cache line 939",
      swaccess: "rw",
      hwaccess: "hrw",
      hwext:    "true",
      hwqe:     "true", // enable `qe` latched signal of software write pulse
      hwre:     "true",
      fields: [
        { bits: "5-1:0",
          name: "CL_TAG",
          desc: "Tag Address"
        }
      ]
    },
    {
      name:     "STATUS_940",
      desc:     "Status register of cache line 940",
      swaccess: "rw",
      hwaccess: "hrw",
      hwext:    "true",
      hwqe:     "true", // enable `qe` latched signal of software write pulse
      hwre:     "true",
      fields: [
        {
          bits: "5+3:5", // 2 bits for status
          name: "CL_STATUS",
          desc: "Contain the current status of the corresponding cache line                [0]: valid, [1]: dirty, [2]: cmpt",
        }
      ]
    },
    { name:     "TAG_940",
      desc:     "Tag Address stored in cache line 940",
      swaccess: "rw",
      hwaccess: "hrw",
      hwext:    "true",
      hwqe:     "true", // enable `qe` latched signal of software write pulse
      hwre:     "true",
      fields: [
        { bits: "5-1:0",
          name: "CL_TAG",
          desc: "Tag Address"
        }
      ]
    },
    {
      name:     "STATUS_941",
      desc:     "Status register of cache line 941",
      swaccess: "rw",
      hwaccess: "hrw",
      hwext:    "true",
      hwqe:     "true", // enable `qe` latched signal of software write pulse
      hwre:     "true",
      fields: [
        {
          bits: "5+3:5", // 2 bits for status
          name: "CL_STATUS",
          desc: "Contain the current status of the corresponding cache line                [0]: valid, [1]: dirty, [2]: cmpt",
        }
      ]
    },
    { name:     "TAG_941",
      desc:     "Tag Address stored in cache line 941",
      swaccess: "rw",
      hwaccess: "hrw",
      hwext:    "true",
      hwqe:     "true", // enable `qe` latched signal of software write pulse
      hwre:     "true",
      fields: [
        { bits: "5-1:0",
          name: "CL_TAG",
          desc: "Tag Address"
        }
      ]
    },
    {
      name:     "STATUS_942",
      desc:     "Status register of cache line 942",
      swaccess: "rw",
      hwaccess: "hrw",
      hwext:    "true",
      hwqe:     "true", // enable `qe` latched signal of software write pulse
      hwre:     "true",
      fields: [
        {
          bits: "5+3:5", // 2 bits for status
          name: "CL_STATUS",
          desc: "Contain the current status of the corresponding cache line                [0]: valid, [1]: dirty, [2]: cmpt",
        }
      ]
    },
    { name:     "TAG_942",
      desc:     "Tag Address stored in cache line 942",
      swaccess: "rw",
      hwaccess: "hrw",
      hwext:    "true",
      hwqe:     "true", // enable `qe` latched signal of software write pulse
      hwre:     "true",
      fields: [
        { bits: "5-1:0",
          name: "CL_TAG",
          desc: "Tag Address"
        }
      ]
    },
    {
      name:     "STATUS_943",
      desc:     "Status register of cache line 943",
      swaccess: "rw",
      hwaccess: "hrw",
      hwext:    "true",
      hwqe:     "true", // enable `qe` latched signal of software write pulse
      hwre:     "true",
      fields: [
        {
          bits: "5+3:5", // 2 bits for status
          name: "CL_STATUS",
          desc: "Contain the current status of the corresponding cache line                [0]: valid, [1]: dirty, [2]: cmpt",
        }
      ]
    },
    { name:     "TAG_943",
      desc:     "Tag Address stored in cache line 943",
      swaccess: "rw",
      hwaccess: "hrw",
      hwext:    "true",
      hwqe:     "true", // enable `qe` latched signal of software write pulse
      hwre:     "true",
      fields: [
        { bits: "5-1:0",
          name: "CL_TAG",
          desc: "Tag Address"
        }
      ]
    },
    {
      name:     "STATUS_944",
      desc:     "Status register of cache line 944",
      swaccess: "rw",
      hwaccess: "hrw",
      hwext:    "true",
      hwqe:     "true", // enable `qe` latched signal of software write pulse
      hwre:     "true",
      fields: [
        {
          bits: "5+3:5", // 2 bits for status
          name: "CL_STATUS",
          desc: "Contain the current status of the corresponding cache line                [0]: valid, [1]: dirty, [2]: cmpt",
        }
      ]
    },
    { name:     "TAG_944",
      desc:     "Tag Address stored in cache line 944",
      swaccess: "rw",
      hwaccess: "hrw",
      hwext:    "true",
      hwqe:     "true", // enable `qe` latched signal of software write pulse
      hwre:     "true",
      fields: [
        { bits: "5-1:0",
          name: "CL_TAG",
          desc: "Tag Address"
        }
      ]
    },
    {
      name:     "STATUS_945",
      desc:     "Status register of cache line 945",
      swaccess: "rw",
      hwaccess: "hrw",
      hwext:    "true",
      hwqe:     "true", // enable `qe` latched signal of software write pulse
      hwre:     "true",
      fields: [
        {
          bits: "5+3:5", // 2 bits for status
          name: "CL_STATUS",
          desc: "Contain the current status of the corresponding cache line                [0]: valid, [1]: dirty, [2]: cmpt",
        }
      ]
    },
    { name:     "TAG_945",
      desc:     "Tag Address stored in cache line 945",
      swaccess: "rw",
      hwaccess: "hrw",
      hwext:    "true",
      hwqe:     "true", // enable `qe` latched signal of software write pulse
      hwre:     "true",
      fields: [
        { bits: "5-1:0",
          name: "CL_TAG",
          desc: "Tag Address"
        }
      ]
    },
    {
      name:     "STATUS_946",
      desc:     "Status register of cache line 946",
      swaccess: "rw",
      hwaccess: "hrw",
      hwext:    "true",
      hwqe:     "true", // enable `qe` latched signal of software write pulse
      hwre:     "true",
      fields: [
        {
          bits: "5+3:5", // 2 bits for status
          name: "CL_STATUS",
          desc: "Contain the current status of the corresponding cache line                [0]: valid, [1]: dirty, [2]: cmpt",
        }
      ]
    },
    { name:     "TAG_946",
      desc:     "Tag Address stored in cache line 946",
      swaccess: "rw",
      hwaccess: "hrw",
      hwext:    "true",
      hwqe:     "true", // enable `qe` latched signal of software write pulse
      hwre:     "true",
      fields: [
        { bits: "5-1:0",
          name: "CL_TAG",
          desc: "Tag Address"
        }
      ]
    },
    {
      name:     "STATUS_947",
      desc:     "Status register of cache line 947",
      swaccess: "rw",
      hwaccess: "hrw",
      hwext:    "true",
      hwqe:     "true", // enable `qe` latched signal of software write pulse
      hwre:     "true",
      fields: [
        {
          bits: "5+3:5", // 2 bits for status
          name: "CL_STATUS",
          desc: "Contain the current status of the corresponding cache line                [0]: valid, [1]: dirty, [2]: cmpt",
        }
      ]
    },
    { name:     "TAG_947",
      desc:     "Tag Address stored in cache line 947",
      swaccess: "rw",
      hwaccess: "hrw",
      hwext:    "true",
      hwqe:     "true", // enable `qe` latched signal of software write pulse
      hwre:     "true",
      fields: [
        { bits: "5-1:0",
          name: "CL_TAG",
          desc: "Tag Address"
        }
      ]
    },
    {
      name:     "STATUS_948",
      desc:     "Status register of cache line 948",
      swaccess: "rw",
      hwaccess: "hrw",
      hwext:    "true",
      hwqe:     "true", // enable `qe` latched signal of software write pulse
      hwre:     "true",
      fields: [
        {
          bits: "5+3:5", // 2 bits for status
          name: "CL_STATUS",
          desc: "Contain the current status of the corresponding cache line                [0]: valid, [1]: dirty, [2]: cmpt",
        }
      ]
    },
    { name:     "TAG_948",
      desc:     "Tag Address stored in cache line 948",
      swaccess: "rw",
      hwaccess: "hrw",
      hwext:    "true",
      hwqe:     "true", // enable `qe` latched signal of software write pulse
      hwre:     "true",
      fields: [
        { bits: "5-1:0",
          name: "CL_TAG",
          desc: "Tag Address"
        }
      ]
    },
    {
      name:     "STATUS_949",
      desc:     "Status register of cache line 949",
      swaccess: "rw",
      hwaccess: "hrw",
      hwext:    "true",
      hwqe:     "true", // enable `qe` latched signal of software write pulse
      hwre:     "true",
      fields: [
        {
          bits: "5+3:5", // 2 bits for status
          name: "CL_STATUS",
          desc: "Contain the current status of the corresponding cache line                [0]: valid, [1]: dirty, [2]: cmpt",
        }
      ]
    },
    { name:     "TAG_949",
      desc:     "Tag Address stored in cache line 949",
      swaccess: "rw",
      hwaccess: "hrw",
      hwext:    "true",
      hwqe:     "true", // enable `qe` latched signal of software write pulse
      hwre:     "true",
      fields: [
        { bits: "5-1:0",
          name: "CL_TAG",
          desc: "Tag Address"
        }
      ]
    },
    {
      name:     "STATUS_950",
      desc:     "Status register of cache line 950",
      swaccess: "rw",
      hwaccess: "hrw",
      hwext:    "true",
      hwqe:     "true", // enable `qe` latched signal of software write pulse
      hwre:     "true",
      fields: [
        {
          bits: "5+3:5", // 2 bits for status
          name: "CL_STATUS",
          desc: "Contain the current status of the corresponding cache line                [0]: valid, [1]: dirty, [2]: cmpt",
        }
      ]
    },
    { name:     "TAG_950",
      desc:     "Tag Address stored in cache line 950",
      swaccess: "rw",
      hwaccess: "hrw",
      hwext:    "true",
      hwqe:     "true", // enable `qe` latched signal of software write pulse
      hwre:     "true",
      fields: [
        { bits: "5-1:0",
          name: "CL_TAG",
          desc: "Tag Address"
        }
      ]
    },
    {
      name:     "STATUS_951",
      desc:     "Status register of cache line 951",
      swaccess: "rw",
      hwaccess: "hrw",
      hwext:    "true",
      hwqe:     "true", // enable `qe` latched signal of software write pulse
      hwre:     "true",
      fields: [
        {
          bits: "5+3:5", // 2 bits for status
          name: "CL_STATUS",
          desc: "Contain the current status of the corresponding cache line                [0]: valid, [1]: dirty, [2]: cmpt",
        }
      ]
    },
    { name:     "TAG_951",
      desc:     "Tag Address stored in cache line 951",
      swaccess: "rw",
      hwaccess: "hrw",
      hwext:    "true",
      hwqe:     "true", // enable `qe` latched signal of software write pulse
      hwre:     "true",
      fields: [
        { bits: "5-1:0",
          name: "CL_TAG",
          desc: "Tag Address"
        }
      ]
    },
    {
      name:     "STATUS_952",
      desc:     "Status register of cache line 952",
      swaccess: "rw",
      hwaccess: "hrw",
      hwext:    "true",
      hwqe:     "true", // enable `qe` latched signal of software write pulse
      hwre:     "true",
      fields: [
        {
          bits: "5+3:5", // 2 bits for status
          name: "CL_STATUS",
          desc: "Contain the current status of the corresponding cache line                [0]: valid, [1]: dirty, [2]: cmpt",
        }
      ]
    },
    { name:     "TAG_952",
      desc:     "Tag Address stored in cache line 952",
      swaccess: "rw",
      hwaccess: "hrw",
      hwext:    "true",
      hwqe:     "true", // enable `qe` latched signal of software write pulse
      hwre:     "true",
      fields: [
        { bits: "5-1:0",
          name: "CL_TAG",
          desc: "Tag Address"
        }
      ]
    },
    {
      name:     "STATUS_953",
      desc:     "Status register of cache line 953",
      swaccess: "rw",
      hwaccess: "hrw",
      hwext:    "true",
      hwqe:     "true", // enable `qe` latched signal of software write pulse
      hwre:     "true",
      fields: [
        {
          bits: "5+3:5", // 2 bits for status
          name: "CL_STATUS",
          desc: "Contain the current status of the corresponding cache line                [0]: valid, [1]: dirty, [2]: cmpt",
        }
      ]
    },
    { name:     "TAG_953",
      desc:     "Tag Address stored in cache line 953",
      swaccess: "rw",
      hwaccess: "hrw",
      hwext:    "true",
      hwqe:     "true", // enable `qe` latched signal of software write pulse
      hwre:     "true",
      fields: [
        { bits: "5-1:0",
          name: "CL_TAG",
          desc: "Tag Address"
        }
      ]
    },
    {
      name:     "STATUS_954",
      desc:     "Status register of cache line 954",
      swaccess: "rw",
      hwaccess: "hrw",
      hwext:    "true",
      hwqe:     "true", // enable `qe` latched signal of software write pulse
      hwre:     "true",
      fields: [
        {
          bits: "5+3:5", // 2 bits for status
          name: "CL_STATUS",
          desc: "Contain the current status of the corresponding cache line                [0]: valid, [1]: dirty, [2]: cmpt",
        }
      ]
    },
    { name:     "TAG_954",
      desc:     "Tag Address stored in cache line 954",
      swaccess: "rw",
      hwaccess: "hrw",
      hwext:    "true",
      hwqe:     "true", // enable `qe` latched signal of software write pulse
      hwre:     "true",
      fields: [
        { bits: "5-1:0",
          name: "CL_TAG",
          desc: "Tag Address"
        }
      ]
    },
    {
      name:     "STATUS_955",
      desc:     "Status register of cache line 955",
      swaccess: "rw",
      hwaccess: "hrw",
      hwext:    "true",
      hwqe:     "true", // enable `qe` latched signal of software write pulse
      hwre:     "true",
      fields: [
        {
          bits: "5+3:5", // 2 bits for status
          name: "CL_STATUS",
          desc: "Contain the current status of the corresponding cache line                [0]: valid, [1]: dirty, [2]: cmpt",
        }
      ]
    },
    { name:     "TAG_955",
      desc:     "Tag Address stored in cache line 955",
      swaccess: "rw",
      hwaccess: "hrw",
      hwext:    "true",
      hwqe:     "true", // enable `qe` latched signal of software write pulse
      hwre:     "true",
      fields: [
        { bits: "5-1:0",
          name: "CL_TAG",
          desc: "Tag Address"
        }
      ]
    },
    {
      name:     "STATUS_956",
      desc:     "Status register of cache line 956",
      swaccess: "rw",
      hwaccess: "hrw",
      hwext:    "true",
      hwqe:     "true", // enable `qe` latched signal of software write pulse
      hwre:     "true",
      fields: [
        {
          bits: "5+3:5", // 2 bits for status
          name: "CL_STATUS",
          desc: "Contain the current status of the corresponding cache line                [0]: valid, [1]: dirty, [2]: cmpt",
        }
      ]
    },
    { name:     "TAG_956",
      desc:     "Tag Address stored in cache line 956",
      swaccess: "rw",
      hwaccess: "hrw",
      hwext:    "true",
      hwqe:     "true", // enable `qe` latched signal of software write pulse
      hwre:     "true",
      fields: [
        { bits: "5-1:0",
          name: "CL_TAG",
          desc: "Tag Address"
        }
      ]
    },
    {
      name:     "STATUS_957",
      desc:     "Status register of cache line 957",
      swaccess: "rw",
      hwaccess: "hrw",
      hwext:    "true",
      hwqe:     "true", // enable `qe` latched signal of software write pulse
      hwre:     "true",
      fields: [
        {
          bits: "5+3:5", // 2 bits for status
          name: "CL_STATUS",
          desc: "Contain the current status of the corresponding cache line                [0]: valid, [1]: dirty, [2]: cmpt",
        }
      ]
    },
    { name:     "TAG_957",
      desc:     "Tag Address stored in cache line 957",
      swaccess: "rw",
      hwaccess: "hrw",
      hwext:    "true",
      hwqe:     "true", // enable `qe` latched signal of software write pulse
      hwre:     "true",
      fields: [
        { bits: "5-1:0",
          name: "CL_TAG",
          desc: "Tag Address"
        }
      ]
    },
    {
      name:     "STATUS_958",
      desc:     "Status register of cache line 958",
      swaccess: "rw",
      hwaccess: "hrw",
      hwext:    "true",
      hwqe:     "true", // enable `qe` latched signal of software write pulse
      hwre:     "true",
      fields: [
        {
          bits: "5+3:5", // 2 bits for status
          name: "CL_STATUS",
          desc: "Contain the current status of the corresponding cache line                [0]: valid, [1]: dirty, [2]: cmpt",
        }
      ]
    },
    { name:     "TAG_958",
      desc:     "Tag Address stored in cache line 958",
      swaccess: "rw",
      hwaccess: "hrw",
      hwext:    "true",
      hwqe:     "true", // enable `qe` latched signal of software write pulse
      hwre:     "true",
      fields: [
        { bits: "5-1:0",
          name: "CL_TAG",
          desc: "Tag Address"
        }
      ]
    },
    {
      name:     "STATUS_959",
      desc:     "Status register of cache line 959",
      swaccess: "rw",
      hwaccess: "hrw",
      hwext:    "true",
      hwqe:     "true", // enable `qe` latched signal of software write pulse
      hwre:     "true",
      fields: [
        {
          bits: "5+3:5", // 2 bits for status
          name: "CL_STATUS",
          desc: "Contain the current status of the corresponding cache line                [0]: valid, [1]: dirty, [2]: cmpt",
        }
      ]
    },
    { name:     "TAG_959",
      desc:     "Tag Address stored in cache line 959",
      swaccess: "rw",
      hwaccess: "hrw",
      hwext:    "true",
      hwqe:     "true", // enable `qe` latched signal of software write pulse
      hwre:     "true",
      fields: [
        { bits: "5-1:0",
          name: "CL_TAG",
          desc: "Tag Address"
        }
      ]
    },
    {
      name:     "STATUS_960",
      desc:     "Status register of cache line 960",
      swaccess: "rw",
      hwaccess: "hrw",
      hwext:    "true",
      hwqe:     "true", // enable `qe` latched signal of software write pulse
      hwre:     "true",
      fields: [
        {
          bits: "5+3:5", // 2 bits for status
          name: "CL_STATUS",
          desc: "Contain the current status of the corresponding cache line                [0]: valid, [1]: dirty, [2]: cmpt",
        }
      ]
    },
    { name:     "TAG_960",
      desc:     "Tag Address stored in cache line 960",
      swaccess: "rw",
      hwaccess: "hrw",
      hwext:    "true",
      hwqe:     "true", // enable `qe` latched signal of software write pulse
      hwre:     "true",
      fields: [
        { bits: "5-1:0",
          name: "CL_TAG",
          desc: "Tag Address"
        }
      ]
    },
    {
      name:     "STATUS_961",
      desc:     "Status register of cache line 961",
      swaccess: "rw",
      hwaccess: "hrw",
      hwext:    "true",
      hwqe:     "true", // enable `qe` latched signal of software write pulse
      hwre:     "true",
      fields: [
        {
          bits: "5+3:5", // 2 bits for status
          name: "CL_STATUS",
          desc: "Contain the current status of the corresponding cache line                [0]: valid, [1]: dirty, [2]: cmpt",
        }
      ]
    },
    { name:     "TAG_961",
      desc:     "Tag Address stored in cache line 961",
      swaccess: "rw",
      hwaccess: "hrw",
      hwext:    "true",
      hwqe:     "true", // enable `qe` latched signal of software write pulse
      hwre:     "true",
      fields: [
        { bits: "5-1:0",
          name: "CL_TAG",
          desc: "Tag Address"
        }
      ]
    },
    {
      name:     "STATUS_962",
      desc:     "Status register of cache line 962",
      swaccess: "rw",
      hwaccess: "hrw",
      hwext:    "true",
      hwqe:     "true", // enable `qe` latched signal of software write pulse
      hwre:     "true",
      fields: [
        {
          bits: "5+3:5", // 2 bits for status
          name: "CL_STATUS",
          desc: "Contain the current status of the corresponding cache line                [0]: valid, [1]: dirty, [2]: cmpt",
        }
      ]
    },
    { name:     "TAG_962",
      desc:     "Tag Address stored in cache line 962",
      swaccess: "rw",
      hwaccess: "hrw",
      hwext:    "true",
      hwqe:     "true", // enable `qe` latched signal of software write pulse
      hwre:     "true",
      fields: [
        { bits: "5-1:0",
          name: "CL_TAG",
          desc: "Tag Address"
        }
      ]
    },
    {
      name:     "STATUS_963",
      desc:     "Status register of cache line 963",
      swaccess: "rw",
      hwaccess: "hrw",
      hwext:    "true",
      hwqe:     "true", // enable `qe` latched signal of software write pulse
      hwre:     "true",
      fields: [
        {
          bits: "5+3:5", // 2 bits for status
          name: "CL_STATUS",
          desc: "Contain the current status of the corresponding cache line                [0]: valid, [1]: dirty, [2]: cmpt",
        }
      ]
    },
    { name:     "TAG_963",
      desc:     "Tag Address stored in cache line 963",
      swaccess: "rw",
      hwaccess: "hrw",
      hwext:    "true",
      hwqe:     "true", // enable `qe` latched signal of software write pulse
      hwre:     "true",
      fields: [
        { bits: "5-1:0",
          name: "CL_TAG",
          desc: "Tag Address"
        }
      ]
    },
    {
      name:     "STATUS_964",
      desc:     "Status register of cache line 964",
      swaccess: "rw",
      hwaccess: "hrw",
      hwext:    "true",
      hwqe:     "true", // enable `qe` latched signal of software write pulse
      hwre:     "true",
      fields: [
        {
          bits: "5+3:5", // 2 bits for status
          name: "CL_STATUS",
          desc: "Contain the current status of the corresponding cache line                [0]: valid, [1]: dirty, [2]: cmpt",
        }
      ]
    },
    { name:     "TAG_964",
      desc:     "Tag Address stored in cache line 964",
      swaccess: "rw",
      hwaccess: "hrw",
      hwext:    "true",
      hwqe:     "true", // enable `qe` latched signal of software write pulse
      hwre:     "true",
      fields: [
        { bits: "5-1:0",
          name: "CL_TAG",
          desc: "Tag Address"
        }
      ]
    },
    {
      name:     "STATUS_965",
      desc:     "Status register of cache line 965",
      swaccess: "rw",
      hwaccess: "hrw",
      hwext:    "true",
      hwqe:     "true", // enable `qe` latched signal of software write pulse
      hwre:     "true",
      fields: [
        {
          bits: "5+3:5", // 2 bits for status
          name: "CL_STATUS",
          desc: "Contain the current status of the corresponding cache line                [0]: valid, [1]: dirty, [2]: cmpt",
        }
      ]
    },
    { name:     "TAG_965",
      desc:     "Tag Address stored in cache line 965",
      swaccess: "rw",
      hwaccess: "hrw",
      hwext:    "true",
      hwqe:     "true", // enable `qe` latched signal of software write pulse
      hwre:     "true",
      fields: [
        { bits: "5-1:0",
          name: "CL_TAG",
          desc: "Tag Address"
        }
      ]
    },
    {
      name:     "STATUS_966",
      desc:     "Status register of cache line 966",
      swaccess: "rw",
      hwaccess: "hrw",
      hwext:    "true",
      hwqe:     "true", // enable `qe` latched signal of software write pulse
      hwre:     "true",
      fields: [
        {
          bits: "5+3:5", // 2 bits for status
          name: "CL_STATUS",
          desc: "Contain the current status of the corresponding cache line                [0]: valid, [1]: dirty, [2]: cmpt",
        }
      ]
    },
    { name:     "TAG_966",
      desc:     "Tag Address stored in cache line 966",
      swaccess: "rw",
      hwaccess: "hrw",
      hwext:    "true",
      hwqe:     "true", // enable `qe` latched signal of software write pulse
      hwre:     "true",
      fields: [
        { bits: "5-1:0",
          name: "CL_TAG",
          desc: "Tag Address"
        }
      ]
    },
    {
      name:     "STATUS_967",
      desc:     "Status register of cache line 967",
      swaccess: "rw",
      hwaccess: "hrw",
      hwext:    "true",
      hwqe:     "true", // enable `qe` latched signal of software write pulse
      hwre:     "true",
      fields: [
        {
          bits: "5+3:5", // 2 bits for status
          name: "CL_STATUS",
          desc: "Contain the current status of the corresponding cache line                [0]: valid, [1]: dirty, [2]: cmpt",
        }
      ]
    },
    { name:     "TAG_967",
      desc:     "Tag Address stored in cache line 967",
      swaccess: "rw",
      hwaccess: "hrw",
      hwext:    "true",
      hwqe:     "true", // enable `qe` latched signal of software write pulse
      hwre:     "true",
      fields: [
        { bits: "5-1:0",
          name: "CL_TAG",
          desc: "Tag Address"
        }
      ]
    },
    {
      name:     "STATUS_968",
      desc:     "Status register of cache line 968",
      swaccess: "rw",
      hwaccess: "hrw",
      hwext:    "true",
      hwqe:     "true", // enable `qe` latched signal of software write pulse
      hwre:     "true",
      fields: [
        {
          bits: "5+3:5", // 2 bits for status
          name: "CL_STATUS",
          desc: "Contain the current status of the corresponding cache line                [0]: valid, [1]: dirty, [2]: cmpt",
        }
      ]
    },
    { name:     "TAG_968",
      desc:     "Tag Address stored in cache line 968",
      swaccess: "rw",
      hwaccess: "hrw",
      hwext:    "true",
      hwqe:     "true", // enable `qe` latched signal of software write pulse
      hwre:     "true",
      fields: [
        { bits: "5-1:0",
          name: "CL_TAG",
          desc: "Tag Address"
        }
      ]
    },
    {
      name:     "STATUS_969",
      desc:     "Status register of cache line 969",
      swaccess: "rw",
      hwaccess: "hrw",
      hwext:    "true",
      hwqe:     "true", // enable `qe` latched signal of software write pulse
      hwre:     "true",
      fields: [
        {
          bits: "5+3:5", // 2 bits for status
          name: "CL_STATUS",
          desc: "Contain the current status of the corresponding cache line                [0]: valid, [1]: dirty, [2]: cmpt",
        }
      ]
    },
    { name:     "TAG_969",
      desc:     "Tag Address stored in cache line 969",
      swaccess: "rw",
      hwaccess: "hrw",
      hwext:    "true",
      hwqe:     "true", // enable `qe` latched signal of software write pulse
      hwre:     "true",
      fields: [
        { bits: "5-1:0",
          name: "CL_TAG",
          desc: "Tag Address"
        }
      ]
    },
    {
      name:     "STATUS_970",
      desc:     "Status register of cache line 970",
      swaccess: "rw",
      hwaccess: "hrw",
      hwext:    "true",
      hwqe:     "true", // enable `qe` latched signal of software write pulse
      hwre:     "true",
      fields: [
        {
          bits: "5+3:5", // 2 bits for status
          name: "CL_STATUS",
          desc: "Contain the current status of the corresponding cache line                [0]: valid, [1]: dirty, [2]: cmpt",
        }
      ]
    },
    { name:     "TAG_970",
      desc:     "Tag Address stored in cache line 970",
      swaccess: "rw",
      hwaccess: "hrw",
      hwext:    "true",
      hwqe:     "true", // enable `qe` latched signal of software write pulse
      hwre:     "true",
      fields: [
        { bits: "5-1:0",
          name: "CL_TAG",
          desc: "Tag Address"
        }
      ]
    },
    {
      name:     "STATUS_971",
      desc:     "Status register of cache line 971",
      swaccess: "rw",
      hwaccess: "hrw",
      hwext:    "true",
      hwqe:     "true", // enable `qe` latched signal of software write pulse
      hwre:     "true",
      fields: [
        {
          bits: "5+3:5", // 2 bits for status
          name: "CL_STATUS",
          desc: "Contain the current status of the corresponding cache line                [0]: valid, [1]: dirty, [2]: cmpt",
        }
      ]
    },
    { name:     "TAG_971",
      desc:     "Tag Address stored in cache line 971",
      swaccess: "rw",
      hwaccess: "hrw",
      hwext:    "true",
      hwqe:     "true", // enable `qe` latched signal of software write pulse
      hwre:     "true",
      fields: [
        { bits: "5-1:0",
          name: "CL_TAG",
          desc: "Tag Address"
        }
      ]
    },
    {
      name:     "STATUS_972",
      desc:     "Status register of cache line 972",
      swaccess: "rw",
      hwaccess: "hrw",
      hwext:    "true",
      hwqe:     "true", // enable `qe` latched signal of software write pulse
      hwre:     "true",
      fields: [
        {
          bits: "5+3:5", // 2 bits for status
          name: "CL_STATUS",
          desc: "Contain the current status of the corresponding cache line                [0]: valid, [1]: dirty, [2]: cmpt",
        }
      ]
    },
    { name:     "TAG_972",
      desc:     "Tag Address stored in cache line 972",
      swaccess: "rw",
      hwaccess: "hrw",
      hwext:    "true",
      hwqe:     "true", // enable `qe` latched signal of software write pulse
      hwre:     "true",
      fields: [
        { bits: "5-1:0",
          name: "CL_TAG",
          desc: "Tag Address"
        }
      ]
    },
    {
      name:     "STATUS_973",
      desc:     "Status register of cache line 973",
      swaccess: "rw",
      hwaccess: "hrw",
      hwext:    "true",
      hwqe:     "true", // enable `qe` latched signal of software write pulse
      hwre:     "true",
      fields: [
        {
          bits: "5+3:5", // 2 bits for status
          name: "CL_STATUS",
          desc: "Contain the current status of the corresponding cache line                [0]: valid, [1]: dirty, [2]: cmpt",
        }
      ]
    },
    { name:     "TAG_973",
      desc:     "Tag Address stored in cache line 973",
      swaccess: "rw",
      hwaccess: "hrw",
      hwext:    "true",
      hwqe:     "true", // enable `qe` latched signal of software write pulse
      hwre:     "true",
      fields: [
        { bits: "5-1:0",
          name: "CL_TAG",
          desc: "Tag Address"
        }
      ]
    },
    {
      name:     "STATUS_974",
      desc:     "Status register of cache line 974",
      swaccess: "rw",
      hwaccess: "hrw",
      hwext:    "true",
      hwqe:     "true", // enable `qe` latched signal of software write pulse
      hwre:     "true",
      fields: [
        {
          bits: "5+3:5", // 2 bits for status
          name: "CL_STATUS",
          desc: "Contain the current status of the corresponding cache line                [0]: valid, [1]: dirty, [2]: cmpt",
        }
      ]
    },
    { name:     "TAG_974",
      desc:     "Tag Address stored in cache line 974",
      swaccess: "rw",
      hwaccess: "hrw",
      hwext:    "true",
      hwqe:     "true", // enable `qe` latched signal of software write pulse
      hwre:     "true",
      fields: [
        { bits: "5-1:0",
          name: "CL_TAG",
          desc: "Tag Address"
        }
      ]
    },
    {
      name:     "STATUS_975",
      desc:     "Status register of cache line 975",
      swaccess: "rw",
      hwaccess: "hrw",
      hwext:    "true",
      hwqe:     "true", // enable `qe` latched signal of software write pulse
      hwre:     "true",
      fields: [
        {
          bits: "5+3:5", // 2 bits for status
          name: "CL_STATUS",
          desc: "Contain the current status of the corresponding cache line                [0]: valid, [1]: dirty, [2]: cmpt",
        }
      ]
    },
    { name:     "TAG_975",
      desc:     "Tag Address stored in cache line 975",
      swaccess: "rw",
      hwaccess: "hrw",
      hwext:    "true",
      hwqe:     "true", // enable `qe` latched signal of software write pulse
      hwre:     "true",
      fields: [
        { bits: "5-1:0",
          name: "CL_TAG",
          desc: "Tag Address"
        }
      ]
    },
    {
      name:     "STATUS_976",
      desc:     "Status register of cache line 976",
      swaccess: "rw",
      hwaccess: "hrw",
      hwext:    "true",
      hwqe:     "true", // enable `qe` latched signal of software write pulse
      hwre:     "true",
      fields: [
        {
          bits: "5+3:5", // 2 bits for status
          name: "CL_STATUS",
          desc: "Contain the current status of the corresponding cache line                [0]: valid, [1]: dirty, [2]: cmpt",
        }
      ]
    },
    { name:     "TAG_976",
      desc:     "Tag Address stored in cache line 976",
      swaccess: "rw",
      hwaccess: "hrw",
      hwext:    "true",
      hwqe:     "true", // enable `qe` latched signal of software write pulse
      hwre:     "true",
      fields: [
        { bits: "5-1:0",
          name: "CL_TAG",
          desc: "Tag Address"
        }
      ]
    },
    {
      name:     "STATUS_977",
      desc:     "Status register of cache line 977",
      swaccess: "rw",
      hwaccess: "hrw",
      hwext:    "true",
      hwqe:     "true", // enable `qe` latched signal of software write pulse
      hwre:     "true",
      fields: [
        {
          bits: "5+3:5", // 2 bits for status
          name: "CL_STATUS",
          desc: "Contain the current status of the corresponding cache line                [0]: valid, [1]: dirty, [2]: cmpt",
        }
      ]
    },
    { name:     "TAG_977",
      desc:     "Tag Address stored in cache line 977",
      swaccess: "rw",
      hwaccess: "hrw",
      hwext:    "true",
      hwqe:     "true", // enable `qe` latched signal of software write pulse
      hwre:     "true",
      fields: [
        { bits: "5-1:0",
          name: "CL_TAG",
          desc: "Tag Address"
        }
      ]
    },
    {
      name:     "STATUS_978",
      desc:     "Status register of cache line 978",
      swaccess: "rw",
      hwaccess: "hrw",
      hwext:    "true",
      hwqe:     "true", // enable `qe` latched signal of software write pulse
      hwre:     "true",
      fields: [
        {
          bits: "5+3:5", // 2 bits for status
          name: "CL_STATUS",
          desc: "Contain the current status of the corresponding cache line                [0]: valid, [1]: dirty, [2]: cmpt",
        }
      ]
    },
    { name:     "TAG_978",
      desc:     "Tag Address stored in cache line 978",
      swaccess: "rw",
      hwaccess: "hrw",
      hwext:    "true",
      hwqe:     "true", // enable `qe` latched signal of software write pulse
      hwre:     "true",
      fields: [
        { bits: "5-1:0",
          name: "CL_TAG",
          desc: "Tag Address"
        }
      ]
    },
    {
      name:     "STATUS_979",
      desc:     "Status register of cache line 979",
      swaccess: "rw",
      hwaccess: "hrw",
      hwext:    "true",
      hwqe:     "true", // enable `qe` latched signal of software write pulse
      hwre:     "true",
      fields: [
        {
          bits: "5+3:5", // 2 bits for status
          name: "CL_STATUS",
          desc: "Contain the current status of the corresponding cache line                [0]: valid, [1]: dirty, [2]: cmpt",
        }
      ]
    },
    { name:     "TAG_979",
      desc:     "Tag Address stored in cache line 979",
      swaccess: "rw",
      hwaccess: "hrw",
      hwext:    "true",
      hwqe:     "true", // enable `qe` latched signal of software write pulse
      hwre:     "true",
      fields: [
        { bits: "5-1:0",
          name: "CL_TAG",
          desc: "Tag Address"
        }
      ]
    },
    {
      name:     "STATUS_980",
      desc:     "Status register of cache line 980",
      swaccess: "rw",
      hwaccess: "hrw",
      hwext:    "true",
      hwqe:     "true", // enable `qe` latched signal of software write pulse
      hwre:     "true",
      fields: [
        {
          bits: "5+3:5", // 2 bits for status
          name: "CL_STATUS",
          desc: "Contain the current status of the corresponding cache line                [0]: valid, [1]: dirty, [2]: cmpt",
        }
      ]
    },
    { name:     "TAG_980",
      desc:     "Tag Address stored in cache line 980",
      swaccess: "rw",
      hwaccess: "hrw",
      hwext:    "true",
      hwqe:     "true", // enable `qe` latched signal of software write pulse
      hwre:     "true",
      fields: [
        { bits: "5-1:0",
          name: "CL_TAG",
          desc: "Tag Address"
        }
      ]
    },
    {
      name:     "STATUS_981",
      desc:     "Status register of cache line 981",
      swaccess: "rw",
      hwaccess: "hrw",
      hwext:    "true",
      hwqe:     "true", // enable `qe` latched signal of software write pulse
      hwre:     "true",
      fields: [
        {
          bits: "5+3:5", // 2 bits for status
          name: "CL_STATUS",
          desc: "Contain the current status of the corresponding cache line                [0]: valid, [1]: dirty, [2]: cmpt",
        }
      ]
    },
    { name:     "TAG_981",
      desc:     "Tag Address stored in cache line 981",
      swaccess: "rw",
      hwaccess: "hrw",
      hwext:    "true",
      hwqe:     "true", // enable `qe` latched signal of software write pulse
      hwre:     "true",
      fields: [
        { bits: "5-1:0",
          name: "CL_TAG",
          desc: "Tag Address"
        }
      ]
    },
    {
      name:     "STATUS_982",
      desc:     "Status register of cache line 982",
      swaccess: "rw",
      hwaccess: "hrw",
      hwext:    "true",
      hwqe:     "true", // enable `qe` latched signal of software write pulse
      hwre:     "true",
      fields: [
        {
          bits: "5+3:5", // 2 bits for status
          name: "CL_STATUS",
          desc: "Contain the current status of the corresponding cache line                [0]: valid, [1]: dirty, [2]: cmpt",
        }
      ]
    },
    { name:     "TAG_982",
      desc:     "Tag Address stored in cache line 982",
      swaccess: "rw",
      hwaccess: "hrw",
      hwext:    "true",
      hwqe:     "true", // enable `qe` latched signal of software write pulse
      hwre:     "true",
      fields: [
        { bits: "5-1:0",
          name: "CL_TAG",
          desc: "Tag Address"
        }
      ]
    },
    {
      name:     "STATUS_983",
      desc:     "Status register of cache line 983",
      swaccess: "rw",
      hwaccess: "hrw",
      hwext:    "true",
      hwqe:     "true", // enable `qe` latched signal of software write pulse
      hwre:     "true",
      fields: [
        {
          bits: "5+3:5", // 2 bits for status
          name: "CL_STATUS",
          desc: "Contain the current status of the corresponding cache line                [0]: valid, [1]: dirty, [2]: cmpt",
        }
      ]
    },
    { name:     "TAG_983",
      desc:     "Tag Address stored in cache line 983",
      swaccess: "rw",
      hwaccess: "hrw",
      hwext:    "true",
      hwqe:     "true", // enable `qe` latched signal of software write pulse
      hwre:     "true",
      fields: [
        { bits: "5-1:0",
          name: "CL_TAG",
          desc: "Tag Address"
        }
      ]
    },
    {
      name:     "STATUS_984",
      desc:     "Status register of cache line 984",
      swaccess: "rw",
      hwaccess: "hrw",
      hwext:    "true",
      hwqe:     "true", // enable `qe` latched signal of software write pulse
      hwre:     "true",
      fields: [
        {
          bits: "5+3:5", // 2 bits for status
          name: "CL_STATUS",
          desc: "Contain the current status of the corresponding cache line                [0]: valid, [1]: dirty, [2]: cmpt",
        }
      ]
    },
    { name:     "TAG_984",
      desc:     "Tag Address stored in cache line 984",
      swaccess: "rw",
      hwaccess: "hrw",
      hwext:    "true",
      hwqe:     "true", // enable `qe` latched signal of software write pulse
      hwre:     "true",
      fields: [
        { bits: "5-1:0",
          name: "CL_TAG",
          desc: "Tag Address"
        }
      ]
    },
    {
      name:     "STATUS_985",
      desc:     "Status register of cache line 985",
      swaccess: "rw",
      hwaccess: "hrw",
      hwext:    "true",
      hwqe:     "true", // enable `qe` latched signal of software write pulse
      hwre:     "true",
      fields: [
        {
          bits: "5+3:5", // 2 bits for status
          name: "CL_STATUS",
          desc: "Contain the current status of the corresponding cache line                [0]: valid, [1]: dirty, [2]: cmpt",
        }
      ]
    },
    { name:     "TAG_985",
      desc:     "Tag Address stored in cache line 985",
      swaccess: "rw",
      hwaccess: "hrw",
      hwext:    "true",
      hwqe:     "true", // enable `qe` latched signal of software write pulse
      hwre:     "true",
      fields: [
        { bits: "5-1:0",
          name: "CL_TAG",
          desc: "Tag Address"
        }
      ]
    },
    {
      name:     "STATUS_986",
      desc:     "Status register of cache line 986",
      swaccess: "rw",
      hwaccess: "hrw",
      hwext:    "true",
      hwqe:     "true", // enable `qe` latched signal of software write pulse
      hwre:     "true",
      fields: [
        {
          bits: "5+3:5", // 2 bits for status
          name: "CL_STATUS",
          desc: "Contain the current status of the corresponding cache line                [0]: valid, [1]: dirty, [2]: cmpt",
        }
      ]
    },
    { name:     "TAG_986",
      desc:     "Tag Address stored in cache line 986",
      swaccess: "rw",
      hwaccess: "hrw",
      hwext:    "true",
      hwqe:     "true", // enable `qe` latched signal of software write pulse
      hwre:     "true",
      fields: [
        { bits: "5-1:0",
          name: "CL_TAG",
          desc: "Tag Address"
        }
      ]
    },
    {
      name:     "STATUS_987",
      desc:     "Status register of cache line 987",
      swaccess: "rw",
      hwaccess: "hrw",
      hwext:    "true",
      hwqe:     "true", // enable `qe` latched signal of software write pulse
      hwre:     "true",
      fields: [
        {
          bits: "5+3:5", // 2 bits for status
          name: "CL_STATUS",
          desc: "Contain the current status of the corresponding cache line                [0]: valid, [1]: dirty, [2]: cmpt",
        }
      ]
    },
    { name:     "TAG_987",
      desc:     "Tag Address stored in cache line 987",
      swaccess: "rw",
      hwaccess: "hrw",
      hwext:    "true",
      hwqe:     "true", // enable `qe` latched signal of software write pulse
      hwre:     "true",
      fields: [
        { bits: "5-1:0",
          name: "CL_TAG",
          desc: "Tag Address"
        }
      ]
    },
    {
      name:     "STATUS_988",
      desc:     "Status register of cache line 988",
      swaccess: "rw",
      hwaccess: "hrw",
      hwext:    "true",
      hwqe:     "true", // enable `qe` latched signal of software write pulse
      hwre:     "true",
      fields: [
        {
          bits: "5+3:5", // 2 bits for status
          name: "CL_STATUS",
          desc: "Contain the current status of the corresponding cache line                [0]: valid, [1]: dirty, [2]: cmpt",
        }
      ]
    },
    { name:     "TAG_988",
      desc:     "Tag Address stored in cache line 988",
      swaccess: "rw",
      hwaccess: "hrw",
      hwext:    "true",
      hwqe:     "true", // enable `qe` latched signal of software write pulse
      hwre:     "true",
      fields: [
        { bits: "5-1:0",
          name: "CL_TAG",
          desc: "Tag Address"
        }
      ]
    },
    {
      name:     "STATUS_989",
      desc:     "Status register of cache line 989",
      swaccess: "rw",
      hwaccess: "hrw",
      hwext:    "true",
      hwqe:     "true", // enable `qe` latched signal of software write pulse
      hwre:     "true",
      fields: [
        {
          bits: "5+3:5", // 2 bits for status
          name: "CL_STATUS",
          desc: "Contain the current status of the corresponding cache line                [0]: valid, [1]: dirty, [2]: cmpt",
        }
      ]
    },
    { name:     "TAG_989",
      desc:     "Tag Address stored in cache line 989",
      swaccess: "rw",
      hwaccess: "hrw",
      hwext:    "true",
      hwqe:     "true", // enable `qe` latched signal of software write pulse
      hwre:     "true",
      fields: [
        { bits: "5-1:0",
          name: "CL_TAG",
          desc: "Tag Address"
        }
      ]
    },
    {
      name:     "STATUS_990",
      desc:     "Status register of cache line 990",
      swaccess: "rw",
      hwaccess: "hrw",
      hwext:    "true",
      hwqe:     "true", // enable `qe` latched signal of software write pulse
      hwre:     "true",
      fields: [
        {
          bits: "5+3:5", // 2 bits for status
          name: "CL_STATUS",
          desc: "Contain the current status of the corresponding cache line                [0]: valid, [1]: dirty, [2]: cmpt",
        }
      ]
    },
    { name:     "TAG_990",
      desc:     "Tag Address stored in cache line 990",
      swaccess: "rw",
      hwaccess: "hrw",
      hwext:    "true",
      hwqe:     "true", // enable `qe` latched signal of software write pulse
      hwre:     "true",
      fields: [
        { bits: "5-1:0",
          name: "CL_TAG",
          desc: "Tag Address"
        }
      ]
    },
    {
      name:     "STATUS_991",
      desc:     "Status register of cache line 991",
      swaccess: "rw",
      hwaccess: "hrw",
      hwext:    "true",
      hwqe:     "true", // enable `qe` latched signal of software write pulse
      hwre:     "true",
      fields: [
        {
          bits: "5+3:5", // 2 bits for status
          name: "CL_STATUS",
          desc: "Contain the current status of the corresponding cache line                [0]: valid, [1]: dirty, [2]: cmpt",
        }
      ]
    },
    { name:     "TAG_991",
      desc:     "Tag Address stored in cache line 991",
      swaccess: "rw",
      hwaccess: "hrw",
      hwext:    "true",
      hwqe:     "true", // enable `qe` latched signal of software write pulse
      hwre:     "true",
      fields: [
        { bits: "5-1:0",
          name: "CL_TAG",
          desc: "Tag Address"
        }
      ]
    },
    {
      name:     "STATUS_992",
      desc:     "Status register of cache line 992",
      swaccess: "rw",
      hwaccess: "hrw",
      hwext:    "true",
      hwqe:     "true", // enable `qe` latched signal of software write pulse
      hwre:     "true",
      fields: [
        {
          bits: "5+3:5", // 2 bits for status
          name: "CL_STATUS",
          desc: "Contain the current status of the corresponding cache line                [0]: valid, [1]: dirty, [2]: cmpt",
        }
      ]
    },
    { name:     "TAG_992",
      desc:     "Tag Address stored in cache line 992",
      swaccess: "rw",
      hwaccess: "hrw",
      hwext:    "true",
      hwqe:     "true", // enable `qe` latched signal of software write pulse
      hwre:     "true",
      fields: [
        { bits: "5-1:0",
          name: "CL_TAG",
          desc: "Tag Address"
        }
      ]
    },
    {
      name:     "STATUS_993",
      desc:     "Status register of cache line 993",
      swaccess: "rw",
      hwaccess: "hrw",
      hwext:    "true",
      hwqe:     "true", // enable `qe` latched signal of software write pulse
      hwre:     "true",
      fields: [
        {
          bits: "5+3:5", // 2 bits for status
          name: "CL_STATUS",
          desc: "Contain the current status of the corresponding cache line                [0]: valid, [1]: dirty, [2]: cmpt",
        }
      ]
    },
    { name:     "TAG_993",
      desc:     "Tag Address stored in cache line 993",
      swaccess: "rw",
      hwaccess: "hrw",
      hwext:    "true",
      hwqe:     "true", // enable `qe` latched signal of software write pulse
      hwre:     "true",
      fields: [
        { bits: "5-1:0",
          name: "CL_TAG",
          desc: "Tag Address"
        }
      ]
    },
    {
      name:     "STATUS_994",
      desc:     "Status register of cache line 994",
      swaccess: "rw",
      hwaccess: "hrw",
      hwext:    "true",
      hwqe:     "true", // enable `qe` latched signal of software write pulse
      hwre:     "true",
      fields: [
        {
          bits: "5+3:5", // 2 bits for status
          name: "CL_STATUS",
          desc: "Contain the current status of the corresponding cache line                [0]: valid, [1]: dirty, [2]: cmpt",
        }
      ]
    },
    { name:     "TAG_994",
      desc:     "Tag Address stored in cache line 994",
      swaccess: "rw",
      hwaccess: "hrw",
      hwext:    "true",
      hwqe:     "true", // enable `qe` latched signal of software write pulse
      hwre:     "true",
      fields: [
        { bits: "5-1:0",
          name: "CL_TAG",
          desc: "Tag Address"
        }
      ]
    },
    {
      name:     "STATUS_995",
      desc:     "Status register of cache line 995",
      swaccess: "rw",
      hwaccess: "hrw",
      hwext:    "true",
      hwqe:     "true", // enable `qe` latched signal of software write pulse
      hwre:     "true",
      fields: [
        {
          bits: "5+3:5", // 2 bits for status
          name: "CL_STATUS",
          desc: "Contain the current status of the corresponding cache line                [0]: valid, [1]: dirty, [2]: cmpt",
        }
      ]
    },
    { name:     "TAG_995",
      desc:     "Tag Address stored in cache line 995",
      swaccess: "rw",
      hwaccess: "hrw",
      hwext:    "true",
      hwqe:     "true", // enable `qe` latched signal of software write pulse
      hwre:     "true",
      fields: [
        { bits: "5-1:0",
          name: "CL_TAG",
          desc: "Tag Address"
        }
      ]
    },
    {
      name:     "STATUS_996",
      desc:     "Status register of cache line 996",
      swaccess: "rw",
      hwaccess: "hrw",
      hwext:    "true",
      hwqe:     "true", // enable `qe` latched signal of software write pulse
      hwre:     "true",
      fields: [
        {
          bits: "5+3:5", // 2 bits for status
          name: "CL_STATUS",
          desc: "Contain the current status of the corresponding cache line                [0]: valid, [1]: dirty, [2]: cmpt",
        }
      ]
    },
    { name:     "TAG_996",
      desc:     "Tag Address stored in cache line 996",
      swaccess: "rw",
      hwaccess: "hrw",
      hwext:    "true",
      hwqe:     "true", // enable `qe` latched signal of software write pulse
      hwre:     "true",
      fields: [
        { bits: "5-1:0",
          name: "CL_TAG",
          desc: "Tag Address"
        }
      ]
    },
    {
      name:     "STATUS_997",
      desc:     "Status register of cache line 997",
      swaccess: "rw",
      hwaccess: "hrw",
      hwext:    "true",
      hwqe:     "true", // enable `qe` latched signal of software write pulse
      hwre:     "true",
      fields: [
        {
          bits: "5+3:5", // 2 bits for status
          name: "CL_STATUS",
          desc: "Contain the current status of the corresponding cache line                [0]: valid, [1]: dirty, [2]: cmpt",
        }
      ]
    },
    { name:     "TAG_997",
      desc:     "Tag Address stored in cache line 997",
      swaccess: "rw",
      hwaccess: "hrw",
      hwext:    "true",
      hwqe:     "true", // enable `qe` latched signal of software write pulse
      hwre:     "true",
      fields: [
        { bits: "5-1:0",
          name: "CL_TAG",
          desc: "Tag Address"
        }
      ]
    },
    {
      name:     "STATUS_998",
      desc:     "Status register of cache line 998",
      swaccess: "rw",
      hwaccess: "hrw",
      hwext:    "true",
      hwqe:     "true", // enable `qe` latched signal of software write pulse
      hwre:     "true",
      fields: [
        {
          bits: "5+3:5", // 2 bits for status
          name: "CL_STATUS",
          desc: "Contain the current status of the corresponding cache line                [0]: valid, [1]: dirty, [2]: cmpt",
        }
      ]
    },
    { name:     "TAG_998",
      desc:     "Tag Address stored in cache line 998",
      swaccess: "rw",
      hwaccess: "hrw",
      hwext:    "true",
      hwqe:     "true", // enable `qe` latched signal of software write pulse
      hwre:     "true",
      fields: [
        { bits: "5-1:0",
          name: "CL_TAG",
          desc: "Tag Address"
        }
      ]
    },
    {
      name:     "STATUS_999",
      desc:     "Status register of cache line 999",
      swaccess: "rw",
      hwaccess: "hrw",
      hwext:    "true",
      hwqe:     "true", // enable `qe` latched signal of software write pulse
      hwre:     "true",
      fields: [
        {
          bits: "5+3:5", // 2 bits for status
          name: "CL_STATUS",
          desc: "Contain the current status of the corresponding cache line                [0]: valid, [1]: dirty, [2]: cmpt",
        }
      ]
    },
    { name:     "TAG_999",
      desc:     "Tag Address stored in cache line 999",
      swaccess: "rw",
      hwaccess: "hrw",
      hwext:    "true",
      hwqe:     "true", // enable `qe` latched signal of software write pulse
      hwre:     "true",
      fields: [
        { bits: "5-1:0",
          name: "CL_TAG",
          desc: "Tag Address"
        }
      ]
    },
    {
      name:     "STATUS_1000",
      desc:     "Status register of cache line 1000",
      swaccess: "rw",
      hwaccess: "hrw",
      hwext:    "true",
      hwqe:     "true", // enable `qe` latched signal of software write pulse
      hwre:     "true",
      fields: [
        {
          bits: "5+3:5", // 2 bits for status
          name: "CL_STATUS",
          desc: "Contain the current status of the corresponding cache line                [0]: valid, [1]: dirty, [2]: cmpt",
        }
      ]
    },
    { name:     "TAG_1000",
      desc:     "Tag Address stored in cache line 1000",
      swaccess: "rw",
      hwaccess: "hrw",
      hwext:    "true",
      hwqe:     "true", // enable `qe` latched signal of software write pulse
      hwre:     "true",
      fields: [
        { bits: "5-1:0",
          name: "CL_TAG",
          desc: "Tag Address"
        }
      ]
    },
    {
      name:     "STATUS_1001",
      desc:     "Status register of cache line 1001",
      swaccess: "rw",
      hwaccess: "hrw",
      hwext:    "true",
      hwqe:     "true", // enable `qe` latched signal of software write pulse
      hwre:     "true",
      fields: [
        {
          bits: "5+3:5", // 2 bits for status
          name: "CL_STATUS",
          desc: "Contain the current status of the corresponding cache line                [0]: valid, [1]: dirty, [2]: cmpt",
        }
      ]
    },
    { name:     "TAG_1001",
      desc:     "Tag Address stored in cache line 1001",
      swaccess: "rw",
      hwaccess: "hrw",
      hwext:    "true",
      hwqe:     "true", // enable `qe` latched signal of software write pulse
      hwre:     "true",
      fields: [
        { bits: "5-1:0",
          name: "CL_TAG",
          desc: "Tag Address"
        }
      ]
    },
    {
      name:     "STATUS_1002",
      desc:     "Status register of cache line 1002",
      swaccess: "rw",
      hwaccess: "hrw",
      hwext:    "true",
      hwqe:     "true", // enable `qe` latched signal of software write pulse
      hwre:     "true",
      fields: [
        {
          bits: "5+3:5", // 2 bits for status
          name: "CL_STATUS",
          desc: "Contain the current status of the corresponding cache line                [0]: valid, [1]: dirty, [2]: cmpt",
        }
      ]
    },
    { name:     "TAG_1002",
      desc:     "Tag Address stored in cache line 1002",
      swaccess: "rw",
      hwaccess: "hrw",
      hwext:    "true",
      hwqe:     "true", // enable `qe` latched signal of software write pulse
      hwre:     "true",
      fields: [
        { bits: "5-1:0",
          name: "CL_TAG",
          desc: "Tag Address"
        }
      ]
    },
    {
      name:     "STATUS_1003",
      desc:     "Status register of cache line 1003",
      swaccess: "rw",
      hwaccess: "hrw",
      hwext:    "true",
      hwqe:     "true", // enable `qe` latched signal of software write pulse
      hwre:     "true",
      fields: [
        {
          bits: "5+3:5", // 2 bits for status
          name: "CL_STATUS",
          desc: "Contain the current status of the corresponding cache line                [0]: valid, [1]: dirty, [2]: cmpt",
        }
      ]
    },
    { name:     "TAG_1003",
      desc:     "Tag Address stored in cache line 1003",
      swaccess: "rw",
      hwaccess: "hrw",
      hwext:    "true",
      hwqe:     "true", // enable `qe` latched signal of software write pulse
      hwre:     "true",
      fields: [
        { bits: "5-1:0",
          name: "CL_TAG",
          desc: "Tag Address"
        }
      ]
    },
    {
      name:     "STATUS_1004",
      desc:     "Status register of cache line 1004",
      swaccess: "rw",
      hwaccess: "hrw",
      hwext:    "true",
      hwqe:     "true", // enable `qe` latched signal of software write pulse
      hwre:     "true",
      fields: [
        {
          bits: "5+3:5", // 2 bits for status
          name: "CL_STATUS",
          desc: "Contain the current status of the corresponding cache line                [0]: valid, [1]: dirty, [2]: cmpt",
        }
      ]
    },
    { name:     "TAG_1004",
      desc:     "Tag Address stored in cache line 1004",
      swaccess: "rw",
      hwaccess: "hrw",
      hwext:    "true",
      hwqe:     "true", // enable `qe` latched signal of software write pulse
      hwre:     "true",
      fields: [
        { bits: "5-1:0",
          name: "CL_TAG",
          desc: "Tag Address"
        }
      ]
    },
    {
      name:     "STATUS_1005",
      desc:     "Status register of cache line 1005",
      swaccess: "rw",
      hwaccess: "hrw",
      hwext:    "true",
      hwqe:     "true", // enable `qe` latched signal of software write pulse
      hwre:     "true",
      fields: [
        {
          bits: "5+3:5", // 2 bits for status
          name: "CL_STATUS",
          desc: "Contain the current status of the corresponding cache line                [0]: valid, [1]: dirty, [2]: cmpt",
        }
      ]
    },
    { name:     "TAG_1005",
      desc:     "Tag Address stored in cache line 1005",
      swaccess: "rw",
      hwaccess: "hrw",
      hwext:    "true",
      hwqe:     "true", // enable `qe` latched signal of software write pulse
      hwre:     "true",
      fields: [
        { bits: "5-1:0",
          name: "CL_TAG",
          desc: "Tag Address"
        }
      ]
    },
    {
      name:     "STATUS_1006",
      desc:     "Status register of cache line 1006",
      swaccess: "rw",
      hwaccess: "hrw",
      hwext:    "true",
      hwqe:     "true", // enable `qe` latched signal of software write pulse
      hwre:     "true",
      fields: [
        {
          bits: "5+3:5", // 2 bits for status
          name: "CL_STATUS",
          desc: "Contain the current status of the corresponding cache line                [0]: valid, [1]: dirty, [2]: cmpt",
        }
      ]
    },
    { name:     "TAG_1006",
      desc:     "Tag Address stored in cache line 1006",
      swaccess: "rw",
      hwaccess: "hrw",
      hwext:    "true",
      hwqe:     "true", // enable `qe` latched signal of software write pulse
      hwre:     "true",
      fields: [
        { bits: "5-1:0",
          name: "CL_TAG",
          desc: "Tag Address"
        }
      ]
    },
    {
      name:     "STATUS_1007",
      desc:     "Status register of cache line 1007",
      swaccess: "rw",
      hwaccess: "hrw",
      hwext:    "true",
      hwqe:     "true", // enable `qe` latched signal of software write pulse
      hwre:     "true",
      fields: [
        {
          bits: "5+3:5", // 2 bits for status
          name: "CL_STATUS",
          desc: "Contain the current status of the corresponding cache line                [0]: valid, [1]: dirty, [2]: cmpt",
        }
      ]
    },
    { name:     "TAG_1007",
      desc:     "Tag Address stored in cache line 1007",
      swaccess: "rw",
      hwaccess: "hrw",
      hwext:    "true",
      hwqe:     "true", // enable `qe` latched signal of software write pulse
      hwre:     "true",
      fields: [
        { bits: "5-1:0",
          name: "CL_TAG",
          desc: "Tag Address"
        }
      ]
    },
    {
      name:     "STATUS_1008",
      desc:     "Status register of cache line 1008",
      swaccess: "rw",
      hwaccess: "hrw",
      hwext:    "true",
      hwqe:     "true", // enable `qe` latched signal of software write pulse
      hwre:     "true",
      fields: [
        {
          bits: "5+3:5", // 2 bits for status
          name: "CL_STATUS",
          desc: "Contain the current status of the corresponding cache line                [0]: valid, [1]: dirty, [2]: cmpt",
        }
      ]
    },
    { name:     "TAG_1008",
      desc:     "Tag Address stored in cache line 1008",
      swaccess: "rw",
      hwaccess: "hrw",
      hwext:    "true",
      hwqe:     "true", // enable `qe` latched signal of software write pulse
      hwre:     "true",
      fields: [
        { bits: "5-1:0",
          name: "CL_TAG",
          desc: "Tag Address"
        }
      ]
    },
    {
      name:     "STATUS_1009",
      desc:     "Status register of cache line 1009",
      swaccess: "rw",
      hwaccess: "hrw",
      hwext:    "true",
      hwqe:     "true", // enable `qe` latched signal of software write pulse
      hwre:     "true",
      fields: [
        {
          bits: "5+3:5", // 2 bits for status
          name: "CL_STATUS",
          desc: "Contain the current status of the corresponding cache line                [0]: valid, [1]: dirty, [2]: cmpt",
        }
      ]
    },
    { name:     "TAG_1009",
      desc:     "Tag Address stored in cache line 1009",
      swaccess: "rw",
      hwaccess: "hrw",
      hwext:    "true",
      hwqe:     "true", // enable `qe` latched signal of software write pulse
      hwre:     "true",
      fields: [
        { bits: "5-1:0",
          name: "CL_TAG",
          desc: "Tag Address"
        }
      ]
    },
    {
      name:     "STATUS_1010",
      desc:     "Status register of cache line 1010",
      swaccess: "rw",
      hwaccess: "hrw",
      hwext:    "true",
      hwqe:     "true", // enable `qe` latched signal of software write pulse
      hwre:     "true",
      fields: [
        {
          bits: "5+3:5", // 2 bits for status
          name: "CL_STATUS",
          desc: "Contain the current status of the corresponding cache line                [0]: valid, [1]: dirty, [2]: cmpt",
        }
      ]
    },
    { name:     "TAG_1010",
      desc:     "Tag Address stored in cache line 1010",
      swaccess: "rw",
      hwaccess: "hrw",
      hwext:    "true",
      hwqe:     "true", // enable `qe` latched signal of software write pulse
      hwre:     "true",
      fields: [
        { bits: "5-1:0",
          name: "CL_TAG",
          desc: "Tag Address"
        }
      ]
    },
    {
      name:     "STATUS_1011",
      desc:     "Status register of cache line 1011",
      swaccess: "rw",
      hwaccess: "hrw",
      hwext:    "true",
      hwqe:     "true", // enable `qe` latched signal of software write pulse
      hwre:     "true",
      fields: [
        {
          bits: "5+3:5", // 2 bits for status
          name: "CL_STATUS",
          desc: "Contain the current status of the corresponding cache line                [0]: valid, [1]: dirty, [2]: cmpt",
        }
      ]
    },
    { name:     "TAG_1011",
      desc:     "Tag Address stored in cache line 1011",
      swaccess: "rw",
      hwaccess: "hrw",
      hwext:    "true",
      hwqe:     "true", // enable `qe` latched signal of software write pulse
      hwre:     "true",
      fields: [
        { bits: "5-1:0",
          name: "CL_TAG",
          desc: "Tag Address"
        }
      ]
    },
    {
      name:     "STATUS_1012",
      desc:     "Status register of cache line 1012",
      swaccess: "rw",
      hwaccess: "hrw",
      hwext:    "true",
      hwqe:     "true", // enable `qe` latched signal of software write pulse
      hwre:     "true",
      fields: [
        {
          bits: "5+3:5", // 2 bits for status
          name: "CL_STATUS",
          desc: "Contain the current status of the corresponding cache line                [0]: valid, [1]: dirty, [2]: cmpt",
        }
      ]
    },
    { name:     "TAG_1012",
      desc:     "Tag Address stored in cache line 1012",
      swaccess: "rw",
      hwaccess: "hrw",
      hwext:    "true",
      hwqe:     "true", // enable `qe` latched signal of software write pulse
      hwre:     "true",
      fields: [
        { bits: "5-1:0",
          name: "CL_TAG",
          desc: "Tag Address"
        }
      ]
    },
    {
      name:     "STATUS_1013",
      desc:     "Status register of cache line 1013",
      swaccess: "rw",
      hwaccess: "hrw",
      hwext:    "true",
      hwqe:     "true", // enable `qe` latched signal of software write pulse
      hwre:     "true",
      fields: [
        {
          bits: "5+3:5", // 2 bits for status
          name: "CL_STATUS",
          desc: "Contain the current status of the corresponding cache line                [0]: valid, [1]: dirty, [2]: cmpt",
        }
      ]
    },
    { name:     "TAG_1013",
      desc:     "Tag Address stored in cache line 1013",
      swaccess: "rw",
      hwaccess: "hrw",
      hwext:    "true",
      hwqe:     "true", // enable `qe` latched signal of software write pulse
      hwre:     "true",
      fields: [
        { bits: "5-1:0",
          name: "CL_TAG",
          desc: "Tag Address"
        }
      ]
    },
    {
      name:     "STATUS_1014",
      desc:     "Status register of cache line 1014",
      swaccess: "rw",
      hwaccess: "hrw",
      hwext:    "true",
      hwqe:     "true", // enable `qe` latched signal of software write pulse
      hwre:     "true",
      fields: [
        {
          bits: "5+3:5", // 2 bits for status
          name: "CL_STATUS",
          desc: "Contain the current status of the corresponding cache line                [0]: valid, [1]: dirty, [2]: cmpt",
        }
      ]
    },
    { name:     "TAG_1014",
      desc:     "Tag Address stored in cache line 1014",
      swaccess: "rw",
      hwaccess: "hrw",
      hwext:    "true",
      hwqe:     "true", // enable `qe` latched signal of software write pulse
      hwre:     "true",
      fields: [
        { bits: "5-1:0",
          name: "CL_TAG",
          desc: "Tag Address"
        }
      ]
    },
    {
      name:     "STATUS_1015",
      desc:     "Status register of cache line 1015",
      swaccess: "rw",
      hwaccess: "hrw",
      hwext:    "true",
      hwqe:     "true", // enable `qe` latched signal of software write pulse
      hwre:     "true",
      fields: [
        {
          bits: "5+3:5", // 2 bits for status
          name: "CL_STATUS",
          desc: "Contain the current status of the corresponding cache line                [0]: valid, [1]: dirty, [2]: cmpt",
        }
      ]
    },
    { name:     "TAG_1015",
      desc:     "Tag Address stored in cache line 1015",
      swaccess: "rw",
      hwaccess: "hrw",
      hwext:    "true",
      hwqe:     "true", // enable `qe` latched signal of software write pulse
      hwre:     "true",
      fields: [
        { bits: "5-1:0",
          name: "CL_TAG",
          desc: "Tag Address"
        }
      ]
    },
    {
      name:     "STATUS_1016",
      desc:     "Status register of cache line 1016",
      swaccess: "rw",
      hwaccess: "hrw",
      hwext:    "true",
      hwqe:     "true", // enable `qe` latched signal of software write pulse
      hwre:     "true",
      fields: [
        {
          bits: "5+3:5", // 2 bits for status
          name: "CL_STATUS",
          desc: "Contain the current status of the corresponding cache line                [0]: valid, [1]: dirty, [2]: cmpt",
        }
      ]
    },
    { name:     "TAG_1016",
      desc:     "Tag Address stored in cache line 1016",
      swaccess: "rw",
      hwaccess: "hrw",
      hwext:    "true",
      hwqe:     "true", // enable `qe` latched signal of software write pulse
      hwre:     "true",
      fields: [
        { bits: "5-1:0",
          name: "CL_TAG",
          desc: "Tag Address"
        }
      ]
    },
    {
      name:     "STATUS_1017",
      desc:     "Status register of cache line 1017",
      swaccess: "rw",
      hwaccess: "hrw",
      hwext:    "true",
      hwqe:     "true", // enable `qe` latched signal of software write pulse
      hwre:     "true",
      fields: [
        {
          bits: "5+3:5", // 2 bits for status
          name: "CL_STATUS",
          desc: "Contain the current status of the corresponding cache line                [0]: valid, [1]: dirty, [2]: cmpt",
        }
      ]
    },
    { name:     "TAG_1017",
      desc:     "Tag Address stored in cache line 1017",
      swaccess: "rw",
      hwaccess: "hrw",
      hwext:    "true",
      hwqe:     "true", // enable `qe` latched signal of software write pulse
      hwre:     "true",
      fields: [
        { bits: "5-1:0",
          name: "CL_TAG",
          desc: "Tag Address"
        }
      ]
    },
    {
      name:     "STATUS_1018",
      desc:     "Status register of cache line 1018",
      swaccess: "rw",
      hwaccess: "hrw",
      hwext:    "true",
      hwqe:     "true", // enable `qe` latched signal of software write pulse
      hwre:     "true",
      fields: [
        {
          bits: "5+3:5", // 2 bits for status
          name: "CL_STATUS",
          desc: "Contain the current status of the corresponding cache line                [0]: valid, [1]: dirty, [2]: cmpt",
        }
      ]
    },
    { name:     "TAG_1018",
      desc:     "Tag Address stored in cache line 1018",
      swaccess: "rw",
      hwaccess: "hrw",
      hwext:    "true",
      hwqe:     "true", // enable `qe` latched signal of software write pulse
      hwre:     "true",
      fields: [
        { bits: "5-1:0",
          name: "CL_TAG",
          desc: "Tag Address"
        }
      ]
    },
    {
      name:     "STATUS_1019",
      desc:     "Status register of cache line 1019",
      swaccess: "rw",
      hwaccess: "hrw",
      hwext:    "true",
      hwqe:     "true", // enable `qe` latched signal of software write pulse
      hwre:     "true",
      fields: [
        {
          bits: "5+3:5", // 2 bits for status
          name: "CL_STATUS",
          desc: "Contain the current status of the corresponding cache line                [0]: valid, [1]: dirty, [2]: cmpt",
        }
      ]
    },
    { name:     "TAG_1019",
      desc:     "Tag Address stored in cache line 1019",
      swaccess: "rw",
      hwaccess: "hrw",
      hwext:    "true",
      hwqe:     "true", // enable `qe` latched signal of software write pulse
      hwre:     "true",
      fields: [
        { bits: "5-1:0",
          name: "CL_TAG",
          desc: "Tag Address"
        }
      ]
    },
    {
      name:     "STATUS_1020",
      desc:     "Status register of cache line 1020",
      swaccess: "rw",
      hwaccess: "hrw",
      hwext:    "true",
      hwqe:     "true", // enable `qe` latched signal of software write pulse
      hwre:     "true",
      fields: [
        {
          bits: "5+3:5", // 2 bits for status
          name: "CL_STATUS",
          desc: "Contain the current status of the corresponding cache line                [0]: valid, [1]: dirty, [2]: cmpt",
        }
      ]
    },
    { name:     "TAG_1020",
      desc:     "Tag Address stored in cache line 1020",
      swaccess: "rw",
      hwaccess: "hrw",
      hwext:    "true",
      hwqe:     "true", // enable `qe` latched signal of software write pulse
      hwre:     "true",
      fields: [
        { bits: "5-1:0",
          name: "CL_TAG",
          desc: "Tag Address"
        }
      ]
    },
    {
      name:     "STATUS_1021",
      desc:     "Status register of cache line 1021",
      swaccess: "rw",
      hwaccess: "hrw",
      hwext:    "true",
      hwqe:     "true", // enable `qe` latched signal of software write pulse
      hwre:     "true",
      fields: [
        {
          bits: "5+3:5", // 2 bits for status
          name: "CL_STATUS",
          desc: "Contain the current status of the corresponding cache line                [0]: valid, [1]: dirty, [2]: cmpt",
        }
      ]
    },
    { name:     "TAG_1021",
      desc:     "Tag Address stored in cache line 1021",
      swaccess: "rw",
      hwaccess: "hrw",
      hwext:    "true",
      hwqe:     "true", // enable `qe` latched signal of software write pulse
      hwre:     "true",
      fields: [
        { bits: "5-1:0",
          name: "CL_TAG",
          desc: "Tag Address"
        }
      ]
    },
    {
      name:     "STATUS_1022",
      desc:     "Status register of cache line 1022",
      swaccess: "rw",
      hwaccess: "hrw",
      hwext:    "true",
      hwqe:     "true", // enable `qe` latched signal of software write pulse
      hwre:     "true",
      fields: [
        {
          bits: "5+3:5", // 2 bits for status
          name: "CL_STATUS",
          desc: "Contain the current status of the corresponding cache line                [0]: valid, [1]: dirty, [2]: cmpt",
        }
      ]
    },
    { name:     "TAG_1022",
      desc:     "Tag Address stored in cache line 1022",
      swaccess: "rw",
      hwaccess: "hrw",
      hwext:    "true",
      hwqe:     "true", // enable `qe` latched signal of software write pulse
      hwre:     "true",
      fields: [
        { bits: "5-1:0",
          name: "CL_TAG",
          desc: "Tag Address"
        }
      ]
    },
    {
      name:     "STATUS_1023",
      desc:     "Status register of cache line 1023",
      swaccess: "rw",
      hwaccess: "hrw",
      hwext:    "true",
      hwqe:     "true", // enable `qe` latched signal of software write pulse
      hwre:     "true",
      fields: [
        {
          bits: "5+3:5", // 2 bits for status
          name: "CL_STATUS",
          desc: "Contain the current status of the corresponding cache line                [0]: valid, [1]: dirty, [2]: cmpt",
        }
      ]
    },
    { name:     "TAG_1023",
      desc:     "Tag Address stored in cache line 1023",
      swaccess: "rw",
      hwaccess: "hrw",
      hwext:    "true",
      hwqe:     "true", // enable `qe` latched signal of software write pulse
      hwre:     "true",
      fields: [
        { bits: "5-1:0",
          name: "CL_TAG",
          desc: "Tag Address"
        }
      ]
    },
    {
      name:     "STATUS_1024",
      desc:     "Status register of cache line 1024",
      swaccess: "rw",
      hwaccess: "hrw",
      hwext:    "true",
      hwqe:     "true", // enable `qe` latched signal of software write pulse
      hwre:     "true",
      fields: [
        {
          bits: "5+3:5", // 2 bits for status
          name: "CL_STATUS",
          desc: "Contain the current status of the corresponding cache line                [0]: valid, [1]: dirty, [2]: cmpt",
        }
      ]
    },
    { name:     "TAG_1024",
      desc:     "Tag Address stored in cache line 1024",
      swaccess: "rw",
      hwaccess: "hrw",
      hwext:    "true",
      hwqe:     "true", // enable `qe` latched signal of software write pulse
      hwre:     "true",
      fields: [
        { bits: "5-1:0",
          name: "CL_TAG",
          desc: "Tag Address"
        }
      ]
    },
    {
      name:     "STATUS_1025",
      desc:     "Status register of cache line 1025",
      swaccess: "rw",
      hwaccess: "hrw",
      hwext:    "true",
      hwqe:     "true", // enable `qe` latched signal of software write pulse
      hwre:     "true",
      fields: [
        {
          bits: "5+3:5", // 2 bits for status
          name: "CL_STATUS",
          desc: "Contain the current status of the corresponding cache line                [0]: valid, [1]: dirty, [2]: cmpt",
        }
      ]
    },
    { name:     "TAG_1025",
      desc:     "Tag Address stored in cache line 1025",
      swaccess: "rw",
      hwaccess: "hrw",
      hwext:    "true",
      hwqe:     "true", // enable `qe` latched signal of software write pulse
      hwre:     "true",
      fields: [
        { bits: "5-1:0",
          name: "CL_TAG",
          desc: "Tag Address"
        }
      ]
    },
    {
      name:     "STATUS_1026",
      desc:     "Status register of cache line 1026",
      swaccess: "rw",
      hwaccess: "hrw",
      hwext:    "true",
      hwqe:     "true", // enable `qe` latched signal of software write pulse
      hwre:     "true",
      fields: [
        {
          bits: "5+3:5", // 2 bits for status
          name: "CL_STATUS",
          desc: "Contain the current status of the corresponding cache line                [0]: valid, [1]: dirty, [2]: cmpt",
        }
      ]
    },
    { name:     "TAG_1026",
      desc:     "Tag Address stored in cache line 1026",
      swaccess: "rw",
      hwaccess: "hrw",
      hwext:    "true",
      hwqe:     "true", // enable `qe` latched signal of software write pulse
      hwre:     "true",
      fields: [
        { bits: "5-1:0",
          name: "CL_TAG",
          desc: "Tag Address"
        }
      ]
    },
    {
      name:     "STATUS_1027",
      desc:     "Status register of cache line 1027",
      swaccess: "rw",
      hwaccess: "hrw",
      hwext:    "true",
      hwqe:     "true", // enable `qe` latched signal of software write pulse
      hwre:     "true",
      fields: [
        {
          bits: "5+3:5", // 2 bits for status
          name: "CL_STATUS",
          desc: "Contain the current status of the corresponding cache line                [0]: valid, [1]: dirty, [2]: cmpt",
        }
      ]
    },
    { name:     "TAG_1027",
      desc:     "Tag Address stored in cache line 1027",
      swaccess: "rw",
      hwaccess: "hrw",
      hwext:    "true",
      hwqe:     "true", // enable `qe` latched signal of software write pulse
      hwre:     "true",
      fields: [
        { bits: "5-1:0",
          name: "CL_TAG",
          desc: "Tag Address"
        }
      ]
    },
    {
      name:     "STATUS_1028",
      desc:     "Status register of cache line 1028",
      swaccess: "rw",
      hwaccess: "hrw",
      hwext:    "true",
      hwqe:     "true", // enable `qe` latched signal of software write pulse
      hwre:     "true",
      fields: [
        {
          bits: "5+3:5", // 2 bits for status
          name: "CL_STATUS",
          desc: "Contain the current status of the corresponding cache line                [0]: valid, [1]: dirty, [2]: cmpt",
        }
      ]
    },
    { name:     "TAG_1028",
      desc:     "Tag Address stored in cache line 1028",
      swaccess: "rw",
      hwaccess: "hrw",
      hwext:    "true",
      hwqe:     "true", // enable `qe` latched signal of software write pulse
      hwre:     "true",
      fields: [
        { bits: "5-1:0",
          name: "CL_TAG",
          desc: "Tag Address"
        }
      ]
    },
    {
      name:     "STATUS_1029",
      desc:     "Status register of cache line 1029",
      swaccess: "rw",
      hwaccess: "hrw",
      hwext:    "true",
      hwqe:     "true", // enable `qe` latched signal of software write pulse
      hwre:     "true",
      fields: [
        {
          bits: "5+3:5", // 2 bits for status
          name: "CL_STATUS",
          desc: "Contain the current status of the corresponding cache line                [0]: valid, [1]: dirty, [2]: cmpt",
        }
      ]
    },
    { name:     "TAG_1029",
      desc:     "Tag Address stored in cache line 1029",
      swaccess: "rw",
      hwaccess: "hrw",
      hwext:    "true",
      hwqe:     "true", // enable `qe` latched signal of software write pulse
      hwre:     "true",
      fields: [
        { bits: "5-1:0",
          name: "CL_TAG",
          desc: "Tag Address"
        }
      ]
    },
    {
      name:     "STATUS_1030",
      desc:     "Status register of cache line 1030",
      swaccess: "rw",
      hwaccess: "hrw",
      hwext:    "true",
      hwqe:     "true", // enable `qe` latched signal of software write pulse
      hwre:     "true",
      fields: [
        {
          bits: "5+3:5", // 2 bits for status
          name: "CL_STATUS",
          desc: "Contain the current status of the corresponding cache line                [0]: valid, [1]: dirty, [2]: cmpt",
        }
      ]
    },
    { name:     "TAG_1030",
      desc:     "Tag Address stored in cache line 1030",
      swaccess: "rw",
      hwaccess: "hrw",
      hwext:    "true",
      hwqe:     "true", // enable `qe` latched signal of software write pulse
      hwre:     "true",
      fields: [
        { bits: "5-1:0",
          name: "CL_TAG",
          desc: "Tag Address"
        }
      ]
    },
    {
      name:     "STATUS_1031",
      desc:     "Status register of cache line 1031",
      swaccess: "rw",
      hwaccess: "hrw",
      hwext:    "true",
      hwqe:     "true", // enable `qe` latched signal of software write pulse
      hwre:     "true",
      fields: [
        {
          bits: "5+3:5", // 2 bits for status
          name: "CL_STATUS",
          desc: "Contain the current status of the corresponding cache line                [0]: valid, [1]: dirty, [2]: cmpt",
        }
      ]
    },
    { name:     "TAG_1031",
      desc:     "Tag Address stored in cache line 1031",
      swaccess: "rw",
      hwaccess: "hrw",
      hwext:    "true",
      hwqe:     "true", // enable `qe` latched signal of software write pulse
      hwre:     "true",
      fields: [
        { bits: "5-1:0",
          name: "CL_TAG",
          desc: "Tag Address"
        }
      ]
    },
    {
      name:     "STATUS_1032",
      desc:     "Status register of cache line 1032",
      swaccess: "rw",
      hwaccess: "hrw",
      hwext:    "true",
      hwqe:     "true", // enable `qe` latched signal of software write pulse
      hwre:     "true",
      fields: [
        {
          bits: "5+3:5", // 2 bits for status
          name: "CL_STATUS",
          desc: "Contain the current status of the corresponding cache line                [0]: valid, [1]: dirty, [2]: cmpt",
        }
      ]
    },
    { name:     "TAG_1032",
      desc:     "Tag Address stored in cache line 1032",
      swaccess: "rw",
      hwaccess: "hrw",
      hwext:    "true",
      hwqe:     "true", // enable `qe` latched signal of software write pulse
      hwre:     "true",
      fields: [
        { bits: "5-1:0",
          name: "CL_TAG",
          desc: "Tag Address"
        }
      ]
    },
    {
      name:     "STATUS_1033",
      desc:     "Status register of cache line 1033",
      swaccess: "rw",
      hwaccess: "hrw",
      hwext:    "true",
      hwqe:     "true", // enable `qe` latched signal of software write pulse
      hwre:     "true",
      fields: [
        {
          bits: "5+3:5", // 2 bits for status
          name: "CL_STATUS",
          desc: "Contain the current status of the corresponding cache line                [0]: valid, [1]: dirty, [2]: cmpt",
        }
      ]
    },
    { name:     "TAG_1033",
      desc:     "Tag Address stored in cache line 1033",
      swaccess: "rw",
      hwaccess: "hrw",
      hwext:    "true",
      hwqe:     "true", // enable `qe` latched signal of software write pulse
      hwre:     "true",
      fields: [
        { bits: "5-1:0",
          name: "CL_TAG",
          desc: "Tag Address"
        }
      ]
    },
    {
      name:     "STATUS_1034",
      desc:     "Status register of cache line 1034",
      swaccess: "rw",
      hwaccess: "hrw",
      hwext:    "true",
      hwqe:     "true", // enable `qe` latched signal of software write pulse
      hwre:     "true",
      fields: [
        {
          bits: "5+3:5", // 2 bits for status
          name: "CL_STATUS",
          desc: "Contain the current status of the corresponding cache line                [0]: valid, [1]: dirty, [2]: cmpt",
        }
      ]
    },
    { name:     "TAG_1034",
      desc:     "Tag Address stored in cache line 1034",
      swaccess: "rw",
      hwaccess: "hrw",
      hwext:    "true",
      hwqe:     "true", // enable `qe` latched signal of software write pulse
      hwre:     "true",
      fields: [
        { bits: "5-1:0",
          name: "CL_TAG",
          desc: "Tag Address"
        }
      ]
    },
    {
      name:     "STATUS_1035",
      desc:     "Status register of cache line 1035",
      swaccess: "rw",
      hwaccess: "hrw",
      hwext:    "true",
      hwqe:     "true", // enable `qe` latched signal of software write pulse
      hwre:     "true",
      fields: [
        {
          bits: "5+3:5", // 2 bits for status
          name: "CL_STATUS",
          desc: "Contain the current status of the corresponding cache line                [0]: valid, [1]: dirty, [2]: cmpt",
        }
      ]
    },
    { name:     "TAG_1035",
      desc:     "Tag Address stored in cache line 1035",
      swaccess: "rw",
      hwaccess: "hrw",
      hwext:    "true",
      hwqe:     "true", // enable `qe` latched signal of software write pulse
      hwre:     "true",
      fields: [
        { bits: "5-1:0",
          name: "CL_TAG",
          desc: "Tag Address"
        }
      ]
    },
    {
      name:     "STATUS_1036",
      desc:     "Status register of cache line 1036",
      swaccess: "rw",
      hwaccess: "hrw",
      hwext:    "true",
      hwqe:     "true", // enable `qe` latched signal of software write pulse
      hwre:     "true",
      fields: [
        {
          bits: "5+3:5", // 2 bits for status
          name: "CL_STATUS",
          desc: "Contain the current status of the corresponding cache line                [0]: valid, [1]: dirty, [2]: cmpt",
        }
      ]
    },
    { name:     "TAG_1036",
      desc:     "Tag Address stored in cache line 1036",
      swaccess: "rw",
      hwaccess: "hrw",
      hwext:    "true",
      hwqe:     "true", // enable `qe` latched signal of software write pulse
      hwre:     "true",
      fields: [
        { bits: "5-1:0",
          name: "CL_TAG",
          desc: "Tag Address"
        }
      ]
    },
    {
      name:     "STATUS_1037",
      desc:     "Status register of cache line 1037",
      swaccess: "rw",
      hwaccess: "hrw",
      hwext:    "true",
      hwqe:     "true", // enable `qe` latched signal of software write pulse
      hwre:     "true",
      fields: [
        {
          bits: "5+3:5", // 2 bits for status
          name: "CL_STATUS",
          desc: "Contain the current status of the corresponding cache line                [0]: valid, [1]: dirty, [2]: cmpt",
        }
      ]
    },
    { name:     "TAG_1037",
      desc:     "Tag Address stored in cache line 1037",
      swaccess: "rw",
      hwaccess: "hrw",
      hwext:    "true",
      hwqe:     "true", // enable `qe` latched signal of software write pulse
      hwre:     "true",
      fields: [
        { bits: "5-1:0",
          name: "CL_TAG",
          desc: "Tag Address"
        }
      ]
    },
    {
      name:     "STATUS_1038",
      desc:     "Status register of cache line 1038",
      swaccess: "rw",
      hwaccess: "hrw",
      hwext:    "true",
      hwqe:     "true", // enable `qe` latched signal of software write pulse
      hwre:     "true",
      fields: [
        {
          bits: "5+3:5", // 2 bits for status
          name: "CL_STATUS",
          desc: "Contain the current status of the corresponding cache line                [0]: valid, [1]: dirty, [2]: cmpt",
        }
      ]
    },
    { name:     "TAG_1038",
      desc:     "Tag Address stored in cache line 1038",
      swaccess: "rw",
      hwaccess: "hrw",
      hwext:    "true",
      hwqe:     "true", // enable `qe` latched signal of software write pulse
      hwre:     "true",
      fields: [
        { bits: "5-1:0",
          name: "CL_TAG",
          desc: "Tag Address"
        }
      ]
    },
    {
      name:     "STATUS_1039",
      desc:     "Status register of cache line 1039",
      swaccess: "rw",
      hwaccess: "hrw",
      hwext:    "true",
      hwqe:     "true", // enable `qe` latched signal of software write pulse
      hwre:     "true",
      fields: [
        {
          bits: "5+3:5", // 2 bits for status
          name: "CL_STATUS",
          desc: "Contain the current status of the corresponding cache line                [0]: valid, [1]: dirty, [2]: cmpt",
        }
      ]
    },
    { name:     "TAG_1039",
      desc:     "Tag Address stored in cache line 1039",
      swaccess: "rw",
      hwaccess: "hrw",
      hwext:    "true",
      hwqe:     "true", // enable `qe` latched signal of software write pulse
      hwre:     "true",
      fields: [
        { bits: "5-1:0",
          name: "CL_TAG",
          desc: "Tag Address"
        }
      ]
    },
    {
      name:     "STATUS_1040",
      desc:     "Status register of cache line 1040",
      swaccess: "rw",
      hwaccess: "hrw",
      hwext:    "true",
      hwqe:     "true", // enable `qe` latched signal of software write pulse
      hwre:     "true",
      fields: [
        {
          bits: "5+3:5", // 2 bits for status
          name: "CL_STATUS",
          desc: "Contain the current status of the corresponding cache line                [0]: valid, [1]: dirty, [2]: cmpt",
        }
      ]
    },
    { name:     "TAG_1040",
      desc:     "Tag Address stored in cache line 1040",
      swaccess: "rw",
      hwaccess: "hrw",
      hwext:    "true",
      hwqe:     "true", // enable `qe` latched signal of software write pulse
      hwre:     "true",
      fields: [
        { bits: "5-1:0",
          name: "CL_TAG",
          desc: "Tag Address"
        }
      ]
    },
    {
      name:     "STATUS_1041",
      desc:     "Status register of cache line 1041",
      swaccess: "rw",
      hwaccess: "hrw",
      hwext:    "true",
      hwqe:     "true", // enable `qe` latched signal of software write pulse
      hwre:     "true",
      fields: [
        {
          bits: "5+3:5", // 2 bits for status
          name: "CL_STATUS",
          desc: "Contain the current status of the corresponding cache line                [0]: valid, [1]: dirty, [2]: cmpt",
        }
      ]
    },
    { name:     "TAG_1041",
      desc:     "Tag Address stored in cache line 1041",
      swaccess: "rw",
      hwaccess: "hrw",
      hwext:    "true",
      hwqe:     "true", // enable `qe` latched signal of software write pulse
      hwre:     "true",
      fields: [
        { bits: "5-1:0",
          name: "CL_TAG",
          desc: "Tag Address"
        }
      ]
    },
    {
      name:     "STATUS_1042",
      desc:     "Status register of cache line 1042",
      swaccess: "rw",
      hwaccess: "hrw",
      hwext:    "true",
      hwqe:     "true", // enable `qe` latched signal of software write pulse
      hwre:     "true",
      fields: [
        {
          bits: "5+3:5", // 2 bits for status
          name: "CL_STATUS",
          desc: "Contain the current status of the corresponding cache line                [0]: valid, [1]: dirty, [2]: cmpt",
        }
      ]
    },
    { name:     "TAG_1042",
      desc:     "Tag Address stored in cache line 1042",
      swaccess: "rw",
      hwaccess: "hrw",
      hwext:    "true",
      hwqe:     "true", // enable `qe` latched signal of software write pulse
      hwre:     "true",
      fields: [
        { bits: "5-1:0",
          name: "CL_TAG",
          desc: "Tag Address"
        }
      ]
    },
    {
      name:     "STATUS_1043",
      desc:     "Status register of cache line 1043",
      swaccess: "rw",
      hwaccess: "hrw",
      hwext:    "true",
      hwqe:     "true", // enable `qe` latched signal of software write pulse
      hwre:     "true",
      fields: [
        {
          bits: "5+3:5", // 2 bits for status
          name: "CL_STATUS",
          desc: "Contain the current status of the corresponding cache line                [0]: valid, [1]: dirty, [2]: cmpt",
        }
      ]
    },
    { name:     "TAG_1043",
      desc:     "Tag Address stored in cache line 1043",
      swaccess: "rw",
      hwaccess: "hrw",
      hwext:    "true",
      hwqe:     "true", // enable `qe` latched signal of software write pulse
      hwre:     "true",
      fields: [
        { bits: "5-1:0",
          name: "CL_TAG",
          desc: "Tag Address"
        }
      ]
    },
    {
      name:     "STATUS_1044",
      desc:     "Status register of cache line 1044",
      swaccess: "rw",
      hwaccess: "hrw",
      hwext:    "true",
      hwqe:     "true", // enable `qe` latched signal of software write pulse
      hwre:     "true",
      fields: [
        {
          bits: "5+3:5", // 2 bits for status
          name: "CL_STATUS",
          desc: "Contain the current status of the corresponding cache line                [0]: valid, [1]: dirty, [2]: cmpt",
        }
      ]
    },
    { name:     "TAG_1044",
      desc:     "Tag Address stored in cache line 1044",
      swaccess: "rw",
      hwaccess: "hrw",
      hwext:    "true",
      hwqe:     "true", // enable `qe` latched signal of software write pulse
      hwre:     "true",
      fields: [
        { bits: "5-1:0",
          name: "CL_TAG",
          desc: "Tag Address"
        }
      ]
    },
    {
      name:     "STATUS_1045",
      desc:     "Status register of cache line 1045",
      swaccess: "rw",
      hwaccess: "hrw",
      hwext:    "true",
      hwqe:     "true", // enable `qe` latched signal of software write pulse
      hwre:     "true",
      fields: [
        {
          bits: "5+3:5", // 2 bits for status
          name: "CL_STATUS",
          desc: "Contain the current status of the corresponding cache line                [0]: valid, [1]: dirty, [2]: cmpt",
        }
      ]
    },
    { name:     "TAG_1045",
      desc:     "Tag Address stored in cache line 1045",
      swaccess: "rw",
      hwaccess: "hrw",
      hwext:    "true",
      hwqe:     "true", // enable `qe` latched signal of software write pulse
      hwre:     "true",
      fields: [
        { bits: "5-1:0",
          name: "CL_TAG",
          desc: "Tag Address"
        }
      ]
    },
    {
      name:     "STATUS_1046",
      desc:     "Status register of cache line 1046",
      swaccess: "rw",
      hwaccess: "hrw",
      hwext:    "true",
      hwqe:     "true", // enable `qe` latched signal of software write pulse
      hwre:     "true",
      fields: [
        {
          bits: "5+3:5", // 2 bits for status
          name: "CL_STATUS",
          desc: "Contain the current status of the corresponding cache line                [0]: valid, [1]: dirty, [2]: cmpt",
        }
      ]
    },
    { name:     "TAG_1046",
      desc:     "Tag Address stored in cache line 1046",
      swaccess: "rw",
      hwaccess: "hrw",
      hwext:    "true",
      hwqe:     "true", // enable `qe` latched signal of software write pulse
      hwre:     "true",
      fields: [
        { bits: "5-1:0",
          name: "CL_TAG",
          desc: "Tag Address"
        }
      ]
    },
    {
      name:     "STATUS_1047",
      desc:     "Status register of cache line 1047",
      swaccess: "rw",
      hwaccess: "hrw",
      hwext:    "true",
      hwqe:     "true", // enable `qe` latched signal of software write pulse
      hwre:     "true",
      fields: [
        {
          bits: "5+3:5", // 2 bits for status
          name: "CL_STATUS",
          desc: "Contain the current status of the corresponding cache line                [0]: valid, [1]: dirty, [2]: cmpt",
        }
      ]
    },
    { name:     "TAG_1047",
      desc:     "Tag Address stored in cache line 1047",
      swaccess: "rw",
      hwaccess: "hrw",
      hwext:    "true",
      hwqe:     "true", // enable `qe` latched signal of software write pulse
      hwre:     "true",
      fields: [
        { bits: "5-1:0",
          name: "CL_TAG",
          desc: "Tag Address"
        }
      ]
    },
    {
      name:     "STATUS_1048",
      desc:     "Status register of cache line 1048",
      swaccess: "rw",
      hwaccess: "hrw",
      hwext:    "true",
      hwqe:     "true", // enable `qe` latched signal of software write pulse
      hwre:     "true",
      fields: [
        {
          bits: "5+3:5", // 2 bits for status
          name: "CL_STATUS",
          desc: "Contain the current status of the corresponding cache line                [0]: valid, [1]: dirty, [2]: cmpt",
        }
      ]
    },
    { name:     "TAG_1048",
      desc:     "Tag Address stored in cache line 1048",
      swaccess: "rw",
      hwaccess: "hrw",
      hwext:    "true",
      hwqe:     "true", // enable `qe` latched signal of software write pulse
      hwre:     "true",
      fields: [
        { bits: "5-1:0",
          name: "CL_TAG",
          desc: "Tag Address"
        }
      ]
    },
    {
      name:     "STATUS_1049",
      desc:     "Status register of cache line 1049",
      swaccess: "rw",
      hwaccess: "hrw",
      hwext:    "true",
      hwqe:     "true", // enable `qe` latched signal of software write pulse
      hwre:     "true",
      fields: [
        {
          bits: "5+3:5", // 2 bits for status
          name: "CL_STATUS",
          desc: "Contain the current status of the corresponding cache line                [0]: valid, [1]: dirty, [2]: cmpt",
        }
      ]
    },
    { name:     "TAG_1049",
      desc:     "Tag Address stored in cache line 1049",
      swaccess: "rw",
      hwaccess: "hrw",
      hwext:    "true",
      hwqe:     "true", // enable `qe` latched signal of software write pulse
      hwre:     "true",
      fields: [
        { bits: "5-1:0",
          name: "CL_TAG",
          desc: "Tag Address"
        }
      ]
    },
    {
      name:     "STATUS_1050",
      desc:     "Status register of cache line 1050",
      swaccess: "rw",
      hwaccess: "hrw",
      hwext:    "true",
      hwqe:     "true", // enable `qe` latched signal of software write pulse
      hwre:     "true",
      fields: [
        {
          bits: "5+3:5", // 2 bits for status
          name: "CL_STATUS",
          desc: "Contain the current status of the corresponding cache line                [0]: valid, [1]: dirty, [2]: cmpt",
        }
      ]
    },
    { name:     "TAG_1050",
      desc:     "Tag Address stored in cache line 1050",
      swaccess: "rw",
      hwaccess: "hrw",
      hwext:    "true",
      hwqe:     "true", // enable `qe` latched signal of software write pulse
      hwre:     "true",
      fields: [
        { bits: "5-1:0",
          name: "CL_TAG",
          desc: "Tag Address"
        }
      ]
    },
    {
      name:     "STATUS_1051",
      desc:     "Status register of cache line 1051",
      swaccess: "rw",
      hwaccess: "hrw",
      hwext:    "true",
      hwqe:     "true", // enable `qe` latched signal of software write pulse
      hwre:     "true",
      fields: [
        {
          bits: "5+3:5", // 2 bits for status
          name: "CL_STATUS",
          desc: "Contain the current status of the corresponding cache line                [0]: valid, [1]: dirty, [2]: cmpt",
        }
      ]
    },
    { name:     "TAG_1051",
      desc:     "Tag Address stored in cache line 1051",
      swaccess: "rw",
      hwaccess: "hrw",
      hwext:    "true",
      hwqe:     "true", // enable `qe` latched signal of software write pulse
      hwre:     "true",
      fields: [
        { bits: "5-1:0",
          name: "CL_TAG",
          desc: "Tag Address"
        }
      ]
    },
    {
      name:     "STATUS_1052",
      desc:     "Status register of cache line 1052",
      swaccess: "rw",
      hwaccess: "hrw",
      hwext:    "true",
      hwqe:     "true", // enable `qe` latched signal of software write pulse
      hwre:     "true",
      fields: [
        {
          bits: "5+3:5", // 2 bits for status
          name: "CL_STATUS",
          desc: "Contain the current status of the corresponding cache line                [0]: valid, [1]: dirty, [2]: cmpt",
        }
      ]
    },
    { name:     "TAG_1052",
      desc:     "Tag Address stored in cache line 1052",
      swaccess: "rw",
      hwaccess: "hrw",
      hwext:    "true",
      hwqe:     "true", // enable `qe` latched signal of software write pulse
      hwre:     "true",
      fields: [
        { bits: "5-1:0",
          name: "CL_TAG",
          desc: "Tag Address"
        }
      ]
    },
    {
      name:     "STATUS_1053",
      desc:     "Status register of cache line 1053",
      swaccess: "rw",
      hwaccess: "hrw",
      hwext:    "true",
      hwqe:     "true", // enable `qe` latched signal of software write pulse
      hwre:     "true",
      fields: [
        {
          bits: "5+3:5", // 2 bits for status
          name: "CL_STATUS",
          desc: "Contain the current status of the corresponding cache line                [0]: valid, [1]: dirty, [2]: cmpt",
        }
      ]
    },
    { name:     "TAG_1053",
      desc:     "Tag Address stored in cache line 1053",
      swaccess: "rw",
      hwaccess: "hrw",
      hwext:    "true",
      hwqe:     "true", // enable `qe` latched signal of software write pulse
      hwre:     "true",
      fields: [
        { bits: "5-1:0",
          name: "CL_TAG",
          desc: "Tag Address"
        }
      ]
    },
    {
      name:     "STATUS_1054",
      desc:     "Status register of cache line 1054",
      swaccess: "rw",
      hwaccess: "hrw",
      hwext:    "true",
      hwqe:     "true", // enable `qe` latched signal of software write pulse
      hwre:     "true",
      fields: [
        {
          bits: "5+3:5", // 2 bits for status
          name: "CL_STATUS",
          desc: "Contain the current status of the corresponding cache line                [0]: valid, [1]: dirty, [2]: cmpt",
        }
      ]
    },
    { name:     "TAG_1054",
      desc:     "Tag Address stored in cache line 1054",
      swaccess: "rw",
      hwaccess: "hrw",
      hwext:    "true",
      hwqe:     "true", // enable `qe` latched signal of software write pulse
      hwre:     "true",
      fields: [
        { bits: "5-1:0",
          name: "CL_TAG",
          desc: "Tag Address"
        }
      ]
    },
    {
      name:     "STATUS_1055",
      desc:     "Status register of cache line 1055",
      swaccess: "rw",
      hwaccess: "hrw",
      hwext:    "true",
      hwqe:     "true", // enable `qe` latched signal of software write pulse
      hwre:     "true",
      fields: [
        {
          bits: "5+3:5", // 2 bits for status
          name: "CL_STATUS",
          desc: "Contain the current status of the corresponding cache line                [0]: valid, [1]: dirty, [2]: cmpt",
        }
      ]
    },
    { name:     "TAG_1055",
      desc:     "Tag Address stored in cache line 1055",
      swaccess: "rw",
      hwaccess: "hrw",
      hwext:    "true",
      hwqe:     "true", // enable `qe` latched signal of software write pulse
      hwre:     "true",
      fields: [
        { bits: "5-1:0",
          name: "CL_TAG",
          desc: "Tag Address"
        }
      ]
    },
    {
      name:     "STATUS_1056",
      desc:     "Status register of cache line 1056",
      swaccess: "rw",
      hwaccess: "hrw",
      hwext:    "true",
      hwqe:     "true", // enable `qe` latched signal of software write pulse
      hwre:     "true",
      fields: [
        {
          bits: "5+3:5", // 2 bits for status
          name: "CL_STATUS",
          desc: "Contain the current status of the corresponding cache line                [0]: valid, [1]: dirty, [2]: cmpt",
        }
      ]
    },
    { name:     "TAG_1056",
      desc:     "Tag Address stored in cache line 1056",
      swaccess: "rw",
      hwaccess: "hrw",
      hwext:    "true",
      hwqe:     "true", // enable `qe` latched signal of software write pulse
      hwre:     "true",
      fields: [
        { bits: "5-1:0",
          name: "CL_TAG",
          desc: "Tag Address"
        }
      ]
    },
    {
      name:     "STATUS_1057",
      desc:     "Status register of cache line 1057",
      swaccess: "rw",
      hwaccess: "hrw",
      hwext:    "true",
      hwqe:     "true", // enable `qe` latched signal of software write pulse
      hwre:     "true",
      fields: [
        {
          bits: "5+3:5", // 2 bits for status
          name: "CL_STATUS",
          desc: "Contain the current status of the corresponding cache line                [0]: valid, [1]: dirty, [2]: cmpt",
        }
      ]
    },
    { name:     "TAG_1057",
      desc:     "Tag Address stored in cache line 1057",
      swaccess: "rw",
      hwaccess: "hrw",
      hwext:    "true",
      hwqe:     "true", // enable `qe` latched signal of software write pulse
      hwre:     "true",
      fields: [
        { bits: "5-1:0",
          name: "CL_TAG",
          desc: "Tag Address"
        }
      ]
    },
    {
      name:     "STATUS_1058",
      desc:     "Status register of cache line 1058",
      swaccess: "rw",
      hwaccess: "hrw",
      hwext:    "true",
      hwqe:     "true", // enable `qe` latched signal of software write pulse
      hwre:     "true",
      fields: [
        {
          bits: "5+3:5", // 2 bits for status
          name: "CL_STATUS",
          desc: "Contain the current status of the corresponding cache line                [0]: valid, [1]: dirty, [2]: cmpt",
        }
      ]
    },
    { name:     "TAG_1058",
      desc:     "Tag Address stored in cache line 1058",
      swaccess: "rw",
      hwaccess: "hrw",
      hwext:    "true",
      hwqe:     "true", // enable `qe` latched signal of software write pulse
      hwre:     "true",
      fields: [
        { bits: "5-1:0",
          name: "CL_TAG",
          desc: "Tag Address"
        }
      ]
    },
    {
      name:     "STATUS_1059",
      desc:     "Status register of cache line 1059",
      swaccess: "rw",
      hwaccess: "hrw",
      hwext:    "true",
      hwqe:     "true", // enable `qe` latched signal of software write pulse
      hwre:     "true",
      fields: [
        {
          bits: "5+3:5", // 2 bits for status
          name: "CL_STATUS",
          desc: "Contain the current status of the corresponding cache line                [0]: valid, [1]: dirty, [2]: cmpt",
        }
      ]
    },
    { name:     "TAG_1059",
      desc:     "Tag Address stored in cache line 1059",
      swaccess: "rw",
      hwaccess: "hrw",
      hwext:    "true",
      hwqe:     "true", // enable `qe` latched signal of software write pulse
      hwre:     "true",
      fields: [
        { bits: "5-1:0",
          name: "CL_TAG",
          desc: "Tag Address"
        }
      ]
    },
    {
      name:     "STATUS_1060",
      desc:     "Status register of cache line 1060",
      swaccess: "rw",
      hwaccess: "hrw",
      hwext:    "true",
      hwqe:     "true", // enable `qe` latched signal of software write pulse
      hwre:     "true",
      fields: [
        {
          bits: "5+3:5", // 2 bits for status
          name: "CL_STATUS",
          desc: "Contain the current status of the corresponding cache line                [0]: valid, [1]: dirty, [2]: cmpt",
        }
      ]
    },
    { name:     "TAG_1060",
      desc:     "Tag Address stored in cache line 1060",
      swaccess: "rw",
      hwaccess: "hrw",
      hwext:    "true",
      hwqe:     "true", // enable `qe` latched signal of software write pulse
      hwre:     "true",
      fields: [
        { bits: "5-1:0",
          name: "CL_TAG",
          desc: "Tag Address"
        }
      ]
    },
    {
      name:     "STATUS_1061",
      desc:     "Status register of cache line 1061",
      swaccess: "rw",
      hwaccess: "hrw",
      hwext:    "true",
      hwqe:     "true", // enable `qe` latched signal of software write pulse
      hwre:     "true",
      fields: [
        {
          bits: "5+3:5", // 2 bits for status
          name: "CL_STATUS",
          desc: "Contain the current status of the corresponding cache line                [0]: valid, [1]: dirty, [2]: cmpt",
        }
      ]
    },
    { name:     "TAG_1061",
      desc:     "Tag Address stored in cache line 1061",
      swaccess: "rw",
      hwaccess: "hrw",
      hwext:    "true",
      hwqe:     "true", // enable `qe` latched signal of software write pulse
      hwre:     "true",
      fields: [
        { bits: "5-1:0",
          name: "CL_TAG",
          desc: "Tag Address"
        }
      ]
    },
    {
      name:     "STATUS_1062",
      desc:     "Status register of cache line 1062",
      swaccess: "rw",
      hwaccess: "hrw",
      hwext:    "true",
      hwqe:     "true", // enable `qe` latched signal of software write pulse
      hwre:     "true",
      fields: [
        {
          bits: "5+3:5", // 2 bits for status
          name: "CL_STATUS",
          desc: "Contain the current status of the corresponding cache line                [0]: valid, [1]: dirty, [2]: cmpt",
        }
      ]
    },
    { name:     "TAG_1062",
      desc:     "Tag Address stored in cache line 1062",
      swaccess: "rw",
      hwaccess: "hrw",
      hwext:    "true",
      hwqe:     "true", // enable `qe` latched signal of software write pulse
      hwre:     "true",
      fields: [
        { bits: "5-1:0",
          name: "CL_TAG",
          desc: "Tag Address"
        }
      ]
    },
    {
      name:     "STATUS_1063",
      desc:     "Status register of cache line 1063",
      swaccess: "rw",
      hwaccess: "hrw",
      hwext:    "true",
      hwqe:     "true", // enable `qe` latched signal of software write pulse
      hwre:     "true",
      fields: [
        {
          bits: "5+3:5", // 2 bits for status
          name: "CL_STATUS",
          desc: "Contain the current status of the corresponding cache line                [0]: valid, [1]: dirty, [2]: cmpt",
        }
      ]
    },
    { name:     "TAG_1063",
      desc:     "Tag Address stored in cache line 1063",
      swaccess: "rw",
      hwaccess: "hrw",
      hwext:    "true",
      hwqe:     "true", // enable `qe` latched signal of software write pulse
      hwre:     "true",
      fields: [
        { bits: "5-1:0",
          name: "CL_TAG",
          desc: "Tag Address"
        }
      ]
    },
    {
      name:     "STATUS_1064",
      desc:     "Status register of cache line 1064",
      swaccess: "rw",
      hwaccess: "hrw",
      hwext:    "true",
      hwqe:     "true", // enable `qe` latched signal of software write pulse
      hwre:     "true",
      fields: [
        {
          bits: "5+3:5", // 2 bits for status
          name: "CL_STATUS",
          desc: "Contain the current status of the corresponding cache line                [0]: valid, [1]: dirty, [2]: cmpt",
        }
      ]
    },
    { name:     "TAG_1064",
      desc:     "Tag Address stored in cache line 1064",
      swaccess: "rw",
      hwaccess: "hrw",
      hwext:    "true",
      hwqe:     "true", // enable `qe` latched signal of software write pulse
      hwre:     "true",
      fields: [
        { bits: "5-1:0",
          name: "CL_TAG",
          desc: "Tag Address"
        }
      ]
    },
    {
      name:     "STATUS_1065",
      desc:     "Status register of cache line 1065",
      swaccess: "rw",
      hwaccess: "hrw",
      hwext:    "true",
      hwqe:     "true", // enable `qe` latched signal of software write pulse
      hwre:     "true",
      fields: [
        {
          bits: "5+3:5", // 2 bits for status
          name: "CL_STATUS",
          desc: "Contain the current status of the corresponding cache line                [0]: valid, [1]: dirty, [2]: cmpt",
        }
      ]
    },
    { name:     "TAG_1065",
      desc:     "Tag Address stored in cache line 1065",
      swaccess: "rw",
      hwaccess: "hrw",
      hwext:    "true",
      hwqe:     "true", // enable `qe` latched signal of software write pulse
      hwre:     "true",
      fields: [
        { bits: "5-1:0",
          name: "CL_TAG",
          desc: "Tag Address"
        }
      ]
    },
    {
      name:     "STATUS_1066",
      desc:     "Status register of cache line 1066",
      swaccess: "rw",
      hwaccess: "hrw",
      hwext:    "true",
      hwqe:     "true", // enable `qe` latched signal of software write pulse
      hwre:     "true",
      fields: [
        {
          bits: "5+3:5", // 2 bits for status
          name: "CL_STATUS",
          desc: "Contain the current status of the corresponding cache line                [0]: valid, [1]: dirty, [2]: cmpt",
        }
      ]
    },
    { name:     "TAG_1066",
      desc:     "Tag Address stored in cache line 1066",
      swaccess: "rw",
      hwaccess: "hrw",
      hwext:    "true",
      hwqe:     "true", // enable `qe` latched signal of software write pulse
      hwre:     "true",
      fields: [
        { bits: "5-1:0",
          name: "CL_TAG",
          desc: "Tag Address"
        }
      ]
    },
    {
      name:     "STATUS_1067",
      desc:     "Status register of cache line 1067",
      swaccess: "rw",
      hwaccess: "hrw",
      hwext:    "true",
      hwqe:     "true", // enable `qe` latched signal of software write pulse
      hwre:     "true",
      fields: [
        {
          bits: "5+3:5", // 2 bits for status
          name: "CL_STATUS",
          desc: "Contain the current status of the corresponding cache line                [0]: valid, [1]: dirty, [2]: cmpt",
        }
      ]
    },
    { name:     "TAG_1067",
      desc:     "Tag Address stored in cache line 1067",
      swaccess: "rw",
      hwaccess: "hrw",
      hwext:    "true",
      hwqe:     "true", // enable `qe` latched signal of software write pulse
      hwre:     "true",
      fields: [
        { bits: "5-1:0",
          name: "CL_TAG",
          desc: "Tag Address"
        }
      ]
    },
    {
      name:     "STATUS_1068",
      desc:     "Status register of cache line 1068",
      swaccess: "rw",
      hwaccess: "hrw",
      hwext:    "true",
      hwqe:     "true", // enable `qe` latched signal of software write pulse
      hwre:     "true",
      fields: [
        {
          bits: "5+3:5", // 2 bits for status
          name: "CL_STATUS",
          desc: "Contain the current status of the corresponding cache line                [0]: valid, [1]: dirty, [2]: cmpt",
        }
      ]
    },
    { name:     "TAG_1068",
      desc:     "Tag Address stored in cache line 1068",
      swaccess: "rw",
      hwaccess: "hrw",
      hwext:    "true",
      hwqe:     "true", // enable `qe` latched signal of software write pulse
      hwre:     "true",
      fields: [
        { bits: "5-1:0",
          name: "CL_TAG",
          desc: "Tag Address"
        }
      ]
    },
    {
      name:     "STATUS_1069",
      desc:     "Status register of cache line 1069",
      swaccess: "rw",
      hwaccess: "hrw",
      hwext:    "true",
      hwqe:     "true", // enable `qe` latched signal of software write pulse
      hwre:     "true",
      fields: [
        {
          bits: "5+3:5", // 2 bits for status
          name: "CL_STATUS",
          desc: "Contain the current status of the corresponding cache line                [0]: valid, [1]: dirty, [2]: cmpt",
        }
      ]
    },
    { name:     "TAG_1069",
      desc:     "Tag Address stored in cache line 1069",
      swaccess: "rw",
      hwaccess: "hrw",
      hwext:    "true",
      hwqe:     "true", // enable `qe` latched signal of software write pulse
      hwre:     "true",
      fields: [
        { bits: "5-1:0",
          name: "CL_TAG",
          desc: "Tag Address"
        }
      ]
    },
    {
      name:     "STATUS_1070",
      desc:     "Status register of cache line 1070",
      swaccess: "rw",
      hwaccess: "hrw",
      hwext:    "true",
      hwqe:     "true", // enable `qe` latched signal of software write pulse
      hwre:     "true",
      fields: [
        {
          bits: "5+3:5", // 2 bits for status
          name: "CL_STATUS",
          desc: "Contain the current status of the corresponding cache line                [0]: valid, [1]: dirty, [2]: cmpt",
        }
      ]
    },
    { name:     "TAG_1070",
      desc:     "Tag Address stored in cache line 1070",
      swaccess: "rw",
      hwaccess: "hrw",
      hwext:    "true",
      hwqe:     "true", // enable `qe` latched signal of software write pulse
      hwre:     "true",
      fields: [
        { bits: "5-1:0",
          name: "CL_TAG",
          desc: "Tag Address"
        }
      ]
    },
    {
      name:     "STATUS_1071",
      desc:     "Status register of cache line 1071",
      swaccess: "rw",
      hwaccess: "hrw",
      hwext:    "true",
      hwqe:     "true", // enable `qe` latched signal of software write pulse
      hwre:     "true",
      fields: [
        {
          bits: "5+3:5", // 2 bits for status
          name: "CL_STATUS",
          desc: "Contain the current status of the corresponding cache line                [0]: valid, [1]: dirty, [2]: cmpt",
        }
      ]
    },
    { name:     "TAG_1071",
      desc:     "Tag Address stored in cache line 1071",
      swaccess: "rw",
      hwaccess: "hrw",
      hwext:    "true",
      hwqe:     "true", // enable `qe` latched signal of software write pulse
      hwre:     "true",
      fields: [
        { bits: "5-1:0",
          name: "CL_TAG",
          desc: "Tag Address"
        }
      ]
    },
    {
      name:     "STATUS_1072",
      desc:     "Status register of cache line 1072",
      swaccess: "rw",
      hwaccess: "hrw",
      hwext:    "true",
      hwqe:     "true", // enable `qe` latched signal of software write pulse
      hwre:     "true",
      fields: [
        {
          bits: "5+3:5", // 2 bits for status
          name: "CL_STATUS",
          desc: "Contain the current status of the corresponding cache line                [0]: valid, [1]: dirty, [2]: cmpt",
        }
      ]
    },
    { name:     "TAG_1072",
      desc:     "Tag Address stored in cache line 1072",
      swaccess: "rw",
      hwaccess: "hrw",
      hwext:    "true",
      hwqe:     "true", // enable `qe` latched signal of software write pulse
      hwre:     "true",
      fields: [
        { bits: "5-1:0",
          name: "CL_TAG",
          desc: "Tag Address"
        }
      ]
    },
    {
      name:     "STATUS_1073",
      desc:     "Status register of cache line 1073",
      swaccess: "rw",
      hwaccess: "hrw",
      hwext:    "true",
      hwqe:     "true", // enable `qe` latched signal of software write pulse
      hwre:     "true",
      fields: [
        {
          bits: "5+3:5", // 2 bits for status
          name: "CL_STATUS",
          desc: "Contain the current status of the corresponding cache line                [0]: valid, [1]: dirty, [2]: cmpt",
        }
      ]
    },
    { name:     "TAG_1073",
      desc:     "Tag Address stored in cache line 1073",
      swaccess: "rw",
      hwaccess: "hrw",
      hwext:    "true",
      hwqe:     "true", // enable `qe` latched signal of software write pulse
      hwre:     "true",
      fields: [
        { bits: "5-1:0",
          name: "CL_TAG",
          desc: "Tag Address"
        }
      ]
    },
    {
      name:     "STATUS_1074",
      desc:     "Status register of cache line 1074",
      swaccess: "rw",
      hwaccess: "hrw",
      hwext:    "true",
      hwqe:     "true", // enable `qe` latched signal of software write pulse
      hwre:     "true",
      fields: [
        {
          bits: "5+3:5", // 2 bits for status
          name: "CL_STATUS",
          desc: "Contain the current status of the corresponding cache line                [0]: valid, [1]: dirty, [2]: cmpt",
        }
      ]
    },
    { name:     "TAG_1074",
      desc:     "Tag Address stored in cache line 1074",
      swaccess: "rw",
      hwaccess: "hrw",
      hwext:    "true",
      hwqe:     "true", // enable `qe` latched signal of software write pulse
      hwre:     "true",
      fields: [
        { bits: "5-1:0",
          name: "CL_TAG",
          desc: "Tag Address"
        }
      ]
    },
    {
      name:     "STATUS_1075",
      desc:     "Status register of cache line 1075",
      swaccess: "rw",
      hwaccess: "hrw",
      hwext:    "true",
      hwqe:     "true", // enable `qe` latched signal of software write pulse
      hwre:     "true",
      fields: [
        {
          bits: "5+3:5", // 2 bits for status
          name: "CL_STATUS",
          desc: "Contain the current status of the corresponding cache line                [0]: valid, [1]: dirty, [2]: cmpt",
        }
      ]
    },
    { name:     "TAG_1075",
      desc:     "Tag Address stored in cache line 1075",
      swaccess: "rw",
      hwaccess: "hrw",
      hwext:    "true",
      hwqe:     "true", // enable `qe` latched signal of software write pulse
      hwre:     "true",
      fields: [
        { bits: "5-1:0",
          name: "CL_TAG",
          desc: "Tag Address"
        }
      ]
    },
    {
      name:     "STATUS_1076",
      desc:     "Status register of cache line 1076",
      swaccess: "rw",
      hwaccess: "hrw",
      hwext:    "true",
      hwqe:     "true", // enable `qe` latched signal of software write pulse
      hwre:     "true",
      fields: [
        {
          bits: "5+3:5", // 2 bits for status
          name: "CL_STATUS",
          desc: "Contain the current status of the corresponding cache line                [0]: valid, [1]: dirty, [2]: cmpt",
        }
      ]
    },
    { name:     "TAG_1076",
      desc:     "Tag Address stored in cache line 1076",
      swaccess: "rw",
      hwaccess: "hrw",
      hwext:    "true",
      hwqe:     "true", // enable `qe` latched signal of software write pulse
      hwre:     "true",
      fields: [
        { bits: "5-1:0",
          name: "CL_TAG",
          desc: "Tag Address"
        }
      ]
    },
    {
      name:     "STATUS_1077",
      desc:     "Status register of cache line 1077",
      swaccess: "rw",
      hwaccess: "hrw",
      hwext:    "true",
      hwqe:     "true", // enable `qe` latched signal of software write pulse
      hwre:     "true",
      fields: [
        {
          bits: "5+3:5", // 2 bits for status
          name: "CL_STATUS",
          desc: "Contain the current status of the corresponding cache line                [0]: valid, [1]: dirty, [2]: cmpt",
        }
      ]
    },
    { name:     "TAG_1077",
      desc:     "Tag Address stored in cache line 1077",
      swaccess: "rw",
      hwaccess: "hrw",
      hwext:    "true",
      hwqe:     "true", // enable `qe` latched signal of software write pulse
      hwre:     "true",
      fields: [
        { bits: "5-1:0",
          name: "CL_TAG",
          desc: "Tag Address"
        }
      ]
    },
    {
      name:     "STATUS_1078",
      desc:     "Status register of cache line 1078",
      swaccess: "rw",
      hwaccess: "hrw",
      hwext:    "true",
      hwqe:     "true", // enable `qe` latched signal of software write pulse
      hwre:     "true",
      fields: [
        {
          bits: "5+3:5", // 2 bits for status
          name: "CL_STATUS",
          desc: "Contain the current status of the corresponding cache line                [0]: valid, [1]: dirty, [2]: cmpt",
        }
      ]
    },
    { name:     "TAG_1078",
      desc:     "Tag Address stored in cache line 1078",
      swaccess: "rw",
      hwaccess: "hrw",
      hwext:    "true",
      hwqe:     "true", // enable `qe` latched signal of software write pulse
      hwre:     "true",
      fields: [
        { bits: "5-1:0",
          name: "CL_TAG",
          desc: "Tag Address"
        }
      ]
    },
    {
      name:     "STATUS_1079",
      desc:     "Status register of cache line 1079",
      swaccess: "rw",
      hwaccess: "hrw",
      hwext:    "true",
      hwqe:     "true", // enable `qe` latched signal of software write pulse
      hwre:     "true",
      fields: [
        {
          bits: "5+3:5", // 2 bits for status
          name: "CL_STATUS",
          desc: "Contain the current status of the corresponding cache line                [0]: valid, [1]: dirty, [2]: cmpt",
        }
      ]
    },
    { name:     "TAG_1079",
      desc:     "Tag Address stored in cache line 1079",
      swaccess: "rw",
      hwaccess: "hrw",
      hwext:    "true",
      hwqe:     "true", // enable `qe` latched signal of software write pulse
      hwre:     "true",
      fields: [
        { bits: "5-1:0",
          name: "CL_TAG",
          desc: "Tag Address"
        }
      ]
    },
    {
      name:     "STATUS_1080",
      desc:     "Status register of cache line 1080",
      swaccess: "rw",
      hwaccess: "hrw",
      hwext:    "true",
      hwqe:     "true", // enable `qe` latched signal of software write pulse
      hwre:     "true",
      fields: [
        {
          bits: "5+3:5", // 2 bits for status
          name: "CL_STATUS",
          desc: "Contain the current status of the corresponding cache line                [0]: valid, [1]: dirty, [2]: cmpt",
        }
      ]
    },
    { name:     "TAG_1080",
      desc:     "Tag Address stored in cache line 1080",
      swaccess: "rw",
      hwaccess: "hrw",
      hwext:    "true",
      hwqe:     "true", // enable `qe` latched signal of software write pulse
      hwre:     "true",
      fields: [
        { bits: "5-1:0",
          name: "CL_TAG",
          desc: "Tag Address"
        }
      ]
    },
    {
      name:     "STATUS_1081",
      desc:     "Status register of cache line 1081",
      swaccess: "rw",
      hwaccess: "hrw",
      hwext:    "true",
      hwqe:     "true", // enable `qe` latched signal of software write pulse
      hwre:     "true",
      fields: [
        {
          bits: "5+3:5", // 2 bits for status
          name: "CL_STATUS",
          desc: "Contain the current status of the corresponding cache line                [0]: valid, [1]: dirty, [2]: cmpt",
        }
      ]
    },
    { name:     "TAG_1081",
      desc:     "Tag Address stored in cache line 1081",
      swaccess: "rw",
      hwaccess: "hrw",
      hwext:    "true",
      hwqe:     "true", // enable `qe` latched signal of software write pulse
      hwre:     "true",
      fields: [
        { bits: "5-1:0",
          name: "CL_TAG",
          desc: "Tag Address"
        }
      ]
    },
    {
      name:     "STATUS_1082",
      desc:     "Status register of cache line 1082",
      swaccess: "rw",
      hwaccess: "hrw",
      hwext:    "true",
      hwqe:     "true", // enable `qe` latched signal of software write pulse
      hwre:     "true",
      fields: [
        {
          bits: "5+3:5", // 2 bits for status
          name: "CL_STATUS",
          desc: "Contain the current status of the corresponding cache line                [0]: valid, [1]: dirty, [2]: cmpt",
        }
      ]
    },
    { name:     "TAG_1082",
      desc:     "Tag Address stored in cache line 1082",
      swaccess: "rw",
      hwaccess: "hrw",
      hwext:    "true",
      hwqe:     "true", // enable `qe` latched signal of software write pulse
      hwre:     "true",
      fields: [
        { bits: "5-1:0",
          name: "CL_TAG",
          desc: "Tag Address"
        }
      ]
    },
    {
      name:     "STATUS_1083",
      desc:     "Status register of cache line 1083",
      swaccess: "rw",
      hwaccess: "hrw",
      hwext:    "true",
      hwqe:     "true", // enable `qe` latched signal of software write pulse
      hwre:     "true",
      fields: [
        {
          bits: "5+3:5", // 2 bits for status
          name: "CL_STATUS",
          desc: "Contain the current status of the corresponding cache line                [0]: valid, [1]: dirty, [2]: cmpt",
        }
      ]
    },
    { name:     "TAG_1083",
      desc:     "Tag Address stored in cache line 1083",
      swaccess: "rw",
      hwaccess: "hrw",
      hwext:    "true",
      hwqe:     "true", // enable `qe` latched signal of software write pulse
      hwre:     "true",
      fields: [
        { bits: "5-1:0",
          name: "CL_TAG",
          desc: "Tag Address"
        }
      ]
    },
    {
      name:     "STATUS_1084",
      desc:     "Status register of cache line 1084",
      swaccess: "rw",
      hwaccess: "hrw",
      hwext:    "true",
      hwqe:     "true", // enable `qe` latched signal of software write pulse
      hwre:     "true",
      fields: [
        {
          bits: "5+3:5", // 2 bits for status
          name: "CL_STATUS",
          desc: "Contain the current status of the corresponding cache line                [0]: valid, [1]: dirty, [2]: cmpt",
        }
      ]
    },
    { name:     "TAG_1084",
      desc:     "Tag Address stored in cache line 1084",
      swaccess: "rw",
      hwaccess: "hrw",
      hwext:    "true",
      hwqe:     "true", // enable `qe` latched signal of software write pulse
      hwre:     "true",
      fields: [
        { bits: "5-1:0",
          name: "CL_TAG",
          desc: "Tag Address"
        }
      ]
    },
    {
      name:     "STATUS_1085",
      desc:     "Status register of cache line 1085",
      swaccess: "rw",
      hwaccess: "hrw",
      hwext:    "true",
      hwqe:     "true", // enable `qe` latched signal of software write pulse
      hwre:     "true",
      fields: [
        {
          bits: "5+3:5", // 2 bits for status
          name: "CL_STATUS",
          desc: "Contain the current status of the corresponding cache line                [0]: valid, [1]: dirty, [2]: cmpt",
        }
      ]
    },
    { name:     "TAG_1085",
      desc:     "Tag Address stored in cache line 1085",
      swaccess: "rw",
      hwaccess: "hrw",
      hwext:    "true",
      hwqe:     "true", // enable `qe` latched signal of software write pulse
      hwre:     "true",
      fields: [
        { bits: "5-1:0",
          name: "CL_TAG",
          desc: "Tag Address"
        }
      ]
    },
    {
      name:     "STATUS_1086",
      desc:     "Status register of cache line 1086",
      swaccess: "rw",
      hwaccess: "hrw",
      hwext:    "true",
      hwqe:     "true", // enable `qe` latched signal of software write pulse
      hwre:     "true",
      fields: [
        {
          bits: "5+3:5", // 2 bits for status
          name: "CL_STATUS",
          desc: "Contain the current status of the corresponding cache line                [0]: valid, [1]: dirty, [2]: cmpt",
        }
      ]
    },
    { name:     "TAG_1086",
      desc:     "Tag Address stored in cache line 1086",
      swaccess: "rw",
      hwaccess: "hrw",
      hwext:    "true",
      hwqe:     "true", // enable `qe` latched signal of software write pulse
      hwre:     "true",
      fields: [
        { bits: "5-1:0",
          name: "CL_TAG",
          desc: "Tag Address"
        }
      ]
    },
    {
      name:     "STATUS_1087",
      desc:     "Status register of cache line 1087",
      swaccess: "rw",
      hwaccess: "hrw",
      hwext:    "true",
      hwqe:     "true", // enable `qe` latched signal of software write pulse
      hwre:     "true",
      fields: [
        {
          bits: "5+3:5", // 2 bits for status
          name: "CL_STATUS",
          desc: "Contain the current status of the corresponding cache line                [0]: valid, [1]: dirty, [2]: cmpt",
        }
      ]
    },
    { name:     "TAG_1087",
      desc:     "Tag Address stored in cache line 1087",
      swaccess: "rw",
      hwaccess: "hrw",
      hwext:    "true",
      hwqe:     "true", // enable `qe` latched signal of software write pulse
      hwre:     "true",
      fields: [
        { bits: "5-1:0",
          name: "CL_TAG",
          desc: "Tag Address"
        }
      ]
    },
    {
      name:     "STATUS_1088",
      desc:     "Status register of cache line 1088",
      swaccess: "rw",
      hwaccess: "hrw",
      hwext:    "true",
      hwqe:     "true", // enable `qe` latched signal of software write pulse
      hwre:     "true",
      fields: [
        {
          bits: "5+3:5", // 2 bits for status
          name: "CL_STATUS",
          desc: "Contain the current status of the corresponding cache line                [0]: valid, [1]: dirty, [2]: cmpt",
        }
      ]
    },
    { name:     "TAG_1088",
      desc:     "Tag Address stored in cache line 1088",
      swaccess: "rw",
      hwaccess: "hrw",
      hwext:    "true",
      hwqe:     "true", // enable `qe` latched signal of software write pulse
      hwre:     "true",
      fields: [
        { bits: "5-1:0",
          name: "CL_TAG",
          desc: "Tag Address"
        }
      ]
    },
    {
      name:     "STATUS_1089",
      desc:     "Status register of cache line 1089",
      swaccess: "rw",
      hwaccess: "hrw",
      hwext:    "true",
      hwqe:     "true", // enable `qe` latched signal of software write pulse
      hwre:     "true",
      fields: [
        {
          bits: "5+3:5", // 2 bits for status
          name: "CL_STATUS",
          desc: "Contain the current status of the corresponding cache line                [0]: valid, [1]: dirty, [2]: cmpt",
        }
      ]
    },
    { name:     "TAG_1089",
      desc:     "Tag Address stored in cache line 1089",
      swaccess: "rw",
      hwaccess: "hrw",
      hwext:    "true",
      hwqe:     "true", // enable `qe` latched signal of software write pulse
      hwre:     "true",
      fields: [
        { bits: "5-1:0",
          name: "CL_TAG",
          desc: "Tag Address"
        }
      ]
    },
    {
      name:     "STATUS_1090",
      desc:     "Status register of cache line 1090",
      swaccess: "rw",
      hwaccess: "hrw",
      hwext:    "true",
      hwqe:     "true", // enable `qe` latched signal of software write pulse
      hwre:     "true",
      fields: [
        {
          bits: "5+3:5", // 2 bits for status
          name: "CL_STATUS",
          desc: "Contain the current status of the corresponding cache line                [0]: valid, [1]: dirty, [2]: cmpt",
        }
      ]
    },
    { name:     "TAG_1090",
      desc:     "Tag Address stored in cache line 1090",
      swaccess: "rw",
      hwaccess: "hrw",
      hwext:    "true",
      hwqe:     "true", // enable `qe` latched signal of software write pulse
      hwre:     "true",
      fields: [
        { bits: "5-1:0",
          name: "CL_TAG",
          desc: "Tag Address"
        }
      ]
    },
    {
      name:     "STATUS_1091",
      desc:     "Status register of cache line 1091",
      swaccess: "rw",
      hwaccess: "hrw",
      hwext:    "true",
      hwqe:     "true", // enable `qe` latched signal of software write pulse
      hwre:     "true",
      fields: [
        {
          bits: "5+3:5", // 2 bits for status
          name: "CL_STATUS",
          desc: "Contain the current status of the corresponding cache line                [0]: valid, [1]: dirty, [2]: cmpt",
        }
      ]
    },
    { name:     "TAG_1091",
      desc:     "Tag Address stored in cache line 1091",
      swaccess: "rw",
      hwaccess: "hrw",
      hwext:    "true",
      hwqe:     "true", // enable `qe` latched signal of software write pulse
      hwre:     "true",
      fields: [
        { bits: "5-1:0",
          name: "CL_TAG",
          desc: "Tag Address"
        }
      ]
    },
    {
      name:     "STATUS_1092",
      desc:     "Status register of cache line 1092",
      swaccess: "rw",
      hwaccess: "hrw",
      hwext:    "true",
      hwqe:     "true", // enable `qe` latched signal of software write pulse
      hwre:     "true",
      fields: [
        {
          bits: "5+3:5", // 2 bits for status
          name: "CL_STATUS",
          desc: "Contain the current status of the corresponding cache line                [0]: valid, [1]: dirty, [2]: cmpt",
        }
      ]
    },
    { name:     "TAG_1092",
      desc:     "Tag Address stored in cache line 1092",
      swaccess: "rw",
      hwaccess: "hrw",
      hwext:    "true",
      hwqe:     "true", // enable `qe` latched signal of software write pulse
      hwre:     "true",
      fields: [
        { bits: "5-1:0",
          name: "CL_TAG",
          desc: "Tag Address"
        }
      ]
    },
    {
      name:     "STATUS_1093",
      desc:     "Status register of cache line 1093",
      swaccess: "rw",
      hwaccess: "hrw",
      hwext:    "true",
      hwqe:     "true", // enable `qe` latched signal of software write pulse
      hwre:     "true",
      fields: [
        {
          bits: "5+3:5", // 2 bits for status
          name: "CL_STATUS",
          desc: "Contain the current status of the corresponding cache line                [0]: valid, [1]: dirty, [2]: cmpt",
        }
      ]
    },
    { name:     "TAG_1093",
      desc:     "Tag Address stored in cache line 1093",
      swaccess: "rw",
      hwaccess: "hrw",
      hwext:    "true",
      hwqe:     "true", // enable `qe` latched signal of software write pulse
      hwre:     "true",
      fields: [
        { bits: "5-1:0",
          name: "CL_TAG",
          desc: "Tag Address"
        }
      ]
    },
    {
      name:     "STATUS_1094",
      desc:     "Status register of cache line 1094",
      swaccess: "rw",
      hwaccess: "hrw",
      hwext:    "true",
      hwqe:     "true", // enable `qe` latched signal of software write pulse
      hwre:     "true",
      fields: [
        {
          bits: "5+3:5", // 2 bits for status
          name: "CL_STATUS",
          desc: "Contain the current status of the corresponding cache line                [0]: valid, [1]: dirty, [2]: cmpt",
        }
      ]
    },
    { name:     "TAG_1094",
      desc:     "Tag Address stored in cache line 1094",
      swaccess: "rw",
      hwaccess: "hrw",
      hwext:    "true",
      hwqe:     "true", // enable `qe` latched signal of software write pulse
      hwre:     "true",
      fields: [
        { bits: "5-1:0",
          name: "CL_TAG",
          desc: "Tag Address"
        }
      ]
    },
    {
      name:     "STATUS_1095",
      desc:     "Status register of cache line 1095",
      swaccess: "rw",
      hwaccess: "hrw",
      hwext:    "true",
      hwqe:     "true", // enable `qe` latched signal of software write pulse
      hwre:     "true",
      fields: [
        {
          bits: "5+3:5", // 2 bits for status
          name: "CL_STATUS",
          desc: "Contain the current status of the corresponding cache line                [0]: valid, [1]: dirty, [2]: cmpt",
        }
      ]
    },
    { name:     "TAG_1095",
      desc:     "Tag Address stored in cache line 1095",
      swaccess: "rw",
      hwaccess: "hrw",
      hwext:    "true",
      hwqe:     "true", // enable `qe` latched signal of software write pulse
      hwre:     "true",
      fields: [
        { bits: "5-1:0",
          name: "CL_TAG",
          desc: "Tag Address"
        }
      ]
    },
    {
      name:     "STATUS_1096",
      desc:     "Status register of cache line 1096",
      swaccess: "rw",
      hwaccess: "hrw",
      hwext:    "true",
      hwqe:     "true", // enable `qe` latched signal of software write pulse
      hwre:     "true",
      fields: [
        {
          bits: "5+3:5", // 2 bits for status
          name: "CL_STATUS",
          desc: "Contain the current status of the corresponding cache line                [0]: valid, [1]: dirty, [2]: cmpt",
        }
      ]
    },
    { name:     "TAG_1096",
      desc:     "Tag Address stored in cache line 1096",
      swaccess: "rw",
      hwaccess: "hrw",
      hwext:    "true",
      hwqe:     "true", // enable `qe` latched signal of software write pulse
      hwre:     "true",
      fields: [
        { bits: "5-1:0",
          name: "CL_TAG",
          desc: "Tag Address"
        }
      ]
    },
    {
      name:     "STATUS_1097",
      desc:     "Status register of cache line 1097",
      swaccess: "rw",
      hwaccess: "hrw",
      hwext:    "true",
      hwqe:     "true", // enable `qe` latched signal of software write pulse
      hwre:     "true",
      fields: [
        {
          bits: "5+3:5", // 2 bits for status
          name: "CL_STATUS",
          desc: "Contain the current status of the corresponding cache line                [0]: valid, [1]: dirty, [2]: cmpt",
        }
      ]
    },
    { name:     "TAG_1097",
      desc:     "Tag Address stored in cache line 1097",
      swaccess: "rw",
      hwaccess: "hrw",
      hwext:    "true",
      hwqe:     "true", // enable `qe` latched signal of software write pulse
      hwre:     "true",
      fields: [
        { bits: "5-1:0",
          name: "CL_TAG",
          desc: "Tag Address"
        }
      ]
    },
    {
      name:     "STATUS_1098",
      desc:     "Status register of cache line 1098",
      swaccess: "rw",
      hwaccess: "hrw",
      hwext:    "true",
      hwqe:     "true", // enable `qe` latched signal of software write pulse
      hwre:     "true",
      fields: [
        {
          bits: "5+3:5", // 2 bits for status
          name: "CL_STATUS",
          desc: "Contain the current status of the corresponding cache line                [0]: valid, [1]: dirty, [2]: cmpt",
        }
      ]
    },
    { name:     "TAG_1098",
      desc:     "Tag Address stored in cache line 1098",
      swaccess: "rw",
      hwaccess: "hrw",
      hwext:    "true",
      hwqe:     "true", // enable `qe` latched signal of software write pulse
      hwre:     "true",
      fields: [
        { bits: "5-1:0",
          name: "CL_TAG",
          desc: "Tag Address"
        }
      ]
    },
    {
      name:     "STATUS_1099",
      desc:     "Status register of cache line 1099",
      swaccess: "rw",
      hwaccess: "hrw",
      hwext:    "true",
      hwqe:     "true", // enable `qe` latched signal of software write pulse
      hwre:     "true",
      fields: [
        {
          bits: "5+3:5", // 2 bits for status
          name: "CL_STATUS",
          desc: "Contain the current status of the corresponding cache line                [0]: valid, [1]: dirty, [2]: cmpt",
        }
      ]
    },
    { name:     "TAG_1099",
      desc:     "Tag Address stored in cache line 1099",
      swaccess: "rw",
      hwaccess: "hrw",
      hwext:    "true",
      hwqe:     "true", // enable `qe` latched signal of software write pulse
      hwre:     "true",
      fields: [
        { bits: "5-1:0",
          name: "CL_TAG",
          desc: "Tag Address"
        }
      ]
    },
    {
      name:     "STATUS_1100",
      desc:     "Status register of cache line 1100",
      swaccess: "rw",
      hwaccess: "hrw",
      hwext:    "true",
      hwqe:     "true", // enable `qe` latched signal of software write pulse
      hwre:     "true",
      fields: [
        {
          bits: "5+3:5", // 2 bits for status
          name: "CL_STATUS",
          desc: "Contain the current status of the corresponding cache line                [0]: valid, [1]: dirty, [2]: cmpt",
        }
      ]
    },
    { name:     "TAG_1100",
      desc:     "Tag Address stored in cache line 1100",
      swaccess: "rw",
      hwaccess: "hrw",
      hwext:    "true",
      hwqe:     "true", // enable `qe` latched signal of software write pulse
      hwre:     "true",
      fields: [
        { bits: "5-1:0",
          name: "CL_TAG",
          desc: "Tag Address"
        }
      ]
    },
    {
      name:     "STATUS_1101",
      desc:     "Status register of cache line 1101",
      swaccess: "rw",
      hwaccess: "hrw",
      hwext:    "true",
      hwqe:     "true", // enable `qe` latched signal of software write pulse
      hwre:     "true",
      fields: [
        {
          bits: "5+3:5", // 2 bits for status
          name: "CL_STATUS",
          desc: "Contain the current status of the corresponding cache line                [0]: valid, [1]: dirty, [2]: cmpt",
        }
      ]
    },
    { name:     "TAG_1101",
      desc:     "Tag Address stored in cache line 1101",
      swaccess: "rw",
      hwaccess: "hrw",
      hwext:    "true",
      hwqe:     "true", // enable `qe` latched signal of software write pulse
      hwre:     "true",
      fields: [
        { bits: "5-1:0",
          name: "CL_TAG",
          desc: "Tag Address"
        }
      ]
    },
    {
      name:     "STATUS_1102",
      desc:     "Status register of cache line 1102",
      swaccess: "rw",
      hwaccess: "hrw",
      hwext:    "true",
      hwqe:     "true", // enable `qe` latched signal of software write pulse
      hwre:     "true",
      fields: [
        {
          bits: "5+3:5", // 2 bits for status
          name: "CL_STATUS",
          desc: "Contain the current status of the corresponding cache line                [0]: valid, [1]: dirty, [2]: cmpt",
        }
      ]
    },
    { name:     "TAG_1102",
      desc:     "Tag Address stored in cache line 1102",
      swaccess: "rw",
      hwaccess: "hrw",
      hwext:    "true",
      hwqe:     "true", // enable `qe` latched signal of software write pulse
      hwre:     "true",
      fields: [
        { bits: "5-1:0",
          name: "CL_TAG",
          desc: "Tag Address"
        }
      ]
    },
    {
      name:     "STATUS_1103",
      desc:     "Status register of cache line 1103",
      swaccess: "rw",
      hwaccess: "hrw",
      hwext:    "true",
      hwqe:     "true", // enable `qe` latched signal of software write pulse
      hwre:     "true",
      fields: [
        {
          bits: "5+3:5", // 2 bits for status
          name: "CL_STATUS",
          desc: "Contain the current status of the corresponding cache line                [0]: valid, [1]: dirty, [2]: cmpt",
        }
      ]
    },
    { name:     "TAG_1103",
      desc:     "Tag Address stored in cache line 1103",
      swaccess: "rw",
      hwaccess: "hrw",
      hwext:    "true",
      hwqe:     "true", // enable `qe` latched signal of software write pulse
      hwre:     "true",
      fields: [
        { bits: "5-1:0",
          name: "CL_TAG",
          desc: "Tag Address"
        }
      ]
    },
    {
      name:     "STATUS_1104",
      desc:     "Status register of cache line 1104",
      swaccess: "rw",
      hwaccess: "hrw",
      hwext:    "true",
      hwqe:     "true", // enable `qe` latched signal of software write pulse
      hwre:     "true",
      fields: [
        {
          bits: "5+3:5", // 2 bits for status
          name: "CL_STATUS",
          desc: "Contain the current status of the corresponding cache line                [0]: valid, [1]: dirty, [2]: cmpt",
        }
      ]
    },
    { name:     "TAG_1104",
      desc:     "Tag Address stored in cache line 1104",
      swaccess: "rw",
      hwaccess: "hrw",
      hwext:    "true",
      hwqe:     "true", // enable `qe` latched signal of software write pulse
      hwre:     "true",
      fields: [
        { bits: "5-1:0",
          name: "CL_TAG",
          desc: "Tag Address"
        }
      ]
    },
    {
      name:     "STATUS_1105",
      desc:     "Status register of cache line 1105",
      swaccess: "rw",
      hwaccess: "hrw",
      hwext:    "true",
      hwqe:     "true", // enable `qe` latched signal of software write pulse
      hwre:     "true",
      fields: [
        {
          bits: "5+3:5", // 2 bits for status
          name: "CL_STATUS",
          desc: "Contain the current status of the corresponding cache line                [0]: valid, [1]: dirty, [2]: cmpt",
        }
      ]
    },
    { name:     "TAG_1105",
      desc:     "Tag Address stored in cache line 1105",
      swaccess: "rw",
      hwaccess: "hrw",
      hwext:    "true",
      hwqe:     "true", // enable `qe` latched signal of software write pulse
      hwre:     "true",
      fields: [
        { bits: "5-1:0",
          name: "CL_TAG",
          desc: "Tag Address"
        }
      ]
    },
    {
      name:     "STATUS_1106",
      desc:     "Status register of cache line 1106",
      swaccess: "rw",
      hwaccess: "hrw",
      hwext:    "true",
      hwqe:     "true", // enable `qe` latched signal of software write pulse
      hwre:     "true",
      fields: [
        {
          bits: "5+3:5", // 2 bits for status
          name: "CL_STATUS",
          desc: "Contain the current status of the corresponding cache line                [0]: valid, [1]: dirty, [2]: cmpt",
        }
      ]
    },
    { name:     "TAG_1106",
      desc:     "Tag Address stored in cache line 1106",
      swaccess: "rw",
      hwaccess: "hrw",
      hwext:    "true",
      hwqe:     "true", // enable `qe` latched signal of software write pulse
      hwre:     "true",
      fields: [
        { bits: "5-1:0",
          name: "CL_TAG",
          desc: "Tag Address"
        }
      ]
    },
    {
      name:     "STATUS_1107",
      desc:     "Status register of cache line 1107",
      swaccess: "rw",
      hwaccess: "hrw",
      hwext:    "true",
      hwqe:     "true", // enable `qe` latched signal of software write pulse
      hwre:     "true",
      fields: [
        {
          bits: "5+3:5", // 2 bits for status
          name: "CL_STATUS",
          desc: "Contain the current status of the corresponding cache line                [0]: valid, [1]: dirty, [2]: cmpt",
        }
      ]
    },
    { name:     "TAG_1107",
      desc:     "Tag Address stored in cache line 1107",
      swaccess: "rw",
      hwaccess: "hrw",
      hwext:    "true",
      hwqe:     "true", // enable `qe` latched signal of software write pulse
      hwre:     "true",
      fields: [
        { bits: "5-1:0",
          name: "CL_TAG",
          desc: "Tag Address"
        }
      ]
    },
    {
      name:     "STATUS_1108",
      desc:     "Status register of cache line 1108",
      swaccess: "rw",
      hwaccess: "hrw",
      hwext:    "true",
      hwqe:     "true", // enable `qe` latched signal of software write pulse
      hwre:     "true",
      fields: [
        {
          bits: "5+3:5", // 2 bits for status
          name: "CL_STATUS",
          desc: "Contain the current status of the corresponding cache line                [0]: valid, [1]: dirty, [2]: cmpt",
        }
      ]
    },
    { name:     "TAG_1108",
      desc:     "Tag Address stored in cache line 1108",
      swaccess: "rw",
      hwaccess: "hrw",
      hwext:    "true",
      hwqe:     "true", // enable `qe` latched signal of software write pulse
      hwre:     "true",
      fields: [
        { bits: "5-1:0",
          name: "CL_TAG",
          desc: "Tag Address"
        }
      ]
    },
    {
      name:     "STATUS_1109",
      desc:     "Status register of cache line 1109",
      swaccess: "rw",
      hwaccess: "hrw",
      hwext:    "true",
      hwqe:     "true", // enable `qe` latched signal of software write pulse
      hwre:     "true",
      fields: [
        {
          bits: "5+3:5", // 2 bits for status
          name: "CL_STATUS",
          desc: "Contain the current status of the corresponding cache line                [0]: valid, [1]: dirty, [2]: cmpt",
        }
      ]
    },
    { name:     "TAG_1109",
      desc:     "Tag Address stored in cache line 1109",
      swaccess: "rw",
      hwaccess: "hrw",
      hwext:    "true",
      hwqe:     "true", // enable `qe` latched signal of software write pulse
      hwre:     "true",
      fields: [
        { bits: "5-1:0",
          name: "CL_TAG",
          desc: "Tag Address"
        }
      ]
    },
    {
      name:     "STATUS_1110",
      desc:     "Status register of cache line 1110",
      swaccess: "rw",
      hwaccess: "hrw",
      hwext:    "true",
      hwqe:     "true", // enable `qe` latched signal of software write pulse
      hwre:     "true",
      fields: [
        {
          bits: "5+3:5", // 2 bits for status
          name: "CL_STATUS",
          desc: "Contain the current status of the corresponding cache line                [0]: valid, [1]: dirty, [2]: cmpt",
        }
      ]
    },
    { name:     "TAG_1110",
      desc:     "Tag Address stored in cache line 1110",
      swaccess: "rw",
      hwaccess: "hrw",
      hwext:    "true",
      hwqe:     "true", // enable `qe` latched signal of software write pulse
      hwre:     "true",
      fields: [
        { bits: "5-1:0",
          name: "CL_TAG",
          desc: "Tag Address"
        }
      ]
    },
    {
      name:     "STATUS_1111",
      desc:     "Status register of cache line 1111",
      swaccess: "rw",
      hwaccess: "hrw",
      hwext:    "true",
      hwqe:     "true", // enable `qe` latched signal of software write pulse
      hwre:     "true",
      fields: [
        {
          bits: "5+3:5", // 2 bits for status
          name: "CL_STATUS",
          desc: "Contain the current status of the corresponding cache line                [0]: valid, [1]: dirty, [2]: cmpt",
        }
      ]
    },
    { name:     "TAG_1111",
      desc:     "Tag Address stored in cache line 1111",
      swaccess: "rw",
      hwaccess: "hrw",
      hwext:    "true",
      hwqe:     "true", // enable `qe` latched signal of software write pulse
      hwre:     "true",
      fields: [
        { bits: "5-1:0",
          name: "CL_TAG",
          desc: "Tag Address"
        }
      ]
    },
    {
      name:     "STATUS_1112",
      desc:     "Status register of cache line 1112",
      swaccess: "rw",
      hwaccess: "hrw",
      hwext:    "true",
      hwqe:     "true", // enable `qe` latched signal of software write pulse
      hwre:     "true",
      fields: [
        {
          bits: "5+3:5", // 2 bits for status
          name: "CL_STATUS",
          desc: "Contain the current status of the corresponding cache line                [0]: valid, [1]: dirty, [2]: cmpt",
        }
      ]
    },
    { name:     "TAG_1112",
      desc:     "Tag Address stored in cache line 1112",
      swaccess: "rw",
      hwaccess: "hrw",
      hwext:    "true",
      hwqe:     "true", // enable `qe` latched signal of software write pulse
      hwre:     "true",
      fields: [
        { bits: "5-1:0",
          name: "CL_TAG",
          desc: "Tag Address"
        }
      ]
    },
    {
      name:     "STATUS_1113",
      desc:     "Status register of cache line 1113",
      swaccess: "rw",
      hwaccess: "hrw",
      hwext:    "true",
      hwqe:     "true", // enable `qe` latched signal of software write pulse
      hwre:     "true",
      fields: [
        {
          bits: "5+3:5", // 2 bits for status
          name: "CL_STATUS",
          desc: "Contain the current status of the corresponding cache line                [0]: valid, [1]: dirty, [2]: cmpt",
        }
      ]
    },
    { name:     "TAG_1113",
      desc:     "Tag Address stored in cache line 1113",
      swaccess: "rw",
      hwaccess: "hrw",
      hwext:    "true",
      hwqe:     "true", // enable `qe` latched signal of software write pulse
      hwre:     "true",
      fields: [
        { bits: "5-1:0",
          name: "CL_TAG",
          desc: "Tag Address"
        }
      ]
    },
    {
      name:     "STATUS_1114",
      desc:     "Status register of cache line 1114",
      swaccess: "rw",
      hwaccess: "hrw",
      hwext:    "true",
      hwqe:     "true", // enable `qe` latched signal of software write pulse
      hwre:     "true",
      fields: [
        {
          bits: "5+3:5", // 2 bits for status
          name: "CL_STATUS",
          desc: "Contain the current status of the corresponding cache line                [0]: valid, [1]: dirty, [2]: cmpt",
        }
      ]
    },
    { name:     "TAG_1114",
      desc:     "Tag Address stored in cache line 1114",
      swaccess: "rw",
      hwaccess: "hrw",
      hwext:    "true",
      hwqe:     "true", // enable `qe` latched signal of software write pulse
      hwre:     "true",
      fields: [
        { bits: "5-1:0",
          name: "CL_TAG",
          desc: "Tag Address"
        }
      ]
    },
    {
      name:     "STATUS_1115",
      desc:     "Status register of cache line 1115",
      swaccess: "rw",
      hwaccess: "hrw",
      hwext:    "true",
      hwqe:     "true", // enable `qe` latched signal of software write pulse
      hwre:     "true",
      fields: [
        {
          bits: "5+3:5", // 2 bits for status
          name: "CL_STATUS",
          desc: "Contain the current status of the corresponding cache line                [0]: valid, [1]: dirty, [2]: cmpt",
        }
      ]
    },
    { name:     "TAG_1115",
      desc:     "Tag Address stored in cache line 1115",
      swaccess: "rw",
      hwaccess: "hrw",
      hwext:    "true",
      hwqe:     "true", // enable `qe` latched signal of software write pulse
      hwre:     "true",
      fields: [
        { bits: "5-1:0",
          name: "CL_TAG",
          desc: "Tag Address"
        }
      ]
    },
    {
      name:     "STATUS_1116",
      desc:     "Status register of cache line 1116",
      swaccess: "rw",
      hwaccess: "hrw",
      hwext:    "true",
      hwqe:     "true", // enable `qe` latched signal of software write pulse
      hwre:     "true",
      fields: [
        {
          bits: "5+3:5", // 2 bits for status
          name: "CL_STATUS",
          desc: "Contain the current status of the corresponding cache line                [0]: valid, [1]: dirty, [2]: cmpt",
        }
      ]
    },
    { name:     "TAG_1116",
      desc:     "Tag Address stored in cache line 1116",
      swaccess: "rw",
      hwaccess: "hrw",
      hwext:    "true",
      hwqe:     "true", // enable `qe` latched signal of software write pulse
      hwre:     "true",
      fields: [
        { bits: "5-1:0",
          name: "CL_TAG",
          desc: "Tag Address"
        }
      ]
    },
    {
      name:     "STATUS_1117",
      desc:     "Status register of cache line 1117",
      swaccess: "rw",
      hwaccess: "hrw",
      hwext:    "true",
      hwqe:     "true", // enable `qe` latched signal of software write pulse
      hwre:     "true",
      fields: [
        {
          bits: "5+3:5", // 2 bits for status
          name: "CL_STATUS",
          desc: "Contain the current status of the corresponding cache line                [0]: valid, [1]: dirty, [2]: cmpt",
        }
      ]
    },
    { name:     "TAG_1117",
      desc:     "Tag Address stored in cache line 1117",
      swaccess: "rw",
      hwaccess: "hrw",
      hwext:    "true",
      hwqe:     "true", // enable `qe` latched signal of software write pulse
      hwre:     "true",
      fields: [
        { bits: "5-1:0",
          name: "CL_TAG",
          desc: "Tag Address"
        }
      ]
    },
    {
      name:     "STATUS_1118",
      desc:     "Status register of cache line 1118",
      swaccess: "rw",
      hwaccess: "hrw",
      hwext:    "true",
      hwqe:     "true", // enable `qe` latched signal of software write pulse
      hwre:     "true",
      fields: [
        {
          bits: "5+3:5", // 2 bits for status
          name: "CL_STATUS",
          desc: "Contain the current status of the corresponding cache line                [0]: valid, [1]: dirty, [2]: cmpt",
        }
      ]
    },
    { name:     "TAG_1118",
      desc:     "Tag Address stored in cache line 1118",
      swaccess: "rw",
      hwaccess: "hrw",
      hwext:    "true",
      hwqe:     "true", // enable `qe` latched signal of software write pulse
      hwre:     "true",
      fields: [
        { bits: "5-1:0",
          name: "CL_TAG",
          desc: "Tag Address"
        }
      ]
    },
    {
      name:     "STATUS_1119",
      desc:     "Status register of cache line 1119",
      swaccess: "rw",
      hwaccess: "hrw",
      hwext:    "true",
      hwqe:     "true", // enable `qe` latched signal of software write pulse
      hwre:     "true",
      fields: [
        {
          bits: "5+3:5", // 2 bits for status
          name: "CL_STATUS",
          desc: "Contain the current status of the corresponding cache line                [0]: valid, [1]: dirty, [2]: cmpt",
        }
      ]
    },
    { name:     "TAG_1119",
      desc:     "Tag Address stored in cache line 1119",
      swaccess: "rw",
      hwaccess: "hrw",
      hwext:    "true",
      hwqe:     "true", // enable `qe` latched signal of software write pulse
      hwre:     "true",
      fields: [
        { bits: "5-1:0",
          name: "CL_TAG",
          desc: "Tag Address"
        }
      ]
    },
    {
      name:     "STATUS_1120",
      desc:     "Status register of cache line 1120",
      swaccess: "rw",
      hwaccess: "hrw",
      hwext:    "true",
      hwqe:     "true", // enable `qe` latched signal of software write pulse
      hwre:     "true",
      fields: [
        {
          bits: "5+3:5", // 2 bits for status
          name: "CL_STATUS",
          desc: "Contain the current status of the corresponding cache line                [0]: valid, [1]: dirty, [2]: cmpt",
        }
      ]
    },
    { name:     "TAG_1120",
      desc:     "Tag Address stored in cache line 1120",
      swaccess: "rw",
      hwaccess: "hrw",
      hwext:    "true",
      hwqe:     "true", // enable `qe` latched signal of software write pulse
      hwre:     "true",
      fields: [
        { bits: "5-1:0",
          name: "CL_TAG",
          desc: "Tag Address"
        }
      ]
    },
    {
      name:     "STATUS_1121",
      desc:     "Status register of cache line 1121",
      swaccess: "rw",
      hwaccess: "hrw",
      hwext:    "true",
      hwqe:     "true", // enable `qe` latched signal of software write pulse
      hwre:     "true",
      fields: [
        {
          bits: "5+3:5", // 2 bits for status
          name: "CL_STATUS",
          desc: "Contain the current status of the corresponding cache line                [0]: valid, [1]: dirty, [2]: cmpt",
        }
      ]
    },
    { name:     "TAG_1121",
      desc:     "Tag Address stored in cache line 1121",
      swaccess: "rw",
      hwaccess: "hrw",
      hwext:    "true",
      hwqe:     "true", // enable `qe` latched signal of software write pulse
      hwre:     "true",
      fields: [
        { bits: "5-1:0",
          name: "CL_TAG",
          desc: "Tag Address"
        }
      ]
    },
    {
      name:     "STATUS_1122",
      desc:     "Status register of cache line 1122",
      swaccess: "rw",
      hwaccess: "hrw",
      hwext:    "true",
      hwqe:     "true", // enable `qe` latched signal of software write pulse
      hwre:     "true",
      fields: [
        {
          bits: "5+3:5", // 2 bits for status
          name: "CL_STATUS",
          desc: "Contain the current status of the corresponding cache line                [0]: valid, [1]: dirty, [2]: cmpt",
        }
      ]
    },
    { name:     "TAG_1122",
      desc:     "Tag Address stored in cache line 1122",
      swaccess: "rw",
      hwaccess: "hrw",
      hwext:    "true",
      hwqe:     "true", // enable `qe` latched signal of software write pulse
      hwre:     "true",
      fields: [
        { bits: "5-1:0",
          name: "CL_TAG",
          desc: "Tag Address"
        }
      ]
    },
    {
      name:     "STATUS_1123",
      desc:     "Status register of cache line 1123",
      swaccess: "rw",
      hwaccess: "hrw",
      hwext:    "true",
      hwqe:     "true", // enable `qe` latched signal of software write pulse
      hwre:     "true",
      fields: [
        {
          bits: "5+3:5", // 2 bits for status
          name: "CL_STATUS",
          desc: "Contain the current status of the corresponding cache line                [0]: valid, [1]: dirty, [2]: cmpt",
        }
      ]
    },
    { name:     "TAG_1123",
      desc:     "Tag Address stored in cache line 1123",
      swaccess: "rw",
      hwaccess: "hrw",
      hwext:    "true",
      hwqe:     "true", // enable `qe` latched signal of software write pulse
      hwre:     "true",
      fields: [
        { bits: "5-1:0",
          name: "CL_TAG",
          desc: "Tag Address"
        }
      ]
    },
    {
      name:     "STATUS_1124",
      desc:     "Status register of cache line 1124",
      swaccess: "rw",
      hwaccess: "hrw",
      hwext:    "true",
      hwqe:     "true", // enable `qe` latched signal of software write pulse
      hwre:     "true",
      fields: [
        {
          bits: "5+3:5", // 2 bits for status
          name: "CL_STATUS",
          desc: "Contain the current status of the corresponding cache line                [0]: valid, [1]: dirty, [2]: cmpt",
        }
      ]
    },
    { name:     "TAG_1124",
      desc:     "Tag Address stored in cache line 1124",
      swaccess: "rw",
      hwaccess: "hrw",
      hwext:    "true",
      hwqe:     "true", // enable `qe` latched signal of software write pulse
      hwre:     "true",
      fields: [
        { bits: "5-1:0",
          name: "CL_TAG",
          desc: "Tag Address"
        }
      ]
    },
    {
      name:     "STATUS_1125",
      desc:     "Status register of cache line 1125",
      swaccess: "rw",
      hwaccess: "hrw",
      hwext:    "true",
      hwqe:     "true", // enable `qe` latched signal of software write pulse
      hwre:     "true",
      fields: [
        {
          bits: "5+3:5", // 2 bits for status
          name: "CL_STATUS",
          desc: "Contain the current status of the corresponding cache line                [0]: valid, [1]: dirty, [2]: cmpt",
        }
      ]
    },
    { name:     "TAG_1125",
      desc:     "Tag Address stored in cache line 1125",
      swaccess: "rw",
      hwaccess: "hrw",
      hwext:    "true",
      hwqe:     "true", // enable `qe` latched signal of software write pulse
      hwre:     "true",
      fields: [
        { bits: "5-1:0",
          name: "CL_TAG",
          desc: "Tag Address"
        }
      ]
    },
    {
      name:     "STATUS_1126",
      desc:     "Status register of cache line 1126",
      swaccess: "rw",
      hwaccess: "hrw",
      hwext:    "true",
      hwqe:     "true", // enable `qe` latched signal of software write pulse
      hwre:     "true",
      fields: [
        {
          bits: "5+3:5", // 2 bits for status
          name: "CL_STATUS",
          desc: "Contain the current status of the corresponding cache line                [0]: valid, [1]: dirty, [2]: cmpt",
        }
      ]
    },
    { name:     "TAG_1126",
      desc:     "Tag Address stored in cache line 1126",
      swaccess: "rw",
      hwaccess: "hrw",
      hwext:    "true",
      hwqe:     "true", // enable `qe` latched signal of software write pulse
      hwre:     "true",
      fields: [
        { bits: "5-1:0",
          name: "CL_TAG",
          desc: "Tag Address"
        }
      ]
    },
    {
      name:     "STATUS_1127",
      desc:     "Status register of cache line 1127",
      swaccess: "rw",
      hwaccess: "hrw",
      hwext:    "true",
      hwqe:     "true", // enable `qe` latched signal of software write pulse
      hwre:     "true",
      fields: [
        {
          bits: "5+3:5", // 2 bits for status
          name: "CL_STATUS",
          desc: "Contain the current status of the corresponding cache line                [0]: valid, [1]: dirty, [2]: cmpt",
        }
      ]
    },
    { name:     "TAG_1127",
      desc:     "Tag Address stored in cache line 1127",
      swaccess: "rw",
      hwaccess: "hrw",
      hwext:    "true",
      hwqe:     "true", // enable `qe` latched signal of software write pulse
      hwre:     "true",
      fields: [
        { bits: "5-1:0",
          name: "CL_TAG",
          desc: "Tag Address"
        }
      ]
    },
    {
      name:     "STATUS_1128",
      desc:     "Status register of cache line 1128",
      swaccess: "rw",
      hwaccess: "hrw",
      hwext:    "true",
      hwqe:     "true", // enable `qe` latched signal of software write pulse
      hwre:     "true",
      fields: [
        {
          bits: "5+3:5", // 2 bits for status
          name: "CL_STATUS",
          desc: "Contain the current status of the corresponding cache line                [0]: valid, [1]: dirty, [2]: cmpt",
        }
      ]
    },
    { name:     "TAG_1128",
      desc:     "Tag Address stored in cache line 1128",
      swaccess: "rw",
      hwaccess: "hrw",
      hwext:    "true",
      hwqe:     "true", // enable `qe` latched signal of software write pulse
      hwre:     "true",
      fields: [
        { bits: "5-1:0",
          name: "CL_TAG",
          desc: "Tag Address"
        }
      ]
    },
    {
      name:     "STATUS_1129",
      desc:     "Status register of cache line 1129",
      swaccess: "rw",
      hwaccess: "hrw",
      hwext:    "true",
      hwqe:     "true", // enable `qe` latched signal of software write pulse
      hwre:     "true",
      fields: [
        {
          bits: "5+3:5", // 2 bits for status
          name: "CL_STATUS",
          desc: "Contain the current status of the corresponding cache line                [0]: valid, [1]: dirty, [2]: cmpt",
        }
      ]
    },
    { name:     "TAG_1129",
      desc:     "Tag Address stored in cache line 1129",
      swaccess: "rw",
      hwaccess: "hrw",
      hwext:    "true",
      hwqe:     "true", // enable `qe` latched signal of software write pulse
      hwre:     "true",
      fields: [
        { bits: "5-1:0",
          name: "CL_TAG",
          desc: "Tag Address"
        }
      ]
    },
    {
      name:     "STATUS_1130",
      desc:     "Status register of cache line 1130",
      swaccess: "rw",
      hwaccess: "hrw",
      hwext:    "true",
      hwqe:     "true", // enable `qe` latched signal of software write pulse
      hwre:     "true",
      fields: [
        {
          bits: "5+3:5", // 2 bits for status
          name: "CL_STATUS",
          desc: "Contain the current status of the corresponding cache line                [0]: valid, [1]: dirty, [2]: cmpt",
        }
      ]
    },
    { name:     "TAG_1130",
      desc:     "Tag Address stored in cache line 1130",
      swaccess: "rw",
      hwaccess: "hrw",
      hwext:    "true",
      hwqe:     "true", // enable `qe` latched signal of software write pulse
      hwre:     "true",
      fields: [
        { bits: "5-1:0",
          name: "CL_TAG",
          desc: "Tag Address"
        }
      ]
    },
    {
      name:     "STATUS_1131",
      desc:     "Status register of cache line 1131",
      swaccess: "rw",
      hwaccess: "hrw",
      hwext:    "true",
      hwqe:     "true", // enable `qe` latched signal of software write pulse
      hwre:     "true",
      fields: [
        {
          bits: "5+3:5", // 2 bits for status
          name: "CL_STATUS",
          desc: "Contain the current status of the corresponding cache line                [0]: valid, [1]: dirty, [2]: cmpt",
        }
      ]
    },
    { name:     "TAG_1131",
      desc:     "Tag Address stored in cache line 1131",
      swaccess: "rw",
      hwaccess: "hrw",
      hwext:    "true",
      hwqe:     "true", // enable `qe` latched signal of software write pulse
      hwre:     "true",
      fields: [
        { bits: "5-1:0",
          name: "CL_TAG",
          desc: "Tag Address"
        }
      ]
    },
    {
      name:     "STATUS_1132",
      desc:     "Status register of cache line 1132",
      swaccess: "rw",
      hwaccess: "hrw",
      hwext:    "true",
      hwqe:     "true", // enable `qe` latched signal of software write pulse
      hwre:     "true",
      fields: [
        {
          bits: "5+3:5", // 2 bits for status
          name: "CL_STATUS",
          desc: "Contain the current status of the corresponding cache line                [0]: valid, [1]: dirty, [2]: cmpt",
        }
      ]
    },
    { name:     "TAG_1132",
      desc:     "Tag Address stored in cache line 1132",
      swaccess: "rw",
      hwaccess: "hrw",
      hwext:    "true",
      hwqe:     "true", // enable `qe` latched signal of software write pulse
      hwre:     "true",
      fields: [
        { bits: "5-1:0",
          name: "CL_TAG",
          desc: "Tag Address"
        }
      ]
    },
    {
      name:     "STATUS_1133",
      desc:     "Status register of cache line 1133",
      swaccess: "rw",
      hwaccess: "hrw",
      hwext:    "true",
      hwqe:     "true", // enable `qe` latched signal of software write pulse
      hwre:     "true",
      fields: [
        {
          bits: "5+3:5", // 2 bits for status
          name: "CL_STATUS",
          desc: "Contain the current status of the corresponding cache line                [0]: valid, [1]: dirty, [2]: cmpt",
        }
      ]
    },
    { name:     "TAG_1133",
      desc:     "Tag Address stored in cache line 1133",
      swaccess: "rw",
      hwaccess: "hrw",
      hwext:    "true",
      hwqe:     "true", // enable `qe` latched signal of software write pulse
      hwre:     "true",
      fields: [
        { bits: "5-1:0",
          name: "CL_TAG",
          desc: "Tag Address"
        }
      ]
    },
    {
      name:     "STATUS_1134",
      desc:     "Status register of cache line 1134",
      swaccess: "rw",
      hwaccess: "hrw",
      hwext:    "true",
      hwqe:     "true", // enable `qe` latched signal of software write pulse
      hwre:     "true",
      fields: [
        {
          bits: "5+3:5", // 2 bits for status
          name: "CL_STATUS",
          desc: "Contain the current status of the corresponding cache line                [0]: valid, [1]: dirty, [2]: cmpt",
        }
      ]
    },
    { name:     "TAG_1134",
      desc:     "Tag Address stored in cache line 1134",
      swaccess: "rw",
      hwaccess: "hrw",
      hwext:    "true",
      hwqe:     "true", // enable `qe` latched signal of software write pulse
      hwre:     "true",
      fields: [
        { bits: "5-1:0",
          name: "CL_TAG",
          desc: "Tag Address"
        }
      ]
    },
    {
      name:     "STATUS_1135",
      desc:     "Status register of cache line 1135",
      swaccess: "rw",
      hwaccess: "hrw",
      hwext:    "true",
      hwqe:     "true", // enable `qe` latched signal of software write pulse
      hwre:     "true",
      fields: [
        {
          bits: "5+3:5", // 2 bits for status
          name: "CL_STATUS",
          desc: "Contain the current status of the corresponding cache line                [0]: valid, [1]: dirty, [2]: cmpt",
        }
      ]
    },
    { name:     "TAG_1135",
      desc:     "Tag Address stored in cache line 1135",
      swaccess: "rw",
      hwaccess: "hrw",
      hwext:    "true",
      hwqe:     "true", // enable `qe` latched signal of software write pulse
      hwre:     "true",
      fields: [
        { bits: "5-1:0",
          name: "CL_TAG",
          desc: "Tag Address"
        }
      ]
    },
    {
      name:     "STATUS_1136",
      desc:     "Status register of cache line 1136",
      swaccess: "rw",
      hwaccess: "hrw",
      hwext:    "true",
      hwqe:     "true", // enable `qe` latched signal of software write pulse
      hwre:     "true",
      fields: [
        {
          bits: "5+3:5", // 2 bits for status
          name: "CL_STATUS",
          desc: "Contain the current status of the corresponding cache line                [0]: valid, [1]: dirty, [2]: cmpt",
        }
      ]
    },
    { name:     "TAG_1136",
      desc:     "Tag Address stored in cache line 1136",
      swaccess: "rw",
      hwaccess: "hrw",
      hwext:    "true",
      hwqe:     "true", // enable `qe` latched signal of software write pulse
      hwre:     "true",
      fields: [
        { bits: "5-1:0",
          name: "CL_TAG",
          desc: "Tag Address"
        }
      ]
    },
    {
      name:     "STATUS_1137",
      desc:     "Status register of cache line 1137",
      swaccess: "rw",
      hwaccess: "hrw",
      hwext:    "true",
      hwqe:     "true", // enable `qe` latched signal of software write pulse
      hwre:     "true",
      fields: [
        {
          bits: "5+3:5", // 2 bits for status
          name: "CL_STATUS",
          desc: "Contain the current status of the corresponding cache line                [0]: valid, [1]: dirty, [2]: cmpt",
        }
      ]
    },
    { name:     "TAG_1137",
      desc:     "Tag Address stored in cache line 1137",
      swaccess: "rw",
      hwaccess: "hrw",
      hwext:    "true",
      hwqe:     "true", // enable `qe` latched signal of software write pulse
      hwre:     "true",
      fields: [
        { bits: "5-1:0",
          name: "CL_TAG",
          desc: "Tag Address"
        }
      ]
    },
    {
      name:     "STATUS_1138",
      desc:     "Status register of cache line 1138",
      swaccess: "rw",
      hwaccess: "hrw",
      hwext:    "true",
      hwqe:     "true", // enable `qe` latched signal of software write pulse
      hwre:     "true",
      fields: [
        {
          bits: "5+3:5", // 2 bits for status
          name: "CL_STATUS",
          desc: "Contain the current status of the corresponding cache line                [0]: valid, [1]: dirty, [2]: cmpt",
        }
      ]
    },
    { name:     "TAG_1138",
      desc:     "Tag Address stored in cache line 1138",
      swaccess: "rw",
      hwaccess: "hrw",
      hwext:    "true",
      hwqe:     "true", // enable `qe` latched signal of software write pulse
      hwre:     "true",
      fields: [
        { bits: "5-1:0",
          name: "CL_TAG",
          desc: "Tag Address"
        }
      ]
    },
    {
      name:     "STATUS_1139",
      desc:     "Status register of cache line 1139",
      swaccess: "rw",
      hwaccess: "hrw",
      hwext:    "true",
      hwqe:     "true", // enable `qe` latched signal of software write pulse
      hwre:     "true",
      fields: [
        {
          bits: "5+3:5", // 2 bits for status
          name: "CL_STATUS",
          desc: "Contain the current status of the corresponding cache line                [0]: valid, [1]: dirty, [2]: cmpt",
        }
      ]
    },
    { name:     "TAG_1139",
      desc:     "Tag Address stored in cache line 1139",
      swaccess: "rw",
      hwaccess: "hrw",
      hwext:    "true",
      hwqe:     "true", // enable `qe` latched signal of software write pulse
      hwre:     "true",
      fields: [
        { bits: "5-1:0",
          name: "CL_TAG",
          desc: "Tag Address"
        }
      ]
    },
    {
      name:     "STATUS_1140",
      desc:     "Status register of cache line 1140",
      swaccess: "rw",
      hwaccess: "hrw",
      hwext:    "true",
      hwqe:     "true", // enable `qe` latched signal of software write pulse
      hwre:     "true",
      fields: [
        {
          bits: "5+3:5", // 2 bits for status
          name: "CL_STATUS",
          desc: "Contain the current status of the corresponding cache line                [0]: valid, [1]: dirty, [2]: cmpt",
        }
      ]
    },
    { name:     "TAG_1140",
      desc:     "Tag Address stored in cache line 1140",
      swaccess: "rw",
      hwaccess: "hrw",
      hwext:    "true",
      hwqe:     "true", // enable `qe` latched signal of software write pulse
      hwre:     "true",
      fields: [
        { bits: "5-1:0",
          name: "CL_TAG",
          desc: "Tag Address"
        }
      ]
    },
    {
      name:     "STATUS_1141",
      desc:     "Status register of cache line 1141",
      swaccess: "rw",
      hwaccess: "hrw",
      hwext:    "true",
      hwqe:     "true", // enable `qe` latched signal of software write pulse
      hwre:     "true",
      fields: [
        {
          bits: "5+3:5", // 2 bits for status
          name: "CL_STATUS",
          desc: "Contain the current status of the corresponding cache line                [0]: valid, [1]: dirty, [2]: cmpt",
        }
      ]
    },
    { name:     "TAG_1141",
      desc:     "Tag Address stored in cache line 1141",
      swaccess: "rw",
      hwaccess: "hrw",
      hwext:    "true",
      hwqe:     "true", // enable `qe` latched signal of software write pulse
      hwre:     "true",
      fields: [
        { bits: "5-1:0",
          name: "CL_TAG",
          desc: "Tag Address"
        }
      ]
    },
    {
      name:     "STATUS_1142",
      desc:     "Status register of cache line 1142",
      swaccess: "rw",
      hwaccess: "hrw",
      hwext:    "true",
      hwqe:     "true", // enable `qe` latched signal of software write pulse
      hwre:     "true",
      fields: [
        {
          bits: "5+3:5", // 2 bits for status
          name: "CL_STATUS",
          desc: "Contain the current status of the corresponding cache line                [0]: valid, [1]: dirty, [2]: cmpt",
        }
      ]
    },
    { name:     "TAG_1142",
      desc:     "Tag Address stored in cache line 1142",
      swaccess: "rw",
      hwaccess: "hrw",
      hwext:    "true",
      hwqe:     "true", // enable `qe` latched signal of software write pulse
      hwre:     "true",
      fields: [
        { bits: "5-1:0",
          name: "CL_TAG",
          desc: "Tag Address"
        }
      ]
    },
    {
      name:     "STATUS_1143",
      desc:     "Status register of cache line 1143",
      swaccess: "rw",
      hwaccess: "hrw",
      hwext:    "true",
      hwqe:     "true", // enable `qe` latched signal of software write pulse
      hwre:     "true",
      fields: [
        {
          bits: "5+3:5", // 2 bits for status
          name: "CL_STATUS",
          desc: "Contain the current status of the corresponding cache line                [0]: valid, [1]: dirty, [2]: cmpt",
        }
      ]
    },
    { name:     "TAG_1143",
      desc:     "Tag Address stored in cache line 1143",
      swaccess: "rw",
      hwaccess: "hrw",
      hwext:    "true",
      hwqe:     "true", // enable `qe` latched signal of software write pulse
      hwre:     "true",
      fields: [
        { bits: "5-1:0",
          name: "CL_TAG",
          desc: "Tag Address"
        }
      ]
    },
    {
      name:     "STATUS_1144",
      desc:     "Status register of cache line 1144",
      swaccess: "rw",
      hwaccess: "hrw",
      hwext:    "true",
      hwqe:     "true", // enable `qe` latched signal of software write pulse
      hwre:     "true",
      fields: [
        {
          bits: "5+3:5", // 2 bits for status
          name: "CL_STATUS",
          desc: "Contain the current status of the corresponding cache line                [0]: valid, [1]: dirty, [2]: cmpt",
        }
      ]
    },
    { name:     "TAG_1144",
      desc:     "Tag Address stored in cache line 1144",
      swaccess: "rw",
      hwaccess: "hrw",
      hwext:    "true",
      hwqe:     "true", // enable `qe` latched signal of software write pulse
      hwre:     "true",
      fields: [
        { bits: "5-1:0",
          name: "CL_TAG",
          desc: "Tag Address"
        }
      ]
    },
    {
      name:     "STATUS_1145",
      desc:     "Status register of cache line 1145",
      swaccess: "rw",
      hwaccess: "hrw",
      hwext:    "true",
      hwqe:     "true", // enable `qe` latched signal of software write pulse
      hwre:     "true",
      fields: [
        {
          bits: "5+3:5", // 2 bits for status
          name: "CL_STATUS",
          desc: "Contain the current status of the corresponding cache line                [0]: valid, [1]: dirty, [2]: cmpt",
        }
      ]
    },
    { name:     "TAG_1145",
      desc:     "Tag Address stored in cache line 1145",
      swaccess: "rw",
      hwaccess: "hrw",
      hwext:    "true",
      hwqe:     "true", // enable `qe` latched signal of software write pulse
      hwre:     "true",
      fields: [
        { bits: "5-1:0",
          name: "CL_TAG",
          desc: "Tag Address"
        }
      ]
    },
    {
      name:     "STATUS_1146",
      desc:     "Status register of cache line 1146",
      swaccess: "rw",
      hwaccess: "hrw",
      hwext:    "true",
      hwqe:     "true", // enable `qe` latched signal of software write pulse
      hwre:     "true",
      fields: [
        {
          bits: "5+3:5", // 2 bits for status
          name: "CL_STATUS",
          desc: "Contain the current status of the corresponding cache line                [0]: valid, [1]: dirty, [2]: cmpt",
        }
      ]
    },
    { name:     "TAG_1146",
      desc:     "Tag Address stored in cache line 1146",
      swaccess: "rw",
      hwaccess: "hrw",
      hwext:    "true",
      hwqe:     "true", // enable `qe` latched signal of software write pulse
      hwre:     "true",
      fields: [
        { bits: "5-1:0",
          name: "CL_TAG",
          desc: "Tag Address"
        }
      ]
    },
    {
      name:     "STATUS_1147",
      desc:     "Status register of cache line 1147",
      swaccess: "rw",
      hwaccess: "hrw",
      hwext:    "true",
      hwqe:     "true", // enable `qe` latched signal of software write pulse
      hwre:     "true",
      fields: [
        {
          bits: "5+3:5", // 2 bits for status
          name: "CL_STATUS",
          desc: "Contain the current status of the corresponding cache line                [0]: valid, [1]: dirty, [2]: cmpt",
        }
      ]
    },
    { name:     "TAG_1147",
      desc:     "Tag Address stored in cache line 1147",
      swaccess: "rw",
      hwaccess: "hrw",
      hwext:    "true",
      hwqe:     "true", // enable `qe` latched signal of software write pulse
      hwre:     "true",
      fields: [
        { bits: "5-1:0",
          name: "CL_TAG",
          desc: "Tag Address"
        }
      ]
    },
    {
      name:     "STATUS_1148",
      desc:     "Status register of cache line 1148",
      swaccess: "rw",
      hwaccess: "hrw",
      hwext:    "true",
      hwqe:     "true", // enable `qe` latched signal of software write pulse
      hwre:     "true",
      fields: [
        {
          bits: "5+3:5", // 2 bits for status
          name: "CL_STATUS",
          desc: "Contain the current status of the corresponding cache line                [0]: valid, [1]: dirty, [2]: cmpt",
        }
      ]
    },
    { name:     "TAG_1148",
      desc:     "Tag Address stored in cache line 1148",
      swaccess: "rw",
      hwaccess: "hrw",
      hwext:    "true",
      hwqe:     "true", // enable `qe` latched signal of software write pulse
      hwre:     "true",
      fields: [
        { bits: "5-1:0",
          name: "CL_TAG",
          desc: "Tag Address"
        }
      ]
    },
    {
      name:     "STATUS_1149",
      desc:     "Status register of cache line 1149",
      swaccess: "rw",
      hwaccess: "hrw",
      hwext:    "true",
      hwqe:     "true", // enable `qe` latched signal of software write pulse
      hwre:     "true",
      fields: [
        {
          bits: "5+3:5", // 2 bits for status
          name: "CL_STATUS",
          desc: "Contain the current status of the corresponding cache line                [0]: valid, [1]: dirty, [2]: cmpt",
        }
      ]
    },
    { name:     "TAG_1149",
      desc:     "Tag Address stored in cache line 1149",
      swaccess: "rw",
      hwaccess: "hrw",
      hwext:    "true",
      hwqe:     "true", // enable `qe` latched signal of software write pulse
      hwre:     "true",
      fields: [
        { bits: "5-1:0",
          name: "CL_TAG",
          desc: "Tag Address"
        }
      ]
    },
    {
      name:     "STATUS_1150",
      desc:     "Status register of cache line 1150",
      swaccess: "rw",
      hwaccess: "hrw",
      hwext:    "true",
      hwqe:     "true", // enable `qe` latched signal of software write pulse
      hwre:     "true",
      fields: [
        {
          bits: "5+3:5", // 2 bits for status
          name: "CL_STATUS",
          desc: "Contain the current status of the corresponding cache line                [0]: valid, [1]: dirty, [2]: cmpt",
        }
      ]
    },
    { name:     "TAG_1150",
      desc:     "Tag Address stored in cache line 1150",
      swaccess: "rw",
      hwaccess: "hrw",
      hwext:    "true",
      hwqe:     "true", // enable `qe` latched signal of software write pulse
      hwre:     "true",
      fields: [
        { bits: "5-1:0",
          name: "CL_TAG",
          desc: "Tag Address"
        }
      ]
    },
    {
      name:     "STATUS_1151",
      desc:     "Status register of cache line 1151",
      swaccess: "rw",
      hwaccess: "hrw",
      hwext:    "true",
      hwqe:     "true", // enable `qe` latched signal of software write pulse
      hwre:     "true",
      fields: [
        {
          bits: "5+3:5", // 2 bits for status
          name: "CL_STATUS",
          desc: "Contain the current status of the corresponding cache line                [0]: valid, [1]: dirty, [2]: cmpt",
        }
      ]
    },
    { name:     "TAG_1151",
      desc:     "Tag Address stored in cache line 1151",
      swaccess: "rw",
      hwaccess: "hrw",
      hwext:    "true",
      hwqe:     "true", // enable `qe` latched signal of software write pulse
      hwre:     "true",
      fields: [
        { bits: "5-1:0",
          name: "CL_TAG",
          desc: "Tag Address"
        }
      ]
    },
    {
      name:     "STATUS_1152",
      desc:     "Status register of cache line 1152",
      swaccess: "rw",
      hwaccess: "hrw",
      hwext:    "true",
      hwqe:     "true", // enable `qe` latched signal of software write pulse
      hwre:     "true",
      fields: [
        {
          bits: "5+3:5", // 2 bits for status
          name: "CL_STATUS",
          desc: "Contain the current status of the corresponding cache line                [0]: valid, [1]: dirty, [2]: cmpt",
        }
      ]
    },
    { name:     "TAG_1152",
      desc:     "Tag Address stored in cache line 1152",
      swaccess: "rw",
      hwaccess: "hrw",
      hwext:    "true",
      hwqe:     "true", // enable `qe` latched signal of software write pulse
      hwre:     "true",
      fields: [
        { bits: "5-1:0",
          name: "CL_TAG",
          desc: "Tag Address"
        }
      ]
    },
    {
      name:     "STATUS_1153",
      desc:     "Status register of cache line 1153",
      swaccess: "rw",
      hwaccess: "hrw",
      hwext:    "true",
      hwqe:     "true", // enable `qe` latched signal of software write pulse
      hwre:     "true",
      fields: [
        {
          bits: "5+3:5", // 2 bits for status
          name: "CL_STATUS",
          desc: "Contain the current status of the corresponding cache line                [0]: valid, [1]: dirty, [2]: cmpt",
        }
      ]
    },
    { name:     "TAG_1153",
      desc:     "Tag Address stored in cache line 1153",
      swaccess: "rw",
      hwaccess: "hrw",
      hwext:    "true",
      hwqe:     "true", // enable `qe` latched signal of software write pulse
      hwre:     "true",
      fields: [
        { bits: "5-1:0",
          name: "CL_TAG",
          desc: "Tag Address"
        }
      ]
    },
    {
      name:     "STATUS_1154",
      desc:     "Status register of cache line 1154",
      swaccess: "rw",
      hwaccess: "hrw",
      hwext:    "true",
      hwqe:     "true", // enable `qe` latched signal of software write pulse
      hwre:     "true",
      fields: [
        {
          bits: "5+3:5", // 2 bits for status
          name: "CL_STATUS",
          desc: "Contain the current status of the corresponding cache line                [0]: valid, [1]: dirty, [2]: cmpt",
        }
      ]
    },
    { name:     "TAG_1154",
      desc:     "Tag Address stored in cache line 1154",
      swaccess: "rw",
      hwaccess: "hrw",
      hwext:    "true",
      hwqe:     "true", // enable `qe` latched signal of software write pulse
      hwre:     "true",
      fields: [
        { bits: "5-1:0",
          name: "CL_TAG",
          desc: "Tag Address"
        }
      ]
    },
    {
      name:     "STATUS_1155",
      desc:     "Status register of cache line 1155",
      swaccess: "rw",
      hwaccess: "hrw",
      hwext:    "true",
      hwqe:     "true", // enable `qe` latched signal of software write pulse
      hwre:     "true",
      fields: [
        {
          bits: "5+3:5", // 2 bits for status
          name: "CL_STATUS",
          desc: "Contain the current status of the corresponding cache line                [0]: valid, [1]: dirty, [2]: cmpt",
        }
      ]
    },
    { name:     "TAG_1155",
      desc:     "Tag Address stored in cache line 1155",
      swaccess: "rw",
      hwaccess: "hrw",
      hwext:    "true",
      hwqe:     "true", // enable `qe` latched signal of software write pulse
      hwre:     "true",
      fields: [
        { bits: "5-1:0",
          name: "CL_TAG",
          desc: "Tag Address"
        }
      ]
    },
    {
      name:     "STATUS_1156",
      desc:     "Status register of cache line 1156",
      swaccess: "rw",
      hwaccess: "hrw",
      hwext:    "true",
      hwqe:     "true", // enable `qe` latched signal of software write pulse
      hwre:     "true",
      fields: [
        {
          bits: "5+3:5", // 2 bits for status
          name: "CL_STATUS",
          desc: "Contain the current status of the corresponding cache line                [0]: valid, [1]: dirty, [2]: cmpt",
        }
      ]
    },
    { name:     "TAG_1156",
      desc:     "Tag Address stored in cache line 1156",
      swaccess: "rw",
      hwaccess: "hrw",
      hwext:    "true",
      hwqe:     "true", // enable `qe` latched signal of software write pulse
      hwre:     "true",
      fields: [
        { bits: "5-1:0",
          name: "CL_TAG",
          desc: "Tag Address"
        }
      ]
    },
    {
      name:     "STATUS_1157",
      desc:     "Status register of cache line 1157",
      swaccess: "rw",
      hwaccess: "hrw",
      hwext:    "true",
      hwqe:     "true", // enable `qe` latched signal of software write pulse
      hwre:     "true",
      fields: [
        {
          bits: "5+3:5", // 2 bits for status
          name: "CL_STATUS",
          desc: "Contain the current status of the corresponding cache line                [0]: valid, [1]: dirty, [2]: cmpt",
        }
      ]
    },
    { name:     "TAG_1157",
      desc:     "Tag Address stored in cache line 1157",
      swaccess: "rw",
      hwaccess: "hrw",
      hwext:    "true",
      hwqe:     "true", // enable `qe` latched signal of software write pulse
      hwre:     "true",
      fields: [
        { bits: "5-1:0",
          name: "CL_TAG",
          desc: "Tag Address"
        }
      ]
    },
    {
      name:     "STATUS_1158",
      desc:     "Status register of cache line 1158",
      swaccess: "rw",
      hwaccess: "hrw",
      hwext:    "true",
      hwqe:     "true", // enable `qe` latched signal of software write pulse
      hwre:     "true",
      fields: [
        {
          bits: "5+3:5", // 2 bits for status
          name: "CL_STATUS",
          desc: "Contain the current status of the corresponding cache line                [0]: valid, [1]: dirty, [2]: cmpt",
        }
      ]
    },
    { name:     "TAG_1158",
      desc:     "Tag Address stored in cache line 1158",
      swaccess: "rw",
      hwaccess: "hrw",
      hwext:    "true",
      hwqe:     "true", // enable `qe` latched signal of software write pulse
      hwre:     "true",
      fields: [
        { bits: "5-1:0",
          name: "CL_TAG",
          desc: "Tag Address"
        }
      ]
    },
    {
      name:     "STATUS_1159",
      desc:     "Status register of cache line 1159",
      swaccess: "rw",
      hwaccess: "hrw",
      hwext:    "true",
      hwqe:     "true", // enable `qe` latched signal of software write pulse
      hwre:     "true",
      fields: [
        {
          bits: "5+3:5", // 2 bits for status
          name: "CL_STATUS",
          desc: "Contain the current status of the corresponding cache line                [0]: valid, [1]: dirty, [2]: cmpt",
        }
      ]
    },
    { name:     "TAG_1159",
      desc:     "Tag Address stored in cache line 1159",
      swaccess: "rw",
      hwaccess: "hrw",
      hwext:    "true",
      hwqe:     "true", // enable `qe` latched signal of software write pulse
      hwre:     "true",
      fields: [
        { bits: "5-1:0",
          name: "CL_TAG",
          desc: "Tag Address"
        }
      ]
    },
    {
      name:     "STATUS_1160",
      desc:     "Status register of cache line 1160",
      swaccess: "rw",
      hwaccess: "hrw",
      hwext:    "true",
      hwqe:     "true", // enable `qe` latched signal of software write pulse
      hwre:     "true",
      fields: [
        {
          bits: "5+3:5", // 2 bits for status
          name: "CL_STATUS",
          desc: "Contain the current status of the corresponding cache line                [0]: valid, [1]: dirty, [2]: cmpt",
        }
      ]
    },
    { name:     "TAG_1160",
      desc:     "Tag Address stored in cache line 1160",
      swaccess: "rw",
      hwaccess: "hrw",
      hwext:    "true",
      hwqe:     "true", // enable `qe` latched signal of software write pulse
      hwre:     "true",
      fields: [
        { bits: "5-1:0",
          name: "CL_TAG",
          desc: "Tag Address"
        }
      ]
    },
    {
      name:     "STATUS_1161",
      desc:     "Status register of cache line 1161",
      swaccess: "rw",
      hwaccess: "hrw",
      hwext:    "true",
      hwqe:     "true", // enable `qe` latched signal of software write pulse
      hwre:     "true",
      fields: [
        {
          bits: "5+3:5", // 2 bits for status
          name: "CL_STATUS",
          desc: "Contain the current status of the corresponding cache line                [0]: valid, [1]: dirty, [2]: cmpt",
        }
      ]
    },
    { name:     "TAG_1161",
      desc:     "Tag Address stored in cache line 1161",
      swaccess: "rw",
      hwaccess: "hrw",
      hwext:    "true",
      hwqe:     "true", // enable `qe` latched signal of software write pulse
      hwre:     "true",
      fields: [
        { bits: "5-1:0",
          name: "CL_TAG",
          desc: "Tag Address"
        }
      ]
    },
    {
      name:     "STATUS_1162",
      desc:     "Status register of cache line 1162",
      swaccess: "rw",
      hwaccess: "hrw",
      hwext:    "true",
      hwqe:     "true", // enable `qe` latched signal of software write pulse
      hwre:     "true",
      fields: [
        {
          bits: "5+3:5", // 2 bits for status
          name: "CL_STATUS",
          desc: "Contain the current status of the corresponding cache line                [0]: valid, [1]: dirty, [2]: cmpt",
        }
      ]
    },
    { name:     "TAG_1162",
      desc:     "Tag Address stored in cache line 1162",
      swaccess: "rw",
      hwaccess: "hrw",
      hwext:    "true",
      hwqe:     "true", // enable `qe` latched signal of software write pulse
      hwre:     "true",
      fields: [
        { bits: "5-1:0",
          name: "CL_TAG",
          desc: "Tag Address"
        }
      ]
    },
    {
      name:     "STATUS_1163",
      desc:     "Status register of cache line 1163",
      swaccess: "rw",
      hwaccess: "hrw",
      hwext:    "true",
      hwqe:     "true", // enable `qe` latched signal of software write pulse
      hwre:     "true",
      fields: [
        {
          bits: "5+3:5", // 2 bits for status
          name: "CL_STATUS",
          desc: "Contain the current status of the corresponding cache line                [0]: valid, [1]: dirty, [2]: cmpt",
        }
      ]
    },
    { name:     "TAG_1163",
      desc:     "Tag Address stored in cache line 1163",
      swaccess: "rw",
      hwaccess: "hrw",
      hwext:    "true",
      hwqe:     "true", // enable `qe` latched signal of software write pulse
      hwre:     "true",
      fields: [
        { bits: "5-1:0",
          name: "CL_TAG",
          desc: "Tag Address"
        }
      ]
    },
    {
      name:     "STATUS_1164",
      desc:     "Status register of cache line 1164",
      swaccess: "rw",
      hwaccess: "hrw",
      hwext:    "true",
      hwqe:     "true", // enable `qe` latched signal of software write pulse
      hwre:     "true",
      fields: [
        {
          bits: "5+3:5", // 2 bits for status
          name: "CL_STATUS",
          desc: "Contain the current status of the corresponding cache line                [0]: valid, [1]: dirty, [2]: cmpt",
        }
      ]
    },
    { name:     "TAG_1164",
      desc:     "Tag Address stored in cache line 1164",
      swaccess: "rw",
      hwaccess: "hrw",
      hwext:    "true",
      hwqe:     "true", // enable `qe` latched signal of software write pulse
      hwre:     "true",
      fields: [
        { bits: "5-1:0",
          name: "CL_TAG",
          desc: "Tag Address"
        }
      ]
    },
    {
      name:     "STATUS_1165",
      desc:     "Status register of cache line 1165",
      swaccess: "rw",
      hwaccess: "hrw",
      hwext:    "true",
      hwqe:     "true", // enable `qe` latched signal of software write pulse
      hwre:     "true",
      fields: [
        {
          bits: "5+3:5", // 2 bits for status
          name: "CL_STATUS",
          desc: "Contain the current status of the corresponding cache line                [0]: valid, [1]: dirty, [2]: cmpt",
        }
      ]
    },
    { name:     "TAG_1165",
      desc:     "Tag Address stored in cache line 1165",
      swaccess: "rw",
      hwaccess: "hrw",
      hwext:    "true",
      hwqe:     "true", // enable `qe` latched signal of software write pulse
      hwre:     "true",
      fields: [
        { bits: "5-1:0",
          name: "CL_TAG",
          desc: "Tag Address"
        }
      ]
    },
    {
      name:     "STATUS_1166",
      desc:     "Status register of cache line 1166",
      swaccess: "rw",
      hwaccess: "hrw",
      hwext:    "true",
      hwqe:     "true", // enable `qe` latched signal of software write pulse
      hwre:     "true",
      fields: [
        {
          bits: "5+3:5", // 2 bits for status
          name: "CL_STATUS",
          desc: "Contain the current status of the corresponding cache line                [0]: valid, [1]: dirty, [2]: cmpt",
        }
      ]
    },
    { name:     "TAG_1166",
      desc:     "Tag Address stored in cache line 1166",
      swaccess: "rw",
      hwaccess: "hrw",
      hwext:    "true",
      hwqe:     "true", // enable `qe` latched signal of software write pulse
      hwre:     "true",
      fields: [
        { bits: "5-1:0",
          name: "CL_TAG",
          desc: "Tag Address"
        }
      ]
    },
    {
      name:     "STATUS_1167",
      desc:     "Status register of cache line 1167",
      swaccess: "rw",
      hwaccess: "hrw",
      hwext:    "true",
      hwqe:     "true", // enable `qe` latched signal of software write pulse
      hwre:     "true",
      fields: [
        {
          bits: "5+3:5", // 2 bits for status
          name: "CL_STATUS",
          desc: "Contain the current status of the corresponding cache line                [0]: valid, [1]: dirty, [2]: cmpt",
        }
      ]
    },
    { name:     "TAG_1167",
      desc:     "Tag Address stored in cache line 1167",
      swaccess: "rw",
      hwaccess: "hrw",
      hwext:    "true",
      hwqe:     "true", // enable `qe` latched signal of software write pulse
      hwre:     "true",
      fields: [
        { bits: "5-1:0",
          name: "CL_TAG",
          desc: "Tag Address"
        }
      ]
    },
    {
      name:     "STATUS_1168",
      desc:     "Status register of cache line 1168",
      swaccess: "rw",
      hwaccess: "hrw",
      hwext:    "true",
      hwqe:     "true", // enable `qe` latched signal of software write pulse
      hwre:     "true",
      fields: [
        {
          bits: "5+3:5", // 2 bits for status
          name: "CL_STATUS",
          desc: "Contain the current status of the corresponding cache line                [0]: valid, [1]: dirty, [2]: cmpt",
        }
      ]
    },
    { name:     "TAG_1168",
      desc:     "Tag Address stored in cache line 1168",
      swaccess: "rw",
      hwaccess: "hrw",
      hwext:    "true",
      hwqe:     "true", // enable `qe` latched signal of software write pulse
      hwre:     "true",
      fields: [
        { bits: "5-1:0",
          name: "CL_TAG",
          desc: "Tag Address"
        }
      ]
    },
    {
      name:     "STATUS_1169",
      desc:     "Status register of cache line 1169",
      swaccess: "rw",
      hwaccess: "hrw",
      hwext:    "true",
      hwqe:     "true", // enable `qe` latched signal of software write pulse
      hwre:     "true",
      fields: [
        {
          bits: "5+3:5", // 2 bits for status
          name: "CL_STATUS",
          desc: "Contain the current status of the corresponding cache line                [0]: valid, [1]: dirty, [2]: cmpt",
        }
      ]
    },
    { name:     "TAG_1169",
      desc:     "Tag Address stored in cache line 1169",
      swaccess: "rw",
      hwaccess: "hrw",
      hwext:    "true",
      hwqe:     "true", // enable `qe` latched signal of software write pulse
      hwre:     "true",
      fields: [
        { bits: "5-1:0",
          name: "CL_TAG",
          desc: "Tag Address"
        }
      ]
    },
    {
      name:     "STATUS_1170",
      desc:     "Status register of cache line 1170",
      swaccess: "rw",
      hwaccess: "hrw",
      hwext:    "true",
      hwqe:     "true", // enable `qe` latched signal of software write pulse
      hwre:     "true",
      fields: [
        {
          bits: "5+3:5", // 2 bits for status
          name: "CL_STATUS",
          desc: "Contain the current status of the corresponding cache line                [0]: valid, [1]: dirty, [2]: cmpt",
        }
      ]
    },
    { name:     "TAG_1170",
      desc:     "Tag Address stored in cache line 1170",
      swaccess: "rw",
      hwaccess: "hrw",
      hwext:    "true",
      hwqe:     "true", // enable `qe` latched signal of software write pulse
      hwre:     "true",
      fields: [
        { bits: "5-1:0",
          name: "CL_TAG",
          desc: "Tag Address"
        }
      ]
    },
    {
      name:     "STATUS_1171",
      desc:     "Status register of cache line 1171",
      swaccess: "rw",
      hwaccess: "hrw",
      hwext:    "true",
      hwqe:     "true", // enable `qe` latched signal of software write pulse
      hwre:     "true",
      fields: [
        {
          bits: "5+3:5", // 2 bits for status
          name: "CL_STATUS",
          desc: "Contain the current status of the corresponding cache line                [0]: valid, [1]: dirty, [2]: cmpt",
        }
      ]
    },
    { name:     "TAG_1171",
      desc:     "Tag Address stored in cache line 1171",
      swaccess: "rw",
      hwaccess: "hrw",
      hwext:    "true",
      hwqe:     "true", // enable `qe` latched signal of software write pulse
      hwre:     "true",
      fields: [
        { bits: "5-1:0",
          name: "CL_TAG",
          desc: "Tag Address"
        }
      ]
    },
    {
      name:     "STATUS_1172",
      desc:     "Status register of cache line 1172",
      swaccess: "rw",
      hwaccess: "hrw",
      hwext:    "true",
      hwqe:     "true", // enable `qe` latched signal of software write pulse
      hwre:     "true",
      fields: [
        {
          bits: "5+3:5", // 2 bits for status
          name: "CL_STATUS",
          desc: "Contain the current status of the corresponding cache line                [0]: valid, [1]: dirty, [2]: cmpt",
        }
      ]
    },
    { name:     "TAG_1172",
      desc:     "Tag Address stored in cache line 1172",
      swaccess: "rw",
      hwaccess: "hrw",
      hwext:    "true",
      hwqe:     "true", // enable `qe` latched signal of software write pulse
      hwre:     "true",
      fields: [
        { bits: "5-1:0",
          name: "CL_TAG",
          desc: "Tag Address"
        }
      ]
    },
    {
      name:     "STATUS_1173",
      desc:     "Status register of cache line 1173",
      swaccess: "rw",
      hwaccess: "hrw",
      hwext:    "true",
      hwqe:     "true", // enable `qe` latched signal of software write pulse
      hwre:     "true",
      fields: [
        {
          bits: "5+3:5", // 2 bits for status
          name: "CL_STATUS",
          desc: "Contain the current status of the corresponding cache line                [0]: valid, [1]: dirty, [2]: cmpt",
        }
      ]
    },
    { name:     "TAG_1173",
      desc:     "Tag Address stored in cache line 1173",
      swaccess: "rw",
      hwaccess: "hrw",
      hwext:    "true",
      hwqe:     "true", // enable `qe` latched signal of software write pulse
      hwre:     "true",
      fields: [
        { bits: "5-1:0",
          name: "CL_TAG",
          desc: "Tag Address"
        }
      ]
    },
    {
      name:     "STATUS_1174",
      desc:     "Status register of cache line 1174",
      swaccess: "rw",
      hwaccess: "hrw",
      hwext:    "true",
      hwqe:     "true", // enable `qe` latched signal of software write pulse
      hwre:     "true",
      fields: [
        {
          bits: "5+3:5", // 2 bits for status
          name: "CL_STATUS",
          desc: "Contain the current status of the corresponding cache line                [0]: valid, [1]: dirty, [2]: cmpt",
        }
      ]
    },
    { name:     "TAG_1174",
      desc:     "Tag Address stored in cache line 1174",
      swaccess: "rw",
      hwaccess: "hrw",
      hwext:    "true",
      hwqe:     "true", // enable `qe` latched signal of software write pulse
      hwre:     "true",
      fields: [
        { bits: "5-1:0",
          name: "CL_TAG",
          desc: "Tag Address"
        }
      ]
    },
    {
      name:     "STATUS_1175",
      desc:     "Status register of cache line 1175",
      swaccess: "rw",
      hwaccess: "hrw",
      hwext:    "true",
      hwqe:     "true", // enable `qe` latched signal of software write pulse
      hwre:     "true",
      fields: [
        {
          bits: "5+3:5", // 2 bits for status
          name: "CL_STATUS",
          desc: "Contain the current status of the corresponding cache line                [0]: valid, [1]: dirty, [2]: cmpt",
        }
      ]
    },
    { name:     "TAG_1175",
      desc:     "Tag Address stored in cache line 1175",
      swaccess: "rw",
      hwaccess: "hrw",
      hwext:    "true",
      hwqe:     "true", // enable `qe` latched signal of software write pulse
      hwre:     "true",
      fields: [
        { bits: "5-1:0",
          name: "CL_TAG",
          desc: "Tag Address"
        }
      ]
    },
    {
      name:     "STATUS_1176",
      desc:     "Status register of cache line 1176",
      swaccess: "rw",
      hwaccess: "hrw",
      hwext:    "true",
      hwqe:     "true", // enable `qe` latched signal of software write pulse
      hwre:     "true",
      fields: [
        {
          bits: "5+3:5", // 2 bits for status
          name: "CL_STATUS",
          desc: "Contain the current status of the corresponding cache line                [0]: valid, [1]: dirty, [2]: cmpt",
        }
      ]
    },
    { name:     "TAG_1176",
      desc:     "Tag Address stored in cache line 1176",
      swaccess: "rw",
      hwaccess: "hrw",
      hwext:    "true",
      hwqe:     "true", // enable `qe` latched signal of software write pulse
      hwre:     "true",
      fields: [
        { bits: "5-1:0",
          name: "CL_TAG",
          desc: "Tag Address"
        }
      ]
    },
    {
      name:     "STATUS_1177",
      desc:     "Status register of cache line 1177",
      swaccess: "rw",
      hwaccess: "hrw",
      hwext:    "true",
      hwqe:     "true", // enable `qe` latched signal of software write pulse
      hwre:     "true",
      fields: [
        {
          bits: "5+3:5", // 2 bits for status
          name: "CL_STATUS",
          desc: "Contain the current status of the corresponding cache line                [0]: valid, [1]: dirty, [2]: cmpt",
        }
      ]
    },
    { name:     "TAG_1177",
      desc:     "Tag Address stored in cache line 1177",
      swaccess: "rw",
      hwaccess: "hrw",
      hwext:    "true",
      hwqe:     "true", // enable `qe` latched signal of software write pulse
      hwre:     "true",
      fields: [
        { bits: "5-1:0",
          name: "CL_TAG",
          desc: "Tag Address"
        }
      ]
    },
    {
      name:     "STATUS_1178",
      desc:     "Status register of cache line 1178",
      swaccess: "rw",
      hwaccess: "hrw",
      hwext:    "true",
      hwqe:     "true", // enable `qe` latched signal of software write pulse
      hwre:     "true",
      fields: [
        {
          bits: "5+3:5", // 2 bits for status
          name: "CL_STATUS",
          desc: "Contain the current status of the corresponding cache line                [0]: valid, [1]: dirty, [2]: cmpt",
        }
      ]
    },
    { name:     "TAG_1178",
      desc:     "Tag Address stored in cache line 1178",
      swaccess: "rw",
      hwaccess: "hrw",
      hwext:    "true",
      hwqe:     "true", // enable `qe` latched signal of software write pulse
      hwre:     "true",
      fields: [
        { bits: "5-1:0",
          name: "CL_TAG",
          desc: "Tag Address"
        }
      ]
    },
    {
      name:     "STATUS_1179",
      desc:     "Status register of cache line 1179",
      swaccess: "rw",
      hwaccess: "hrw",
      hwext:    "true",
      hwqe:     "true", // enable `qe` latched signal of software write pulse
      hwre:     "true",
      fields: [
        {
          bits: "5+3:5", // 2 bits for status
          name: "CL_STATUS",
          desc: "Contain the current status of the corresponding cache line                [0]: valid, [1]: dirty, [2]: cmpt",
        }
      ]
    },
    { name:     "TAG_1179",
      desc:     "Tag Address stored in cache line 1179",
      swaccess: "rw",
      hwaccess: "hrw",
      hwext:    "true",
      hwqe:     "true", // enable `qe` latched signal of software write pulse
      hwre:     "true",
      fields: [
        { bits: "5-1:0",
          name: "CL_TAG",
          desc: "Tag Address"
        }
      ]
    },
    {
      name:     "STATUS_1180",
      desc:     "Status register of cache line 1180",
      swaccess: "rw",
      hwaccess: "hrw",
      hwext:    "true",
      hwqe:     "true", // enable `qe` latched signal of software write pulse
      hwre:     "true",
      fields: [
        {
          bits: "5+3:5", // 2 bits for status
          name: "CL_STATUS",
          desc: "Contain the current status of the corresponding cache line                [0]: valid, [1]: dirty, [2]: cmpt",
        }
      ]
    },
    { name:     "TAG_1180",
      desc:     "Tag Address stored in cache line 1180",
      swaccess: "rw",
      hwaccess: "hrw",
      hwext:    "true",
      hwqe:     "true", // enable `qe` latched signal of software write pulse
      hwre:     "true",
      fields: [
        { bits: "5-1:0",
          name: "CL_TAG",
          desc: "Tag Address"
        }
      ]
    },
    {
      name:     "STATUS_1181",
      desc:     "Status register of cache line 1181",
      swaccess: "rw",
      hwaccess: "hrw",
      hwext:    "true",
      hwqe:     "true", // enable `qe` latched signal of software write pulse
      hwre:     "true",
      fields: [
        {
          bits: "5+3:5", // 2 bits for status
          name: "CL_STATUS",
          desc: "Contain the current status of the corresponding cache line                [0]: valid, [1]: dirty, [2]: cmpt",
        }
      ]
    },
    { name:     "TAG_1181",
      desc:     "Tag Address stored in cache line 1181",
      swaccess: "rw",
      hwaccess: "hrw",
      hwext:    "true",
      hwqe:     "true", // enable `qe` latched signal of software write pulse
      hwre:     "true",
      fields: [
        { bits: "5-1:0",
          name: "CL_TAG",
          desc: "Tag Address"
        }
      ]
    },
    {
      name:     "STATUS_1182",
      desc:     "Status register of cache line 1182",
      swaccess: "rw",
      hwaccess: "hrw",
      hwext:    "true",
      hwqe:     "true", // enable `qe` latched signal of software write pulse
      hwre:     "true",
      fields: [
        {
          bits: "5+3:5", // 2 bits for status
          name: "CL_STATUS",
          desc: "Contain the current status of the corresponding cache line                [0]: valid, [1]: dirty, [2]: cmpt",
        }
      ]
    },
    { name:     "TAG_1182",
      desc:     "Tag Address stored in cache line 1182",
      swaccess: "rw",
      hwaccess: "hrw",
      hwext:    "true",
      hwqe:     "true", // enable `qe` latched signal of software write pulse
      hwre:     "true",
      fields: [
        { bits: "5-1:0",
          name: "CL_TAG",
          desc: "Tag Address"
        }
      ]
    },
    {
      name:     "STATUS_1183",
      desc:     "Status register of cache line 1183",
      swaccess: "rw",
      hwaccess: "hrw",
      hwext:    "true",
      hwqe:     "true", // enable `qe` latched signal of software write pulse
      hwre:     "true",
      fields: [
        {
          bits: "5+3:5", // 2 bits for status
          name: "CL_STATUS",
          desc: "Contain the current status of the corresponding cache line                [0]: valid, [1]: dirty, [2]: cmpt",
        }
      ]
    },
    { name:     "TAG_1183",
      desc:     "Tag Address stored in cache line 1183",
      swaccess: "rw",
      hwaccess: "hrw",
      hwext:    "true",
      hwqe:     "true", // enable `qe` latched signal of software write pulse
      hwre:     "true",
      fields: [
        { bits: "5-1:0",
          name: "CL_TAG",
          desc: "Tag Address"
        }
      ]
    },
    {
      name:     "STATUS_1184",
      desc:     "Status register of cache line 1184",
      swaccess: "rw",
      hwaccess: "hrw",
      hwext:    "true",
      hwqe:     "true", // enable `qe` latched signal of software write pulse
      hwre:     "true",
      fields: [
        {
          bits: "5+3:5", // 2 bits for status
          name: "CL_STATUS",
          desc: "Contain the current status of the corresponding cache line                [0]: valid, [1]: dirty, [2]: cmpt",
        }
      ]
    },
    { name:     "TAG_1184",
      desc:     "Tag Address stored in cache line 1184",
      swaccess: "rw",
      hwaccess: "hrw",
      hwext:    "true",
      hwqe:     "true", // enable `qe` latched signal of software write pulse
      hwre:     "true",
      fields: [
        { bits: "5-1:0",
          name: "CL_TAG",
          desc: "Tag Address"
        }
      ]
    },
    {
      name:     "STATUS_1185",
      desc:     "Status register of cache line 1185",
      swaccess: "rw",
      hwaccess: "hrw",
      hwext:    "true",
      hwqe:     "true", // enable `qe` latched signal of software write pulse
      hwre:     "true",
      fields: [
        {
          bits: "5+3:5", // 2 bits for status
          name: "CL_STATUS",
          desc: "Contain the current status of the corresponding cache line                [0]: valid, [1]: dirty, [2]: cmpt",
        }
      ]
    },
    { name:     "TAG_1185",
      desc:     "Tag Address stored in cache line 1185",
      swaccess: "rw",
      hwaccess: "hrw",
      hwext:    "true",
      hwqe:     "true", // enable `qe` latched signal of software write pulse
      hwre:     "true",
      fields: [
        { bits: "5-1:0",
          name: "CL_TAG",
          desc: "Tag Address"
        }
      ]
    },
    {
      name:     "STATUS_1186",
      desc:     "Status register of cache line 1186",
      swaccess: "rw",
      hwaccess: "hrw",
      hwext:    "true",
      hwqe:     "true", // enable `qe` latched signal of software write pulse
      hwre:     "true",
      fields: [
        {
          bits: "5+3:5", // 2 bits for status
          name: "CL_STATUS",
          desc: "Contain the current status of the corresponding cache line                [0]: valid, [1]: dirty, [2]: cmpt",
        }
      ]
    },
    { name:     "TAG_1186",
      desc:     "Tag Address stored in cache line 1186",
      swaccess: "rw",
      hwaccess: "hrw",
      hwext:    "true",
      hwqe:     "true", // enable `qe` latched signal of software write pulse
      hwre:     "true",
      fields: [
        { bits: "5-1:0",
          name: "CL_TAG",
          desc: "Tag Address"
        }
      ]
    },
    {
      name:     "STATUS_1187",
      desc:     "Status register of cache line 1187",
      swaccess: "rw",
      hwaccess: "hrw",
      hwext:    "true",
      hwqe:     "true", // enable `qe` latched signal of software write pulse
      hwre:     "true",
      fields: [
        {
          bits: "5+3:5", // 2 bits for status
          name: "CL_STATUS",
          desc: "Contain the current status of the corresponding cache line                [0]: valid, [1]: dirty, [2]: cmpt",
        }
      ]
    },
    { name:     "TAG_1187",
      desc:     "Tag Address stored in cache line 1187",
      swaccess: "rw",
      hwaccess: "hrw",
      hwext:    "true",
      hwqe:     "true", // enable `qe` latched signal of software write pulse
      hwre:     "true",
      fields: [
        { bits: "5-1:0",
          name: "CL_TAG",
          desc: "Tag Address"
        }
      ]
    },
    {
      name:     "STATUS_1188",
      desc:     "Status register of cache line 1188",
      swaccess: "rw",
      hwaccess: "hrw",
      hwext:    "true",
      hwqe:     "true", // enable `qe` latched signal of software write pulse
      hwre:     "true",
      fields: [
        {
          bits: "5+3:5", // 2 bits for status
          name: "CL_STATUS",
          desc: "Contain the current status of the corresponding cache line                [0]: valid, [1]: dirty, [2]: cmpt",
        }
      ]
    },
    { name:     "TAG_1188",
      desc:     "Tag Address stored in cache line 1188",
      swaccess: "rw",
      hwaccess: "hrw",
      hwext:    "true",
      hwqe:     "true", // enable `qe` latched signal of software write pulse
      hwre:     "true",
      fields: [
        { bits: "5-1:0",
          name: "CL_TAG",
          desc: "Tag Address"
        }
      ]
    },
    {
      name:     "STATUS_1189",
      desc:     "Status register of cache line 1189",
      swaccess: "rw",
      hwaccess: "hrw",
      hwext:    "true",
      hwqe:     "true", // enable `qe` latched signal of software write pulse
      hwre:     "true",
      fields: [
        {
          bits: "5+3:5", // 2 bits for status
          name: "CL_STATUS",
          desc: "Contain the current status of the corresponding cache line                [0]: valid, [1]: dirty, [2]: cmpt",
        }
      ]
    },
    { name:     "TAG_1189",
      desc:     "Tag Address stored in cache line 1189",
      swaccess: "rw",
      hwaccess: "hrw",
      hwext:    "true",
      hwqe:     "true", // enable `qe` latched signal of software write pulse
      hwre:     "true",
      fields: [
        { bits: "5-1:0",
          name: "CL_TAG",
          desc: "Tag Address"
        }
      ]
    },
    {
      name:     "STATUS_1190",
      desc:     "Status register of cache line 1190",
      swaccess: "rw",
      hwaccess: "hrw",
      hwext:    "true",
      hwqe:     "true", // enable `qe` latched signal of software write pulse
      hwre:     "true",
      fields: [
        {
          bits: "5+3:5", // 2 bits for status
          name: "CL_STATUS",
          desc: "Contain the current status of the corresponding cache line                [0]: valid, [1]: dirty, [2]: cmpt",
        }
      ]
    },
    { name:     "TAG_1190",
      desc:     "Tag Address stored in cache line 1190",
      swaccess: "rw",
      hwaccess: "hrw",
      hwext:    "true",
      hwqe:     "true", // enable `qe` latched signal of software write pulse
      hwre:     "true",
      fields: [
        { bits: "5-1:0",
          name: "CL_TAG",
          desc: "Tag Address"
        }
      ]
    },
    {
      name:     "STATUS_1191",
      desc:     "Status register of cache line 1191",
      swaccess: "rw",
      hwaccess: "hrw",
      hwext:    "true",
      hwqe:     "true", // enable `qe` latched signal of software write pulse
      hwre:     "true",
      fields: [
        {
          bits: "5+3:5", // 2 bits for status
          name: "CL_STATUS",
          desc: "Contain the current status of the corresponding cache line                [0]: valid, [1]: dirty, [2]: cmpt",
        }
      ]
    },
    { name:     "TAG_1191",
      desc:     "Tag Address stored in cache line 1191",
      swaccess: "rw",
      hwaccess: "hrw",
      hwext:    "true",
      hwqe:     "true", // enable `qe` latched signal of software write pulse
      hwre:     "true",
      fields: [
        { bits: "5-1:0",
          name: "CL_TAG",
          desc: "Tag Address"
        }
      ]
    },
    {
      name:     "STATUS_1192",
      desc:     "Status register of cache line 1192",
      swaccess: "rw",
      hwaccess: "hrw",
      hwext:    "true",
      hwqe:     "true", // enable `qe` latched signal of software write pulse
      hwre:     "true",
      fields: [
        {
          bits: "5+3:5", // 2 bits for status
          name: "CL_STATUS",
          desc: "Contain the current status of the corresponding cache line                [0]: valid, [1]: dirty, [2]: cmpt",
        }
      ]
    },
    { name:     "TAG_1192",
      desc:     "Tag Address stored in cache line 1192",
      swaccess: "rw",
      hwaccess: "hrw",
      hwext:    "true",
      hwqe:     "true", // enable `qe` latched signal of software write pulse
      hwre:     "true",
      fields: [
        { bits: "5-1:0",
          name: "CL_TAG",
          desc: "Tag Address"
        }
      ]
    },
    {
      name:     "STATUS_1193",
      desc:     "Status register of cache line 1193",
      swaccess: "rw",
      hwaccess: "hrw",
      hwext:    "true",
      hwqe:     "true", // enable `qe` latched signal of software write pulse
      hwre:     "true",
      fields: [
        {
          bits: "5+3:5", // 2 bits for status
          name: "CL_STATUS",
          desc: "Contain the current status of the corresponding cache line                [0]: valid, [1]: dirty, [2]: cmpt",
        }
      ]
    },
    { name:     "TAG_1193",
      desc:     "Tag Address stored in cache line 1193",
      swaccess: "rw",
      hwaccess: "hrw",
      hwext:    "true",
      hwqe:     "true", // enable `qe` latched signal of software write pulse
      hwre:     "true",
      fields: [
        { bits: "5-1:0",
          name: "CL_TAG",
          desc: "Tag Address"
        }
      ]
    },
    {
      name:     "STATUS_1194",
      desc:     "Status register of cache line 1194",
      swaccess: "rw",
      hwaccess: "hrw",
      hwext:    "true",
      hwqe:     "true", // enable `qe` latched signal of software write pulse
      hwre:     "true",
      fields: [
        {
          bits: "5+3:5", // 2 bits for status
          name: "CL_STATUS",
          desc: "Contain the current status of the corresponding cache line                [0]: valid, [1]: dirty, [2]: cmpt",
        }
      ]
    },
    { name:     "TAG_1194",
      desc:     "Tag Address stored in cache line 1194",
      swaccess: "rw",
      hwaccess: "hrw",
      hwext:    "true",
      hwqe:     "true", // enable `qe` latched signal of software write pulse
      hwre:     "true",
      fields: [
        { bits: "5-1:0",
          name: "CL_TAG",
          desc: "Tag Address"
        }
      ]
    },
    {
      name:     "STATUS_1195",
      desc:     "Status register of cache line 1195",
      swaccess: "rw",
      hwaccess: "hrw",
      hwext:    "true",
      hwqe:     "true", // enable `qe` latched signal of software write pulse
      hwre:     "true",
      fields: [
        {
          bits: "5+3:5", // 2 bits for status
          name: "CL_STATUS",
          desc: "Contain the current status of the corresponding cache line                [0]: valid, [1]: dirty, [2]: cmpt",
        }
      ]
    },
    { name:     "TAG_1195",
      desc:     "Tag Address stored in cache line 1195",
      swaccess: "rw",
      hwaccess: "hrw",
      hwext:    "true",
      hwqe:     "true", // enable `qe` latched signal of software write pulse
      hwre:     "true",
      fields: [
        { bits: "5-1:0",
          name: "CL_TAG",
          desc: "Tag Address"
        }
      ]
    },
    {
      name:     "STATUS_1196",
      desc:     "Status register of cache line 1196",
      swaccess: "rw",
      hwaccess: "hrw",
      hwext:    "true",
      hwqe:     "true", // enable `qe` latched signal of software write pulse
      hwre:     "true",
      fields: [
        {
          bits: "5+3:5", // 2 bits for status
          name: "CL_STATUS",
          desc: "Contain the current status of the corresponding cache line                [0]: valid, [1]: dirty, [2]: cmpt",
        }
      ]
    },
    { name:     "TAG_1196",
      desc:     "Tag Address stored in cache line 1196",
      swaccess: "rw",
      hwaccess: "hrw",
      hwext:    "true",
      hwqe:     "true", // enable `qe` latched signal of software write pulse
      hwre:     "true",
      fields: [
        { bits: "5-1:0",
          name: "CL_TAG",
          desc: "Tag Address"
        }
      ]
    },
    {
      name:     "STATUS_1197",
      desc:     "Status register of cache line 1197",
      swaccess: "rw",
      hwaccess: "hrw",
      hwext:    "true",
      hwqe:     "true", // enable `qe` latched signal of software write pulse
      hwre:     "true",
      fields: [
        {
          bits: "5+3:5", // 2 bits for status
          name: "CL_STATUS",
          desc: "Contain the current status of the corresponding cache line                [0]: valid, [1]: dirty, [2]: cmpt",
        }
      ]
    },
    { name:     "TAG_1197",
      desc:     "Tag Address stored in cache line 1197",
      swaccess: "rw",
      hwaccess: "hrw",
      hwext:    "true",
      hwqe:     "true", // enable `qe` latched signal of software write pulse
      hwre:     "true",
      fields: [
        { bits: "5-1:0",
          name: "CL_TAG",
          desc: "Tag Address"
        }
      ]
    },
    {
      name:     "STATUS_1198",
      desc:     "Status register of cache line 1198",
      swaccess: "rw",
      hwaccess: "hrw",
      hwext:    "true",
      hwqe:     "true", // enable `qe` latched signal of software write pulse
      hwre:     "true",
      fields: [
        {
          bits: "5+3:5", // 2 bits for status
          name: "CL_STATUS",
          desc: "Contain the current status of the corresponding cache line                [0]: valid, [1]: dirty, [2]: cmpt",
        }
      ]
    },
    { name:     "TAG_1198",
      desc:     "Tag Address stored in cache line 1198",
      swaccess: "rw",
      hwaccess: "hrw",
      hwext:    "true",
      hwqe:     "true", // enable `qe` latched signal of software write pulse
      hwre:     "true",
      fields: [
        { bits: "5-1:0",
          name: "CL_TAG",
          desc: "Tag Address"
        }
      ]
    },
    {
      name:     "STATUS_1199",
      desc:     "Status register of cache line 1199",
      swaccess: "rw",
      hwaccess: "hrw",
      hwext:    "true",
      hwqe:     "true", // enable `qe` latched signal of software write pulse
      hwre:     "true",
      fields: [
        {
          bits: "5+3:5", // 2 bits for status
          name: "CL_STATUS",
          desc: "Contain the current status of the corresponding cache line                [0]: valid, [1]: dirty, [2]: cmpt",
        }
      ]
    },
    { name:     "TAG_1199",
      desc:     "Tag Address stored in cache line 1199",
      swaccess: "rw",
      hwaccess: "hrw",
      hwext:    "true",
      hwqe:     "true", // enable `qe` latched signal of software write pulse
      hwre:     "true",
      fields: [
        { bits: "5-1:0",
          name: "CL_TAG",
          desc: "Tag Address"
        }
      ]
    },
    {
      name:     "STATUS_1200",
      desc:     "Status register of cache line 1200",
      swaccess: "rw",
      hwaccess: "hrw",
      hwext:    "true",
      hwqe:     "true", // enable `qe` latched signal of software write pulse
      hwre:     "true",
      fields: [
        {
          bits: "5+3:5", // 2 bits for status
          name: "CL_STATUS",
          desc: "Contain the current status of the corresponding cache line                [0]: valid, [1]: dirty, [2]: cmpt",
        }
      ]
    },
    { name:     "TAG_1200",
      desc:     "Tag Address stored in cache line 1200",
      swaccess: "rw",
      hwaccess: "hrw",
      hwext:    "true",
      hwqe:     "true", // enable `qe` latched signal of software write pulse
      hwre:     "true",
      fields: [
        { bits: "5-1:0",
          name: "CL_TAG",
          desc: "Tag Address"
        }
      ]
    },
    {
      name:     "STATUS_1201",
      desc:     "Status register of cache line 1201",
      swaccess: "rw",
      hwaccess: "hrw",
      hwext:    "true",
      hwqe:     "true", // enable `qe` latched signal of software write pulse
      hwre:     "true",
      fields: [
        {
          bits: "5+3:5", // 2 bits for status
          name: "CL_STATUS",
          desc: "Contain the current status of the corresponding cache line                [0]: valid, [1]: dirty, [2]: cmpt",
        }
      ]
    },
    { name:     "TAG_1201",
      desc:     "Tag Address stored in cache line 1201",
      swaccess: "rw",
      hwaccess: "hrw",
      hwext:    "true",
      hwqe:     "true", // enable `qe` latched signal of software write pulse
      hwre:     "true",
      fields: [
        { bits: "5-1:0",
          name: "CL_TAG",
          desc: "Tag Address"
        }
      ]
    },
    {
      name:     "STATUS_1202",
      desc:     "Status register of cache line 1202",
      swaccess: "rw",
      hwaccess: "hrw",
      hwext:    "true",
      hwqe:     "true", // enable `qe` latched signal of software write pulse
      hwre:     "true",
      fields: [
        {
          bits: "5+3:5", // 2 bits for status
          name: "CL_STATUS",
          desc: "Contain the current status of the corresponding cache line                [0]: valid, [1]: dirty, [2]: cmpt",
        }
      ]
    },
    { name:     "TAG_1202",
      desc:     "Tag Address stored in cache line 1202",
      swaccess: "rw",
      hwaccess: "hrw",
      hwext:    "true",
      hwqe:     "true", // enable `qe` latched signal of software write pulse
      hwre:     "true",
      fields: [
        { bits: "5-1:0",
          name: "CL_TAG",
          desc: "Tag Address"
        }
      ]
    },
    {
      name:     "STATUS_1203",
      desc:     "Status register of cache line 1203",
      swaccess: "rw",
      hwaccess: "hrw",
      hwext:    "true",
      hwqe:     "true", // enable `qe` latched signal of software write pulse
      hwre:     "true",
      fields: [
        {
          bits: "5+3:5", // 2 bits for status
          name: "CL_STATUS",
          desc: "Contain the current status of the corresponding cache line                [0]: valid, [1]: dirty, [2]: cmpt",
        }
      ]
    },
    { name:     "TAG_1203",
      desc:     "Tag Address stored in cache line 1203",
      swaccess: "rw",
      hwaccess: "hrw",
      hwext:    "true",
      hwqe:     "true", // enable `qe` latched signal of software write pulse
      hwre:     "true",
      fields: [
        { bits: "5-1:0",
          name: "CL_TAG",
          desc: "Tag Address"
        }
      ]
    },
    {
      name:     "STATUS_1204",
      desc:     "Status register of cache line 1204",
      swaccess: "rw",
      hwaccess: "hrw",
      hwext:    "true",
      hwqe:     "true", // enable `qe` latched signal of software write pulse
      hwre:     "true",
      fields: [
        {
          bits: "5+3:5", // 2 bits for status
          name: "CL_STATUS",
          desc: "Contain the current status of the corresponding cache line                [0]: valid, [1]: dirty, [2]: cmpt",
        }
      ]
    },
    { name:     "TAG_1204",
      desc:     "Tag Address stored in cache line 1204",
      swaccess: "rw",
      hwaccess: "hrw",
      hwext:    "true",
      hwqe:     "true", // enable `qe` latched signal of software write pulse
      hwre:     "true",
      fields: [
        { bits: "5-1:0",
          name: "CL_TAG",
          desc: "Tag Address"
        }
      ]
    },
    {
      name:     "STATUS_1205",
      desc:     "Status register of cache line 1205",
      swaccess: "rw",
      hwaccess: "hrw",
      hwext:    "true",
      hwqe:     "true", // enable `qe` latched signal of software write pulse
      hwre:     "true",
      fields: [
        {
          bits: "5+3:5", // 2 bits for status
          name: "CL_STATUS",
          desc: "Contain the current status of the corresponding cache line                [0]: valid, [1]: dirty, [2]: cmpt",
        }
      ]
    },
    { name:     "TAG_1205",
      desc:     "Tag Address stored in cache line 1205",
      swaccess: "rw",
      hwaccess: "hrw",
      hwext:    "true",
      hwqe:     "true", // enable `qe` latched signal of software write pulse
      hwre:     "true",
      fields: [
        { bits: "5-1:0",
          name: "CL_TAG",
          desc: "Tag Address"
        }
      ]
    },
    {
      name:     "STATUS_1206",
      desc:     "Status register of cache line 1206",
      swaccess: "rw",
      hwaccess: "hrw",
      hwext:    "true",
      hwqe:     "true", // enable `qe` latched signal of software write pulse
      hwre:     "true",
      fields: [
        {
          bits: "5+3:5", // 2 bits for status
          name: "CL_STATUS",
          desc: "Contain the current status of the corresponding cache line                [0]: valid, [1]: dirty, [2]: cmpt",
        }
      ]
    },
    { name:     "TAG_1206",
      desc:     "Tag Address stored in cache line 1206",
      swaccess: "rw",
      hwaccess: "hrw",
      hwext:    "true",
      hwqe:     "true", // enable `qe` latched signal of software write pulse
      hwre:     "true",
      fields: [
        { bits: "5-1:0",
          name: "CL_TAG",
          desc: "Tag Address"
        }
      ]
    },
    {
      name:     "STATUS_1207",
      desc:     "Status register of cache line 1207",
      swaccess: "rw",
      hwaccess: "hrw",
      hwext:    "true",
      hwqe:     "true", // enable `qe` latched signal of software write pulse
      hwre:     "true",
      fields: [
        {
          bits: "5+3:5", // 2 bits for status
          name: "CL_STATUS",
          desc: "Contain the current status of the corresponding cache line                [0]: valid, [1]: dirty, [2]: cmpt",
        }
      ]
    },
    { name:     "TAG_1207",
      desc:     "Tag Address stored in cache line 1207",
      swaccess: "rw",
      hwaccess: "hrw",
      hwext:    "true",
      hwqe:     "true", // enable `qe` latched signal of software write pulse
      hwre:     "true",
      fields: [
        { bits: "5-1:0",
          name: "CL_TAG",
          desc: "Tag Address"
        }
      ]
    },
    {
      name:     "STATUS_1208",
      desc:     "Status register of cache line 1208",
      swaccess: "rw",
      hwaccess: "hrw",
      hwext:    "true",
      hwqe:     "true", // enable `qe` latched signal of software write pulse
      hwre:     "true",
      fields: [
        {
          bits: "5+3:5", // 2 bits for status
          name: "CL_STATUS",
          desc: "Contain the current status of the corresponding cache line                [0]: valid, [1]: dirty, [2]: cmpt",
        }
      ]
    },
    { name:     "TAG_1208",
      desc:     "Tag Address stored in cache line 1208",
      swaccess: "rw",
      hwaccess: "hrw",
      hwext:    "true",
      hwqe:     "true", // enable `qe` latched signal of software write pulse
      hwre:     "true",
      fields: [
        { bits: "5-1:0",
          name: "CL_TAG",
          desc: "Tag Address"
        }
      ]
    },
    {
      name:     "STATUS_1209",
      desc:     "Status register of cache line 1209",
      swaccess: "rw",
      hwaccess: "hrw",
      hwext:    "true",
      hwqe:     "true", // enable `qe` latched signal of software write pulse
      hwre:     "true",
      fields: [
        {
          bits: "5+3:5", // 2 bits for status
          name: "CL_STATUS",
          desc: "Contain the current status of the corresponding cache line                [0]: valid, [1]: dirty, [2]: cmpt",
        }
      ]
    },
    { name:     "TAG_1209",
      desc:     "Tag Address stored in cache line 1209",
      swaccess: "rw",
      hwaccess: "hrw",
      hwext:    "true",
      hwqe:     "true", // enable `qe` latched signal of software write pulse
      hwre:     "true",
      fields: [
        { bits: "5-1:0",
          name: "CL_TAG",
          desc: "Tag Address"
        }
      ]
    },
    {
      name:     "STATUS_1210",
      desc:     "Status register of cache line 1210",
      swaccess: "rw",
      hwaccess: "hrw",
      hwext:    "true",
      hwqe:     "true", // enable `qe` latched signal of software write pulse
      hwre:     "true",
      fields: [
        {
          bits: "5+3:5", // 2 bits for status
          name: "CL_STATUS",
          desc: "Contain the current status of the corresponding cache line                [0]: valid, [1]: dirty, [2]: cmpt",
        }
      ]
    },
    { name:     "TAG_1210",
      desc:     "Tag Address stored in cache line 1210",
      swaccess: "rw",
      hwaccess: "hrw",
      hwext:    "true",
      hwqe:     "true", // enable `qe` latched signal of software write pulse
      hwre:     "true",
      fields: [
        { bits: "5-1:0",
          name: "CL_TAG",
          desc: "Tag Address"
        }
      ]
    },
    {
      name:     "STATUS_1211",
      desc:     "Status register of cache line 1211",
      swaccess: "rw",
      hwaccess: "hrw",
      hwext:    "true",
      hwqe:     "true", // enable `qe` latched signal of software write pulse
      hwre:     "true",
      fields: [
        {
          bits: "5+3:5", // 2 bits for status
          name: "CL_STATUS",
          desc: "Contain the current status of the corresponding cache line                [0]: valid, [1]: dirty, [2]: cmpt",
        }
      ]
    },
    { name:     "TAG_1211",
      desc:     "Tag Address stored in cache line 1211",
      swaccess: "rw",
      hwaccess: "hrw",
      hwext:    "true",
      hwqe:     "true", // enable `qe` latched signal of software write pulse
      hwre:     "true",
      fields: [
        { bits: "5-1:0",
          name: "CL_TAG",
          desc: "Tag Address"
        }
      ]
    },
    {
      name:     "STATUS_1212",
      desc:     "Status register of cache line 1212",
      swaccess: "rw",
      hwaccess: "hrw",
      hwext:    "true",
      hwqe:     "true", // enable `qe` latched signal of software write pulse
      hwre:     "true",
      fields: [
        {
          bits: "5+3:5", // 2 bits for status
          name: "CL_STATUS",
          desc: "Contain the current status of the corresponding cache line                [0]: valid, [1]: dirty, [2]: cmpt",
        }
      ]
    },
    { name:     "TAG_1212",
      desc:     "Tag Address stored in cache line 1212",
      swaccess: "rw",
      hwaccess: "hrw",
      hwext:    "true",
      hwqe:     "true", // enable `qe` latched signal of software write pulse
      hwre:     "true",
      fields: [
        { bits: "5-1:0",
          name: "CL_TAG",
          desc: "Tag Address"
        }
      ]
    },
    {
      name:     "STATUS_1213",
      desc:     "Status register of cache line 1213",
      swaccess: "rw",
      hwaccess: "hrw",
      hwext:    "true",
      hwqe:     "true", // enable `qe` latched signal of software write pulse
      hwre:     "true",
      fields: [
        {
          bits: "5+3:5", // 2 bits for status
          name: "CL_STATUS",
          desc: "Contain the current status of the corresponding cache line                [0]: valid, [1]: dirty, [2]: cmpt",
        }
      ]
    },
    { name:     "TAG_1213",
      desc:     "Tag Address stored in cache line 1213",
      swaccess: "rw",
      hwaccess: "hrw",
      hwext:    "true",
      hwqe:     "true", // enable `qe` latched signal of software write pulse
      hwre:     "true",
      fields: [
        { bits: "5-1:0",
          name: "CL_TAG",
          desc: "Tag Address"
        }
      ]
    },
    {
      name:     "STATUS_1214",
      desc:     "Status register of cache line 1214",
      swaccess: "rw",
      hwaccess: "hrw",
      hwext:    "true",
      hwqe:     "true", // enable `qe` latched signal of software write pulse
      hwre:     "true",
      fields: [
        {
          bits: "5+3:5", // 2 bits for status
          name: "CL_STATUS",
          desc: "Contain the current status of the corresponding cache line                [0]: valid, [1]: dirty, [2]: cmpt",
        }
      ]
    },
    { name:     "TAG_1214",
      desc:     "Tag Address stored in cache line 1214",
      swaccess: "rw",
      hwaccess: "hrw",
      hwext:    "true",
      hwqe:     "true", // enable `qe` latched signal of software write pulse
      hwre:     "true",
      fields: [
        { bits: "5-1:0",
          name: "CL_TAG",
          desc: "Tag Address"
        }
      ]
    },
    {
      name:     "STATUS_1215",
      desc:     "Status register of cache line 1215",
      swaccess: "rw",
      hwaccess: "hrw",
      hwext:    "true",
      hwqe:     "true", // enable `qe` latched signal of software write pulse
      hwre:     "true",
      fields: [
        {
          bits: "5+3:5", // 2 bits for status
          name: "CL_STATUS",
          desc: "Contain the current status of the corresponding cache line                [0]: valid, [1]: dirty, [2]: cmpt",
        }
      ]
    },
    { name:     "TAG_1215",
      desc:     "Tag Address stored in cache line 1215",
      swaccess: "rw",
      hwaccess: "hrw",
      hwext:    "true",
      hwqe:     "true", // enable `qe` latched signal of software write pulse
      hwre:     "true",
      fields: [
        { bits: "5-1:0",
          name: "CL_TAG",
          desc: "Tag Address"
        }
      ]
    },
    {
      name:     "STATUS_1216",
      desc:     "Status register of cache line 1216",
      swaccess: "rw",
      hwaccess: "hrw",
      hwext:    "true",
      hwqe:     "true", // enable `qe` latched signal of software write pulse
      hwre:     "true",
      fields: [
        {
          bits: "5+3:5", // 2 bits for status
          name: "CL_STATUS",
          desc: "Contain the current status of the corresponding cache line                [0]: valid, [1]: dirty, [2]: cmpt",
        }
      ]
    },
    { name:     "TAG_1216",
      desc:     "Tag Address stored in cache line 1216",
      swaccess: "rw",
      hwaccess: "hrw",
      hwext:    "true",
      hwqe:     "true", // enable `qe` latched signal of software write pulse
      hwre:     "true",
      fields: [
        { bits: "5-1:0",
          name: "CL_TAG",
          desc: "Tag Address"
        }
      ]
    },
    {
      name:     "STATUS_1217",
      desc:     "Status register of cache line 1217",
      swaccess: "rw",
      hwaccess: "hrw",
      hwext:    "true",
      hwqe:     "true", // enable `qe` latched signal of software write pulse
      hwre:     "true",
      fields: [
        {
          bits: "5+3:5", // 2 bits for status
          name: "CL_STATUS",
          desc: "Contain the current status of the corresponding cache line                [0]: valid, [1]: dirty, [2]: cmpt",
        }
      ]
    },
    { name:     "TAG_1217",
      desc:     "Tag Address stored in cache line 1217",
      swaccess: "rw",
      hwaccess: "hrw",
      hwext:    "true",
      hwqe:     "true", // enable `qe` latched signal of software write pulse
      hwre:     "true",
      fields: [
        { bits: "5-1:0",
          name: "CL_TAG",
          desc: "Tag Address"
        }
      ]
    },
    {
      name:     "STATUS_1218",
      desc:     "Status register of cache line 1218",
      swaccess: "rw",
      hwaccess: "hrw",
      hwext:    "true",
      hwqe:     "true", // enable `qe` latched signal of software write pulse
      hwre:     "true",
      fields: [
        {
          bits: "5+3:5", // 2 bits for status
          name: "CL_STATUS",
          desc: "Contain the current status of the corresponding cache line                [0]: valid, [1]: dirty, [2]: cmpt",
        }
      ]
    },
    { name:     "TAG_1218",
      desc:     "Tag Address stored in cache line 1218",
      swaccess: "rw",
      hwaccess: "hrw",
      hwext:    "true",
      hwqe:     "true", // enable `qe` latched signal of software write pulse
      hwre:     "true",
      fields: [
        { bits: "5-1:0",
          name: "CL_TAG",
          desc: "Tag Address"
        }
      ]
    },
    {
      name:     "STATUS_1219",
      desc:     "Status register of cache line 1219",
      swaccess: "rw",
      hwaccess: "hrw",
      hwext:    "true",
      hwqe:     "true", // enable `qe` latched signal of software write pulse
      hwre:     "true",
      fields: [
        {
          bits: "5+3:5", // 2 bits for status
          name: "CL_STATUS",
          desc: "Contain the current status of the corresponding cache line                [0]: valid, [1]: dirty, [2]: cmpt",
        }
      ]
    },
    { name:     "TAG_1219",
      desc:     "Tag Address stored in cache line 1219",
      swaccess: "rw",
      hwaccess: "hrw",
      hwext:    "true",
      hwqe:     "true", // enable `qe` latched signal of software write pulse
      hwre:     "true",
      fields: [
        { bits: "5-1:0",
          name: "CL_TAG",
          desc: "Tag Address"
        }
      ]
    },
    {
      name:     "STATUS_1220",
      desc:     "Status register of cache line 1220",
      swaccess: "rw",
      hwaccess: "hrw",
      hwext:    "true",
      hwqe:     "true", // enable `qe` latched signal of software write pulse
      hwre:     "true",
      fields: [
        {
          bits: "5+3:5", // 2 bits for status
          name: "CL_STATUS",
          desc: "Contain the current status of the corresponding cache line                [0]: valid, [1]: dirty, [2]: cmpt",
        }
      ]
    },
    { name:     "TAG_1220",
      desc:     "Tag Address stored in cache line 1220",
      swaccess: "rw",
      hwaccess: "hrw",
      hwext:    "true",
      hwqe:     "true", // enable `qe` latched signal of software write pulse
      hwre:     "true",
      fields: [
        { bits: "5-1:0",
          name: "CL_TAG",
          desc: "Tag Address"
        }
      ]
    },
    {
      name:     "STATUS_1221",
      desc:     "Status register of cache line 1221",
      swaccess: "rw",
      hwaccess: "hrw",
      hwext:    "true",
      hwqe:     "true", // enable `qe` latched signal of software write pulse
      hwre:     "true",
      fields: [
        {
          bits: "5+3:5", // 2 bits for status
          name: "CL_STATUS",
          desc: "Contain the current status of the corresponding cache line                [0]: valid, [1]: dirty, [2]: cmpt",
        }
      ]
    },
    { name:     "TAG_1221",
      desc:     "Tag Address stored in cache line 1221",
      swaccess: "rw",
      hwaccess: "hrw",
      hwext:    "true",
      hwqe:     "true", // enable `qe` latched signal of software write pulse
      hwre:     "true",
      fields: [
        { bits: "5-1:0",
          name: "CL_TAG",
          desc: "Tag Address"
        }
      ]
    },
    {
      name:     "STATUS_1222",
      desc:     "Status register of cache line 1222",
      swaccess: "rw",
      hwaccess: "hrw",
      hwext:    "true",
      hwqe:     "true", // enable `qe` latched signal of software write pulse
      hwre:     "true",
      fields: [
        {
          bits: "5+3:5", // 2 bits for status
          name: "CL_STATUS",
          desc: "Contain the current status of the corresponding cache line                [0]: valid, [1]: dirty, [2]: cmpt",
        }
      ]
    },
    { name:     "TAG_1222",
      desc:     "Tag Address stored in cache line 1222",
      swaccess: "rw",
      hwaccess: "hrw",
      hwext:    "true",
      hwqe:     "true", // enable `qe` latched signal of software write pulse
      hwre:     "true",
      fields: [
        { bits: "5-1:0",
          name: "CL_TAG",
          desc: "Tag Address"
        }
      ]
    },
    {
      name:     "STATUS_1223",
      desc:     "Status register of cache line 1223",
      swaccess: "rw",
      hwaccess: "hrw",
      hwext:    "true",
      hwqe:     "true", // enable `qe` latched signal of software write pulse
      hwre:     "true",
      fields: [
        {
          bits: "5+3:5", // 2 bits for status
          name: "CL_STATUS",
          desc: "Contain the current status of the corresponding cache line                [0]: valid, [1]: dirty, [2]: cmpt",
        }
      ]
    },
    { name:     "TAG_1223",
      desc:     "Tag Address stored in cache line 1223",
      swaccess: "rw",
      hwaccess: "hrw",
      hwext:    "true",
      hwqe:     "true", // enable `qe` latched signal of software write pulse
      hwre:     "true",
      fields: [
        { bits: "5-1:0",
          name: "CL_TAG",
          desc: "Tag Address"
        }
      ]
    },
    {
      name:     "STATUS_1224",
      desc:     "Status register of cache line 1224",
      swaccess: "rw",
      hwaccess: "hrw",
      hwext:    "true",
      hwqe:     "true", // enable `qe` latched signal of software write pulse
      hwre:     "true",
      fields: [
        {
          bits: "5+3:5", // 2 bits for status
          name: "CL_STATUS",
          desc: "Contain the current status of the corresponding cache line                [0]: valid, [1]: dirty, [2]: cmpt",
        }
      ]
    },
    { name:     "TAG_1224",
      desc:     "Tag Address stored in cache line 1224",
      swaccess: "rw",
      hwaccess: "hrw",
      hwext:    "true",
      hwqe:     "true", // enable `qe` latched signal of software write pulse
      hwre:     "true",
      fields: [
        { bits: "5-1:0",
          name: "CL_TAG",
          desc: "Tag Address"
        }
      ]
    },
    {
      name:     "STATUS_1225",
      desc:     "Status register of cache line 1225",
      swaccess: "rw",
      hwaccess: "hrw",
      hwext:    "true",
      hwqe:     "true", // enable `qe` latched signal of software write pulse
      hwre:     "true",
      fields: [
        {
          bits: "5+3:5", // 2 bits for status
          name: "CL_STATUS",
          desc: "Contain the current status of the corresponding cache line                [0]: valid, [1]: dirty, [2]: cmpt",
        }
      ]
    },
    { name:     "TAG_1225",
      desc:     "Tag Address stored in cache line 1225",
      swaccess: "rw",
      hwaccess: "hrw",
      hwext:    "true",
      hwqe:     "true", // enable `qe` latched signal of software write pulse
      hwre:     "true",
      fields: [
        { bits: "5-1:0",
          name: "CL_TAG",
          desc: "Tag Address"
        }
      ]
    },
    {
      name:     "STATUS_1226",
      desc:     "Status register of cache line 1226",
      swaccess: "rw",
      hwaccess: "hrw",
      hwext:    "true",
      hwqe:     "true", // enable `qe` latched signal of software write pulse
      hwre:     "true",
      fields: [
        {
          bits: "5+3:5", // 2 bits for status
          name: "CL_STATUS",
          desc: "Contain the current status of the corresponding cache line                [0]: valid, [1]: dirty, [2]: cmpt",
        }
      ]
    },
    { name:     "TAG_1226",
      desc:     "Tag Address stored in cache line 1226",
      swaccess: "rw",
      hwaccess: "hrw",
      hwext:    "true",
      hwqe:     "true", // enable `qe` latched signal of software write pulse
      hwre:     "true",
      fields: [
        { bits: "5-1:0",
          name: "CL_TAG",
          desc: "Tag Address"
        }
      ]
    },
    {
      name:     "STATUS_1227",
      desc:     "Status register of cache line 1227",
      swaccess: "rw",
      hwaccess: "hrw",
      hwext:    "true",
      hwqe:     "true", // enable `qe` latched signal of software write pulse
      hwre:     "true",
      fields: [
        {
          bits: "5+3:5", // 2 bits for status
          name: "CL_STATUS",
          desc: "Contain the current status of the corresponding cache line                [0]: valid, [1]: dirty, [2]: cmpt",
        }
      ]
    },
    { name:     "TAG_1227",
      desc:     "Tag Address stored in cache line 1227",
      swaccess: "rw",
      hwaccess: "hrw",
      hwext:    "true",
      hwqe:     "true", // enable `qe` latched signal of software write pulse
      hwre:     "true",
      fields: [
        { bits: "5-1:0",
          name: "CL_TAG",
          desc: "Tag Address"
        }
      ]
    },
    {
      name:     "STATUS_1228",
      desc:     "Status register of cache line 1228",
      swaccess: "rw",
      hwaccess: "hrw",
      hwext:    "true",
      hwqe:     "true", // enable `qe` latched signal of software write pulse
      hwre:     "true",
      fields: [
        {
          bits: "5+3:5", // 2 bits for status
          name: "CL_STATUS",
          desc: "Contain the current status of the corresponding cache line                [0]: valid, [1]: dirty, [2]: cmpt",
        }
      ]
    },
    { name:     "TAG_1228",
      desc:     "Tag Address stored in cache line 1228",
      swaccess: "rw",
      hwaccess: "hrw",
      hwext:    "true",
      hwqe:     "true", // enable `qe` latched signal of software write pulse
      hwre:     "true",
      fields: [
        { bits: "5-1:0",
          name: "CL_TAG",
          desc: "Tag Address"
        }
      ]
    },
    {
      name:     "STATUS_1229",
      desc:     "Status register of cache line 1229",
      swaccess: "rw",
      hwaccess: "hrw",
      hwext:    "true",
      hwqe:     "true", // enable `qe` latched signal of software write pulse
      hwre:     "true",
      fields: [
        {
          bits: "5+3:5", // 2 bits for status
          name: "CL_STATUS",
          desc: "Contain the current status of the corresponding cache line                [0]: valid, [1]: dirty, [2]: cmpt",
        }
      ]
    },
    { name:     "TAG_1229",
      desc:     "Tag Address stored in cache line 1229",
      swaccess: "rw",
      hwaccess: "hrw",
      hwext:    "true",
      hwqe:     "true", // enable `qe` latched signal of software write pulse
      hwre:     "true",
      fields: [
        { bits: "5-1:0",
          name: "CL_TAG",
          desc: "Tag Address"
        }
      ]
    },
    {
      name:     "STATUS_1230",
      desc:     "Status register of cache line 1230",
      swaccess: "rw",
      hwaccess: "hrw",
      hwext:    "true",
      hwqe:     "true", // enable `qe` latched signal of software write pulse
      hwre:     "true",
      fields: [
        {
          bits: "5+3:5", // 2 bits for status
          name: "CL_STATUS",
          desc: "Contain the current status of the corresponding cache line                [0]: valid, [1]: dirty, [2]: cmpt",
        }
      ]
    },
    { name:     "TAG_1230",
      desc:     "Tag Address stored in cache line 1230",
      swaccess: "rw",
      hwaccess: "hrw",
      hwext:    "true",
      hwqe:     "true", // enable `qe` latched signal of software write pulse
      hwre:     "true",
      fields: [
        { bits: "5-1:0",
          name: "CL_TAG",
          desc: "Tag Address"
        }
      ]
    },
    {
      name:     "STATUS_1231",
      desc:     "Status register of cache line 1231",
      swaccess: "rw",
      hwaccess: "hrw",
      hwext:    "true",
      hwqe:     "true", // enable `qe` latched signal of software write pulse
      hwre:     "true",
      fields: [
        {
          bits: "5+3:5", // 2 bits for status
          name: "CL_STATUS",
          desc: "Contain the current status of the corresponding cache line                [0]: valid, [1]: dirty, [2]: cmpt",
        }
      ]
    },
    { name:     "TAG_1231",
      desc:     "Tag Address stored in cache line 1231",
      swaccess: "rw",
      hwaccess: "hrw",
      hwext:    "true",
      hwqe:     "true", // enable `qe` latched signal of software write pulse
      hwre:     "true",
      fields: [
        { bits: "5-1:0",
          name: "CL_TAG",
          desc: "Tag Address"
        }
      ]
    },
    {
      name:     "STATUS_1232",
      desc:     "Status register of cache line 1232",
      swaccess: "rw",
      hwaccess: "hrw",
      hwext:    "true",
      hwqe:     "true", // enable `qe` latched signal of software write pulse
      hwre:     "true",
      fields: [
        {
          bits: "5+3:5", // 2 bits for status
          name: "CL_STATUS",
          desc: "Contain the current status of the corresponding cache line                [0]: valid, [1]: dirty, [2]: cmpt",
        }
      ]
    },
    { name:     "TAG_1232",
      desc:     "Tag Address stored in cache line 1232",
      swaccess: "rw",
      hwaccess: "hrw",
      hwext:    "true",
      hwqe:     "true", // enable `qe` latched signal of software write pulse
      hwre:     "true",
      fields: [
        { bits: "5-1:0",
          name: "CL_TAG",
          desc: "Tag Address"
        }
      ]
    },
    {
      name:     "STATUS_1233",
      desc:     "Status register of cache line 1233",
      swaccess: "rw",
      hwaccess: "hrw",
      hwext:    "true",
      hwqe:     "true", // enable `qe` latched signal of software write pulse
      hwre:     "true",
      fields: [
        {
          bits: "5+3:5", // 2 bits for status
          name: "CL_STATUS",
          desc: "Contain the current status of the corresponding cache line                [0]: valid, [1]: dirty, [2]: cmpt",
        }
      ]
    },
    { name:     "TAG_1233",
      desc:     "Tag Address stored in cache line 1233",
      swaccess: "rw",
      hwaccess: "hrw",
      hwext:    "true",
      hwqe:     "true", // enable `qe` latched signal of software write pulse
      hwre:     "true",
      fields: [
        { bits: "5-1:0",
          name: "CL_TAG",
          desc: "Tag Address"
        }
      ]
    },
    {
      name:     "STATUS_1234",
      desc:     "Status register of cache line 1234",
      swaccess: "rw",
      hwaccess: "hrw",
      hwext:    "true",
      hwqe:     "true", // enable `qe` latched signal of software write pulse
      hwre:     "true",
      fields: [
        {
          bits: "5+3:5", // 2 bits for status
          name: "CL_STATUS",
          desc: "Contain the current status of the corresponding cache line                [0]: valid, [1]: dirty, [2]: cmpt",
        }
      ]
    },
    { name:     "TAG_1234",
      desc:     "Tag Address stored in cache line 1234",
      swaccess: "rw",
      hwaccess: "hrw",
      hwext:    "true",
      hwqe:     "true", // enable `qe` latched signal of software write pulse
      hwre:     "true",
      fields: [
        { bits: "5-1:0",
          name: "CL_TAG",
          desc: "Tag Address"
        }
      ]
    },
    {
      name:     "STATUS_1235",
      desc:     "Status register of cache line 1235",
      swaccess: "rw",
      hwaccess: "hrw",
      hwext:    "true",
      hwqe:     "true", // enable `qe` latched signal of software write pulse
      hwre:     "true",
      fields: [
        {
          bits: "5+3:5", // 2 bits for status
          name: "CL_STATUS",
          desc: "Contain the current status of the corresponding cache line                [0]: valid, [1]: dirty, [2]: cmpt",
        }
      ]
    },
    { name:     "TAG_1235",
      desc:     "Tag Address stored in cache line 1235",
      swaccess: "rw",
      hwaccess: "hrw",
      hwext:    "true",
      hwqe:     "true", // enable `qe` latched signal of software write pulse
      hwre:     "true",
      fields: [
        { bits: "5-1:0",
          name: "CL_TAG",
          desc: "Tag Address"
        }
      ]
    },
    {
      name:     "STATUS_1236",
      desc:     "Status register of cache line 1236",
      swaccess: "rw",
      hwaccess: "hrw",
      hwext:    "true",
      hwqe:     "true", // enable `qe` latched signal of software write pulse
      hwre:     "true",
      fields: [
        {
          bits: "5+3:5", // 2 bits for status
          name: "CL_STATUS",
          desc: "Contain the current status of the corresponding cache line                [0]: valid, [1]: dirty, [2]: cmpt",
        }
      ]
    },
    { name:     "TAG_1236",
      desc:     "Tag Address stored in cache line 1236",
      swaccess: "rw",
      hwaccess: "hrw",
      hwext:    "true",
      hwqe:     "true", // enable `qe` latched signal of software write pulse
      hwre:     "true",
      fields: [
        { bits: "5-1:0",
          name: "CL_TAG",
          desc: "Tag Address"
        }
      ]
    },
    {
      name:     "STATUS_1237",
      desc:     "Status register of cache line 1237",
      swaccess: "rw",
      hwaccess: "hrw",
      hwext:    "true",
      hwqe:     "true", // enable `qe` latched signal of software write pulse
      hwre:     "true",
      fields: [
        {
          bits: "5+3:5", // 2 bits for status
          name: "CL_STATUS",
          desc: "Contain the current status of the corresponding cache line                [0]: valid, [1]: dirty, [2]: cmpt",
        }
      ]
    },
    { name:     "TAG_1237",
      desc:     "Tag Address stored in cache line 1237",
      swaccess: "rw",
      hwaccess: "hrw",
      hwext:    "true",
      hwqe:     "true", // enable `qe` latched signal of software write pulse
      hwre:     "true",
      fields: [
        { bits: "5-1:0",
          name: "CL_TAG",
          desc: "Tag Address"
        }
      ]
    },
    {
      name:     "STATUS_1238",
      desc:     "Status register of cache line 1238",
      swaccess: "rw",
      hwaccess: "hrw",
      hwext:    "true",
      hwqe:     "true", // enable `qe` latched signal of software write pulse
      hwre:     "true",
      fields: [
        {
          bits: "5+3:5", // 2 bits for status
          name: "CL_STATUS",
          desc: "Contain the current status of the corresponding cache line                [0]: valid, [1]: dirty, [2]: cmpt",
        }
      ]
    },
    { name:     "TAG_1238",
      desc:     "Tag Address stored in cache line 1238",
      swaccess: "rw",
      hwaccess: "hrw",
      hwext:    "true",
      hwqe:     "true", // enable `qe` latched signal of software write pulse
      hwre:     "true",
      fields: [
        { bits: "5-1:0",
          name: "CL_TAG",
          desc: "Tag Address"
        }
      ]
    },
    {
      name:     "STATUS_1239",
      desc:     "Status register of cache line 1239",
      swaccess: "rw",
      hwaccess: "hrw",
      hwext:    "true",
      hwqe:     "true", // enable `qe` latched signal of software write pulse
      hwre:     "true",
      fields: [
        {
          bits: "5+3:5", // 2 bits for status
          name: "CL_STATUS",
          desc: "Contain the current status of the corresponding cache line                [0]: valid, [1]: dirty, [2]: cmpt",
        }
      ]
    },
    { name:     "TAG_1239",
      desc:     "Tag Address stored in cache line 1239",
      swaccess: "rw",
      hwaccess: "hrw",
      hwext:    "true",
      hwqe:     "true", // enable `qe` latched signal of software write pulse
      hwre:     "true",
      fields: [
        { bits: "5-1:0",
          name: "CL_TAG",
          desc: "Tag Address"
        }
      ]
    },
    {
      name:     "STATUS_1240",
      desc:     "Status register of cache line 1240",
      swaccess: "rw",
      hwaccess: "hrw",
      hwext:    "true",
      hwqe:     "true", // enable `qe` latched signal of software write pulse
      hwre:     "true",
      fields: [
        {
          bits: "5+3:5", // 2 bits for status
          name: "CL_STATUS",
          desc: "Contain the current status of the corresponding cache line                [0]: valid, [1]: dirty, [2]: cmpt",
        }
      ]
    },
    { name:     "TAG_1240",
      desc:     "Tag Address stored in cache line 1240",
      swaccess: "rw",
      hwaccess: "hrw",
      hwext:    "true",
      hwqe:     "true", // enable `qe` latched signal of software write pulse
      hwre:     "true",
      fields: [
        { bits: "5-1:0",
          name: "CL_TAG",
          desc: "Tag Address"
        }
      ]
    },
    {
      name:     "STATUS_1241",
      desc:     "Status register of cache line 1241",
      swaccess: "rw",
      hwaccess: "hrw",
      hwext:    "true",
      hwqe:     "true", // enable `qe` latched signal of software write pulse
      hwre:     "true",
      fields: [
        {
          bits: "5+3:5", // 2 bits for status
          name: "CL_STATUS",
          desc: "Contain the current status of the corresponding cache line                [0]: valid, [1]: dirty, [2]: cmpt",
        }
      ]
    },
    { name:     "TAG_1241",
      desc:     "Tag Address stored in cache line 1241",
      swaccess: "rw",
      hwaccess: "hrw",
      hwext:    "true",
      hwqe:     "true", // enable `qe` latched signal of software write pulse
      hwre:     "true",
      fields: [
        { bits: "5-1:0",
          name: "CL_TAG",
          desc: "Tag Address"
        }
      ]
    },
    {
      name:     "STATUS_1242",
      desc:     "Status register of cache line 1242",
      swaccess: "rw",
      hwaccess: "hrw",
      hwext:    "true",
      hwqe:     "true", // enable `qe` latched signal of software write pulse
      hwre:     "true",
      fields: [
        {
          bits: "5+3:5", // 2 bits for status
          name: "CL_STATUS",
          desc: "Contain the current status of the corresponding cache line                [0]: valid, [1]: dirty, [2]: cmpt",
        }
      ]
    },
    { name:     "TAG_1242",
      desc:     "Tag Address stored in cache line 1242",
      swaccess: "rw",
      hwaccess: "hrw",
      hwext:    "true",
      hwqe:     "true", // enable `qe` latched signal of software write pulse
      hwre:     "true",
      fields: [
        { bits: "5-1:0",
          name: "CL_TAG",
          desc: "Tag Address"
        }
      ]
    },
    {
      name:     "STATUS_1243",
      desc:     "Status register of cache line 1243",
      swaccess: "rw",
      hwaccess: "hrw",
      hwext:    "true",
      hwqe:     "true", // enable `qe` latched signal of software write pulse
      hwre:     "true",
      fields: [
        {
          bits: "5+3:5", // 2 bits for status
          name: "CL_STATUS",
          desc: "Contain the current status of the corresponding cache line                [0]: valid, [1]: dirty, [2]: cmpt",
        }
      ]
    },
    { name:     "TAG_1243",
      desc:     "Tag Address stored in cache line 1243",
      swaccess: "rw",
      hwaccess: "hrw",
      hwext:    "true",
      hwqe:     "true", // enable `qe` latched signal of software write pulse
      hwre:     "true",
      fields: [
        { bits: "5-1:0",
          name: "CL_TAG",
          desc: "Tag Address"
        }
      ]
    },
    {
      name:     "STATUS_1244",
      desc:     "Status register of cache line 1244",
      swaccess: "rw",
      hwaccess: "hrw",
      hwext:    "true",
      hwqe:     "true", // enable `qe` latched signal of software write pulse
      hwre:     "true",
      fields: [
        {
          bits: "5+3:5", // 2 bits for status
          name: "CL_STATUS",
          desc: "Contain the current status of the corresponding cache line                [0]: valid, [1]: dirty, [2]: cmpt",
        }
      ]
    },
    { name:     "TAG_1244",
      desc:     "Tag Address stored in cache line 1244",
      swaccess: "rw",
      hwaccess: "hrw",
      hwext:    "true",
      hwqe:     "true", // enable `qe` latched signal of software write pulse
      hwre:     "true",
      fields: [
        { bits: "5-1:0",
          name: "CL_TAG",
          desc: "Tag Address"
        }
      ]
    },
    {
      name:     "STATUS_1245",
      desc:     "Status register of cache line 1245",
      swaccess: "rw",
      hwaccess: "hrw",
      hwext:    "true",
      hwqe:     "true", // enable `qe` latched signal of software write pulse
      hwre:     "true",
      fields: [
        {
          bits: "5+3:5", // 2 bits for status
          name: "CL_STATUS",
          desc: "Contain the current status of the corresponding cache line                [0]: valid, [1]: dirty, [2]: cmpt",
        }
      ]
    },
    { name:     "TAG_1245",
      desc:     "Tag Address stored in cache line 1245",
      swaccess: "rw",
      hwaccess: "hrw",
      hwext:    "true",
      hwqe:     "true", // enable `qe` latched signal of software write pulse
      hwre:     "true",
      fields: [
        { bits: "5-1:0",
          name: "CL_TAG",
          desc: "Tag Address"
        }
      ]
    },
    {
      name:     "STATUS_1246",
      desc:     "Status register of cache line 1246",
      swaccess: "rw",
      hwaccess: "hrw",
      hwext:    "true",
      hwqe:     "true", // enable `qe` latched signal of software write pulse
      hwre:     "true",
      fields: [
        {
          bits: "5+3:5", // 2 bits for status
          name: "CL_STATUS",
          desc: "Contain the current status of the corresponding cache line                [0]: valid, [1]: dirty, [2]: cmpt",
        }
      ]
    },
    { name:     "TAG_1246",
      desc:     "Tag Address stored in cache line 1246",
      swaccess: "rw",
      hwaccess: "hrw",
      hwext:    "true",
      hwqe:     "true", // enable `qe` latched signal of software write pulse
      hwre:     "true",
      fields: [
        { bits: "5-1:0",
          name: "CL_TAG",
          desc: "Tag Address"
        }
      ]
    },
    {
      name:     "STATUS_1247",
      desc:     "Status register of cache line 1247",
      swaccess: "rw",
      hwaccess: "hrw",
      hwext:    "true",
      hwqe:     "true", // enable `qe` latched signal of software write pulse
      hwre:     "true",
      fields: [
        {
          bits: "5+3:5", // 2 bits for status
          name: "CL_STATUS",
          desc: "Contain the current status of the corresponding cache line                [0]: valid, [1]: dirty, [2]: cmpt",
        }
      ]
    },
    { name:     "TAG_1247",
      desc:     "Tag Address stored in cache line 1247",
      swaccess: "rw",
      hwaccess: "hrw",
      hwext:    "true",
      hwqe:     "true", // enable `qe` latched signal of software write pulse
      hwre:     "true",
      fields: [
        { bits: "5-1:0",
          name: "CL_TAG",
          desc: "Tag Address"
        }
      ]
    },
    {
      name:     "STATUS_1248",
      desc:     "Status register of cache line 1248",
      swaccess: "rw",
      hwaccess: "hrw",
      hwext:    "true",
      hwqe:     "true", // enable `qe` latched signal of software write pulse
      hwre:     "true",
      fields: [
        {
          bits: "5+3:5", // 2 bits for status
          name: "CL_STATUS",
          desc: "Contain the current status of the corresponding cache line                [0]: valid, [1]: dirty, [2]: cmpt",
        }
      ]
    },
    { name:     "TAG_1248",
      desc:     "Tag Address stored in cache line 1248",
      swaccess: "rw",
      hwaccess: "hrw",
      hwext:    "true",
      hwqe:     "true", // enable `qe` latched signal of software write pulse
      hwre:     "true",
      fields: [
        { bits: "5-1:0",
          name: "CL_TAG",
          desc: "Tag Address"
        }
      ]
    },
    {
      name:     "STATUS_1249",
      desc:     "Status register of cache line 1249",
      swaccess: "rw",
      hwaccess: "hrw",
      hwext:    "true",
      hwqe:     "true", // enable `qe` latched signal of software write pulse
      hwre:     "true",
      fields: [
        {
          bits: "5+3:5", // 2 bits for status
          name: "CL_STATUS",
          desc: "Contain the current status of the corresponding cache line                [0]: valid, [1]: dirty, [2]: cmpt",
        }
      ]
    },
    { name:     "TAG_1249",
      desc:     "Tag Address stored in cache line 1249",
      swaccess: "rw",
      hwaccess: "hrw",
      hwext:    "true",
      hwqe:     "true", // enable `qe` latched signal of software write pulse
      hwre:     "true",
      fields: [
        { bits: "5-1:0",
          name: "CL_TAG",
          desc: "Tag Address"
        }
      ]
    },
    {
      name:     "STATUS_1250",
      desc:     "Status register of cache line 1250",
      swaccess: "rw",
      hwaccess: "hrw",
      hwext:    "true",
      hwqe:     "true", // enable `qe` latched signal of software write pulse
      hwre:     "true",
      fields: [
        {
          bits: "5+3:5", // 2 bits for status
          name: "CL_STATUS",
          desc: "Contain the current status of the corresponding cache line                [0]: valid, [1]: dirty, [2]: cmpt",
        }
      ]
    },
    { name:     "TAG_1250",
      desc:     "Tag Address stored in cache line 1250",
      swaccess: "rw",
      hwaccess: "hrw",
      hwext:    "true",
      hwqe:     "true", // enable `qe` latched signal of software write pulse
      hwre:     "true",
      fields: [
        { bits: "5-1:0",
          name: "CL_TAG",
          desc: "Tag Address"
        }
      ]
    },
    {
      name:     "STATUS_1251",
      desc:     "Status register of cache line 1251",
      swaccess: "rw",
      hwaccess: "hrw",
      hwext:    "true",
      hwqe:     "true", // enable `qe` latched signal of software write pulse
      hwre:     "true",
      fields: [
        {
          bits: "5+3:5", // 2 bits for status
          name: "CL_STATUS",
          desc: "Contain the current status of the corresponding cache line                [0]: valid, [1]: dirty, [2]: cmpt",
        }
      ]
    },
    { name:     "TAG_1251",
      desc:     "Tag Address stored in cache line 1251",
      swaccess: "rw",
      hwaccess: "hrw",
      hwext:    "true",
      hwqe:     "true", // enable `qe` latched signal of software write pulse
      hwre:     "true",
      fields: [
        { bits: "5-1:0",
          name: "CL_TAG",
          desc: "Tag Address"
        }
      ]
    },
    {
      name:     "STATUS_1252",
      desc:     "Status register of cache line 1252",
      swaccess: "rw",
      hwaccess: "hrw",
      hwext:    "true",
      hwqe:     "true", // enable `qe` latched signal of software write pulse
      hwre:     "true",
      fields: [
        {
          bits: "5+3:5", // 2 bits for status
          name: "CL_STATUS",
          desc: "Contain the current status of the corresponding cache line                [0]: valid, [1]: dirty, [2]: cmpt",
        }
      ]
    },
    { name:     "TAG_1252",
      desc:     "Tag Address stored in cache line 1252",
      swaccess: "rw",
      hwaccess: "hrw",
      hwext:    "true",
      hwqe:     "true", // enable `qe` latched signal of software write pulse
      hwre:     "true",
      fields: [
        { bits: "5-1:0",
          name: "CL_TAG",
          desc: "Tag Address"
        }
      ]
    },
    {
      name:     "STATUS_1253",
      desc:     "Status register of cache line 1253",
      swaccess: "rw",
      hwaccess: "hrw",
      hwext:    "true",
      hwqe:     "true", // enable `qe` latched signal of software write pulse
      hwre:     "true",
      fields: [
        {
          bits: "5+3:5", // 2 bits for status
          name: "CL_STATUS",
          desc: "Contain the current status of the corresponding cache line                [0]: valid, [1]: dirty, [2]: cmpt",
        }
      ]
    },
    { name:     "TAG_1253",
      desc:     "Tag Address stored in cache line 1253",
      swaccess: "rw",
      hwaccess: "hrw",
      hwext:    "true",
      hwqe:     "true", // enable `qe` latched signal of software write pulse
      hwre:     "true",
      fields: [
        { bits: "5-1:0",
          name: "CL_TAG",
          desc: "Tag Address"
        }
      ]
    },
    {
      name:     "STATUS_1254",
      desc:     "Status register of cache line 1254",
      swaccess: "rw",
      hwaccess: "hrw",
      hwext:    "true",
      hwqe:     "true", // enable `qe` latched signal of software write pulse
      hwre:     "true",
      fields: [
        {
          bits: "5+3:5", // 2 bits for status
          name: "CL_STATUS",
          desc: "Contain the current status of the corresponding cache line                [0]: valid, [1]: dirty, [2]: cmpt",
        }
      ]
    },
    { name:     "TAG_1254",
      desc:     "Tag Address stored in cache line 1254",
      swaccess: "rw",
      hwaccess: "hrw",
      hwext:    "true",
      hwqe:     "true", // enable `qe` latched signal of software write pulse
      hwre:     "true",
      fields: [
        { bits: "5-1:0",
          name: "CL_TAG",
          desc: "Tag Address"
        }
      ]
    },
    {
      name:     "STATUS_1255",
      desc:     "Status register of cache line 1255",
      swaccess: "rw",
      hwaccess: "hrw",
      hwext:    "true",
      hwqe:     "true", // enable `qe` latched signal of software write pulse
      hwre:     "true",
      fields: [
        {
          bits: "5+3:5", // 2 bits for status
          name: "CL_STATUS",
          desc: "Contain the current status of the corresponding cache line                [0]: valid, [1]: dirty, [2]: cmpt",
        }
      ]
    },
    { name:     "TAG_1255",
      desc:     "Tag Address stored in cache line 1255",
      swaccess: "rw",
      hwaccess: "hrw",
      hwext:    "true",
      hwqe:     "true", // enable `qe` latched signal of software write pulse
      hwre:     "true",
      fields: [
        { bits: "5-1:0",
          name: "CL_TAG",
          desc: "Tag Address"
        }
      ]
    },
    {
      name:     "STATUS_1256",
      desc:     "Status register of cache line 1256",
      swaccess: "rw",
      hwaccess: "hrw",
      hwext:    "true",
      hwqe:     "true", // enable `qe` latched signal of software write pulse
      hwre:     "true",
      fields: [
        {
          bits: "5+3:5", // 2 bits for status
          name: "CL_STATUS",
          desc: "Contain the current status of the corresponding cache line                [0]: valid, [1]: dirty, [2]: cmpt",
        }
      ]
    },
    { name:     "TAG_1256",
      desc:     "Tag Address stored in cache line 1256",
      swaccess: "rw",
      hwaccess: "hrw",
      hwext:    "true",
      hwqe:     "true", // enable `qe` latched signal of software write pulse
      hwre:     "true",
      fields: [
        { bits: "5-1:0",
          name: "CL_TAG",
          desc: "Tag Address"
        }
      ]
    },
    {
      name:     "STATUS_1257",
      desc:     "Status register of cache line 1257",
      swaccess: "rw",
      hwaccess: "hrw",
      hwext:    "true",
      hwqe:     "true", // enable `qe` latched signal of software write pulse
      hwre:     "true",
      fields: [
        {
          bits: "5+3:5", // 2 bits for status
          name: "CL_STATUS",
          desc: "Contain the current status of the corresponding cache line                [0]: valid, [1]: dirty, [2]: cmpt",
        }
      ]
    },
    { name:     "TAG_1257",
      desc:     "Tag Address stored in cache line 1257",
      swaccess: "rw",
      hwaccess: "hrw",
      hwext:    "true",
      hwqe:     "true", // enable `qe` latched signal of software write pulse
      hwre:     "true",
      fields: [
        { bits: "5-1:0",
          name: "CL_TAG",
          desc: "Tag Address"
        }
      ]
    },
    {
      name:     "STATUS_1258",
      desc:     "Status register of cache line 1258",
      swaccess: "rw",
      hwaccess: "hrw",
      hwext:    "true",
      hwqe:     "true", // enable `qe` latched signal of software write pulse
      hwre:     "true",
      fields: [
        {
          bits: "5+3:5", // 2 bits for status
          name: "CL_STATUS",
          desc: "Contain the current status of the corresponding cache line                [0]: valid, [1]: dirty, [2]: cmpt",
        }
      ]
    },
    { name:     "TAG_1258",
      desc:     "Tag Address stored in cache line 1258",
      swaccess: "rw",
      hwaccess: "hrw",
      hwext:    "true",
      hwqe:     "true", // enable `qe` latched signal of software write pulse
      hwre:     "true",
      fields: [
        { bits: "5-1:0",
          name: "CL_TAG",
          desc: "Tag Address"
        }
      ]
    },
    {
      name:     "STATUS_1259",
      desc:     "Status register of cache line 1259",
      swaccess: "rw",
      hwaccess: "hrw",
      hwext:    "true",
      hwqe:     "true", // enable `qe` latched signal of software write pulse
      hwre:     "true",
      fields: [
        {
          bits: "5+3:5", // 2 bits for status
          name: "CL_STATUS",
          desc: "Contain the current status of the corresponding cache line                [0]: valid, [1]: dirty, [2]: cmpt",
        }
      ]
    },
    { name:     "TAG_1259",
      desc:     "Tag Address stored in cache line 1259",
      swaccess: "rw",
      hwaccess: "hrw",
      hwext:    "true",
      hwqe:     "true", // enable `qe` latched signal of software write pulse
      hwre:     "true",
      fields: [
        { bits: "5-1:0",
          name: "CL_TAG",
          desc: "Tag Address"
        }
      ]
    },
    {
      name:     "STATUS_1260",
      desc:     "Status register of cache line 1260",
      swaccess: "rw",
      hwaccess: "hrw",
      hwext:    "true",
      hwqe:     "true", // enable `qe` latched signal of software write pulse
      hwre:     "true",
      fields: [
        {
          bits: "5+3:5", // 2 bits for status
          name: "CL_STATUS",
          desc: "Contain the current status of the corresponding cache line                [0]: valid, [1]: dirty, [2]: cmpt",
        }
      ]
    },
    { name:     "TAG_1260",
      desc:     "Tag Address stored in cache line 1260",
      swaccess: "rw",
      hwaccess: "hrw",
      hwext:    "true",
      hwqe:     "true", // enable `qe` latched signal of software write pulse
      hwre:     "true",
      fields: [
        { bits: "5-1:0",
          name: "CL_TAG",
          desc: "Tag Address"
        }
      ]
    },
    {
      name:     "STATUS_1261",
      desc:     "Status register of cache line 1261",
      swaccess: "rw",
      hwaccess: "hrw",
      hwext:    "true",
      hwqe:     "true", // enable `qe` latched signal of software write pulse
      hwre:     "true",
      fields: [
        {
          bits: "5+3:5", // 2 bits for status
          name: "CL_STATUS",
          desc: "Contain the current status of the corresponding cache line                [0]: valid, [1]: dirty, [2]: cmpt",
        }
      ]
    },
    { name:     "TAG_1261",
      desc:     "Tag Address stored in cache line 1261",
      swaccess: "rw",
      hwaccess: "hrw",
      hwext:    "true",
      hwqe:     "true", // enable `qe` latched signal of software write pulse
      hwre:     "true",
      fields: [
        { bits: "5-1:0",
          name: "CL_TAG",
          desc: "Tag Address"
        }
      ]
    },
    {
      name:     "STATUS_1262",
      desc:     "Status register of cache line 1262",
      swaccess: "rw",
      hwaccess: "hrw",
      hwext:    "true",
      hwqe:     "true", // enable `qe` latched signal of software write pulse
      hwre:     "true",
      fields: [
        {
          bits: "5+3:5", // 2 bits for status
          name: "CL_STATUS",
          desc: "Contain the current status of the corresponding cache line                [0]: valid, [1]: dirty, [2]: cmpt",
        }
      ]
    },
    { name:     "TAG_1262",
      desc:     "Tag Address stored in cache line 1262",
      swaccess: "rw",
      hwaccess: "hrw",
      hwext:    "true",
      hwqe:     "true", // enable `qe` latched signal of software write pulse
      hwre:     "true",
      fields: [
        { bits: "5-1:0",
          name: "CL_TAG",
          desc: "Tag Address"
        }
      ]
    },
    {
      name:     "STATUS_1263",
      desc:     "Status register of cache line 1263",
      swaccess: "rw",
      hwaccess: "hrw",
      hwext:    "true",
      hwqe:     "true", // enable `qe` latched signal of software write pulse
      hwre:     "true",
      fields: [
        {
          bits: "5+3:5", // 2 bits for status
          name: "CL_STATUS",
          desc: "Contain the current status of the corresponding cache line                [0]: valid, [1]: dirty, [2]: cmpt",
        }
      ]
    },
    { name:     "TAG_1263",
      desc:     "Tag Address stored in cache line 1263",
      swaccess: "rw",
      hwaccess: "hrw",
      hwext:    "true",
      hwqe:     "true", // enable `qe` latched signal of software write pulse
      hwre:     "true",
      fields: [
        { bits: "5-1:0",
          name: "CL_TAG",
          desc: "Tag Address"
        }
      ]
    },
    {
      name:     "STATUS_1264",
      desc:     "Status register of cache line 1264",
      swaccess: "rw",
      hwaccess: "hrw",
      hwext:    "true",
      hwqe:     "true", // enable `qe` latched signal of software write pulse
      hwre:     "true",
      fields: [
        {
          bits: "5+3:5", // 2 bits for status
          name: "CL_STATUS",
          desc: "Contain the current status of the corresponding cache line                [0]: valid, [1]: dirty, [2]: cmpt",
        }
      ]
    },
    { name:     "TAG_1264",
      desc:     "Tag Address stored in cache line 1264",
      swaccess: "rw",
      hwaccess: "hrw",
      hwext:    "true",
      hwqe:     "true", // enable `qe` latched signal of software write pulse
      hwre:     "true",
      fields: [
        { bits: "5-1:0",
          name: "CL_TAG",
          desc: "Tag Address"
        }
      ]
    },
    {
      name:     "STATUS_1265",
      desc:     "Status register of cache line 1265",
      swaccess: "rw",
      hwaccess: "hrw",
      hwext:    "true",
      hwqe:     "true", // enable `qe` latched signal of software write pulse
      hwre:     "true",
      fields: [
        {
          bits: "5+3:5", // 2 bits for status
          name: "CL_STATUS",
          desc: "Contain the current status of the corresponding cache line                [0]: valid, [1]: dirty, [2]: cmpt",
        }
      ]
    },
    { name:     "TAG_1265",
      desc:     "Tag Address stored in cache line 1265",
      swaccess: "rw",
      hwaccess: "hrw",
      hwext:    "true",
      hwqe:     "true", // enable `qe` latched signal of software write pulse
      hwre:     "true",
      fields: [
        { bits: "5-1:0",
          name: "CL_TAG",
          desc: "Tag Address"
        }
      ]
    },
    {
      name:     "STATUS_1266",
      desc:     "Status register of cache line 1266",
      swaccess: "rw",
      hwaccess: "hrw",
      hwext:    "true",
      hwqe:     "true", // enable `qe` latched signal of software write pulse
      hwre:     "true",
      fields: [
        {
          bits: "5+3:5", // 2 bits for status
          name: "CL_STATUS",
          desc: "Contain the current status of the corresponding cache line                [0]: valid, [1]: dirty, [2]: cmpt",
        }
      ]
    },
    { name:     "TAG_1266",
      desc:     "Tag Address stored in cache line 1266",
      swaccess: "rw",
      hwaccess: "hrw",
      hwext:    "true",
      hwqe:     "true", // enable `qe` latched signal of software write pulse
      hwre:     "true",
      fields: [
        { bits: "5-1:0",
          name: "CL_TAG",
          desc: "Tag Address"
        }
      ]
    },
    {
      name:     "STATUS_1267",
      desc:     "Status register of cache line 1267",
      swaccess: "rw",
      hwaccess: "hrw",
      hwext:    "true",
      hwqe:     "true", // enable `qe` latched signal of software write pulse
      hwre:     "true",
      fields: [
        {
          bits: "5+3:5", // 2 bits for status
          name: "CL_STATUS",
          desc: "Contain the current status of the corresponding cache line                [0]: valid, [1]: dirty, [2]: cmpt",
        }
      ]
    },
    { name:     "TAG_1267",
      desc:     "Tag Address stored in cache line 1267",
      swaccess: "rw",
      hwaccess: "hrw",
      hwext:    "true",
      hwqe:     "true", // enable `qe` latched signal of software write pulse
      hwre:     "true",
      fields: [
        { bits: "5-1:0",
          name: "CL_TAG",
          desc: "Tag Address"
        }
      ]
    },
    {
      name:     "STATUS_1268",
      desc:     "Status register of cache line 1268",
      swaccess: "rw",
      hwaccess: "hrw",
      hwext:    "true",
      hwqe:     "true", // enable `qe` latched signal of software write pulse
      hwre:     "true",
      fields: [
        {
          bits: "5+3:5", // 2 bits for status
          name: "CL_STATUS",
          desc: "Contain the current status of the corresponding cache line                [0]: valid, [1]: dirty, [2]: cmpt",
        }
      ]
    },
    { name:     "TAG_1268",
      desc:     "Tag Address stored in cache line 1268",
      swaccess: "rw",
      hwaccess: "hrw",
      hwext:    "true",
      hwqe:     "true", // enable `qe` latched signal of software write pulse
      hwre:     "true",
      fields: [
        { bits: "5-1:0",
          name: "CL_TAG",
          desc: "Tag Address"
        }
      ]
    },
    {
      name:     "STATUS_1269",
      desc:     "Status register of cache line 1269",
      swaccess: "rw",
      hwaccess: "hrw",
      hwext:    "true",
      hwqe:     "true", // enable `qe` latched signal of software write pulse
      hwre:     "true",
      fields: [
        {
          bits: "5+3:5", // 2 bits for status
          name: "CL_STATUS",
          desc: "Contain the current status of the corresponding cache line                [0]: valid, [1]: dirty, [2]: cmpt",
        }
      ]
    },
    { name:     "TAG_1269",
      desc:     "Tag Address stored in cache line 1269",
      swaccess: "rw",
      hwaccess: "hrw",
      hwext:    "true",
      hwqe:     "true", // enable `qe` latched signal of software write pulse
      hwre:     "true",
      fields: [
        { bits: "5-1:0",
          name: "CL_TAG",
          desc: "Tag Address"
        }
      ]
    },
    {
      name:     "STATUS_1270",
      desc:     "Status register of cache line 1270",
      swaccess: "rw",
      hwaccess: "hrw",
      hwext:    "true",
      hwqe:     "true", // enable `qe` latched signal of software write pulse
      hwre:     "true",
      fields: [
        {
          bits: "5+3:5", // 2 bits for status
          name: "CL_STATUS",
          desc: "Contain the current status of the corresponding cache line                [0]: valid, [1]: dirty, [2]: cmpt",
        }
      ]
    },
    { name:     "TAG_1270",
      desc:     "Tag Address stored in cache line 1270",
      swaccess: "rw",
      hwaccess: "hrw",
      hwext:    "true",
      hwqe:     "true", // enable `qe` latched signal of software write pulse
      hwre:     "true",
      fields: [
        { bits: "5-1:0",
          name: "CL_TAG",
          desc: "Tag Address"
        }
      ]
    },
    {
      name:     "STATUS_1271",
      desc:     "Status register of cache line 1271",
      swaccess: "rw",
      hwaccess: "hrw",
      hwext:    "true",
      hwqe:     "true", // enable `qe` latched signal of software write pulse
      hwre:     "true",
      fields: [
        {
          bits: "5+3:5", // 2 bits for status
          name: "CL_STATUS",
          desc: "Contain the current status of the corresponding cache line                [0]: valid, [1]: dirty, [2]: cmpt",
        }
      ]
    },
    { name:     "TAG_1271",
      desc:     "Tag Address stored in cache line 1271",
      swaccess: "rw",
      hwaccess: "hrw",
      hwext:    "true",
      hwqe:     "true", // enable `qe` latched signal of software write pulse
      hwre:     "true",
      fields: [
        { bits: "5-1:0",
          name: "CL_TAG",
          desc: "Tag Address"
        }
      ]
    },
    {
      name:     "STATUS_1272",
      desc:     "Status register of cache line 1272",
      swaccess: "rw",
      hwaccess: "hrw",
      hwext:    "true",
      hwqe:     "true", // enable `qe` latched signal of software write pulse
      hwre:     "true",
      fields: [
        {
          bits: "5+3:5", // 2 bits for status
          name: "CL_STATUS",
          desc: "Contain the current status of the corresponding cache line                [0]: valid, [1]: dirty, [2]: cmpt",
        }
      ]
    },
    { name:     "TAG_1272",
      desc:     "Tag Address stored in cache line 1272",
      swaccess: "rw",
      hwaccess: "hrw",
      hwext:    "true",
      hwqe:     "true", // enable `qe` latched signal of software write pulse
      hwre:     "true",
      fields: [
        { bits: "5-1:0",
          name: "CL_TAG",
          desc: "Tag Address"
        }
      ]
    },
    {
      name:     "STATUS_1273",
      desc:     "Status register of cache line 1273",
      swaccess: "rw",
      hwaccess: "hrw",
      hwext:    "true",
      hwqe:     "true", // enable `qe` latched signal of software write pulse
      hwre:     "true",
      fields: [
        {
          bits: "5+3:5", // 2 bits for status
          name: "CL_STATUS",
          desc: "Contain the current status of the corresponding cache line                [0]: valid, [1]: dirty, [2]: cmpt",
        }
      ]
    },
    { name:     "TAG_1273",
      desc:     "Tag Address stored in cache line 1273",
      swaccess: "rw",
      hwaccess: "hrw",
      hwext:    "true",
      hwqe:     "true", // enable `qe` latched signal of software write pulse
      hwre:     "true",
      fields: [
        { bits: "5-1:0",
          name: "CL_TAG",
          desc: "Tag Address"
        }
      ]
    },
    {
      name:     "STATUS_1274",
      desc:     "Status register of cache line 1274",
      swaccess: "rw",
      hwaccess: "hrw",
      hwext:    "true",
      hwqe:     "true", // enable `qe` latched signal of software write pulse
      hwre:     "true",
      fields: [
        {
          bits: "5+3:5", // 2 bits for status
          name: "CL_STATUS",
          desc: "Contain the current status of the corresponding cache line                [0]: valid, [1]: dirty, [2]: cmpt",
        }
      ]
    },
    { name:     "TAG_1274",
      desc:     "Tag Address stored in cache line 1274",
      swaccess: "rw",
      hwaccess: "hrw",
      hwext:    "true",
      hwqe:     "true", // enable `qe` latched signal of software write pulse
      hwre:     "true",
      fields: [
        { bits: "5-1:0",
          name: "CL_TAG",
          desc: "Tag Address"
        }
      ]
    },
    {
      name:     "STATUS_1275",
      desc:     "Status register of cache line 1275",
      swaccess: "rw",
      hwaccess: "hrw",
      hwext:    "true",
      hwqe:     "true", // enable `qe` latched signal of software write pulse
      hwre:     "true",
      fields: [
        {
          bits: "5+3:5", // 2 bits for status
          name: "CL_STATUS",
          desc: "Contain the current status of the corresponding cache line                [0]: valid, [1]: dirty, [2]: cmpt",
        }
      ]
    },
    { name:     "TAG_1275",
      desc:     "Tag Address stored in cache line 1275",
      swaccess: "rw",
      hwaccess: "hrw",
      hwext:    "true",
      hwqe:     "true", // enable `qe` latched signal of software write pulse
      hwre:     "true",
      fields: [
        { bits: "5-1:0",
          name: "CL_TAG",
          desc: "Tag Address"
        }
      ]
    },
    {
      name:     "STATUS_1276",
      desc:     "Status register of cache line 1276",
      swaccess: "rw",
      hwaccess: "hrw",
      hwext:    "true",
      hwqe:     "true", // enable `qe` latched signal of software write pulse
      hwre:     "true",
      fields: [
        {
          bits: "5+3:5", // 2 bits for status
          name: "CL_STATUS",
          desc: "Contain the current status of the corresponding cache line                [0]: valid, [1]: dirty, [2]: cmpt",
        }
      ]
    },
    { name:     "TAG_1276",
      desc:     "Tag Address stored in cache line 1276",
      swaccess: "rw",
      hwaccess: "hrw",
      hwext:    "true",
      hwqe:     "true", // enable `qe` latched signal of software write pulse
      hwre:     "true",
      fields: [
        { bits: "5-1:0",
          name: "CL_TAG",
          desc: "Tag Address"
        }
      ]
    },
    {
      name:     "STATUS_1277",
      desc:     "Status register of cache line 1277",
      swaccess: "rw",
      hwaccess: "hrw",
      hwext:    "true",
      hwqe:     "true", // enable `qe` latched signal of software write pulse
      hwre:     "true",
      fields: [
        {
          bits: "5+3:5", // 2 bits for status
          name: "CL_STATUS",
          desc: "Contain the current status of the corresponding cache line                [0]: valid, [1]: dirty, [2]: cmpt",
        }
      ]
    },
    { name:     "TAG_1277",
      desc:     "Tag Address stored in cache line 1277",
      swaccess: "rw",
      hwaccess: "hrw",
      hwext:    "true",
      hwqe:     "true", // enable `qe` latched signal of software write pulse
      hwre:     "true",
      fields: [
        { bits: "5-1:0",
          name: "CL_TAG",
          desc: "Tag Address"
        }
      ]
    },
    {
      name:     "STATUS_1278",
      desc:     "Status register of cache line 1278",
      swaccess: "rw",
      hwaccess: "hrw",
      hwext:    "true",
      hwqe:     "true", // enable `qe` latched signal of software write pulse
      hwre:     "true",
      fields: [
        {
          bits: "5+3:5", // 2 bits for status
          name: "CL_STATUS",
          desc: "Contain the current status of the corresponding cache line                [0]: valid, [1]: dirty, [2]: cmpt",
        }
      ]
    },
    { name:     "TAG_1278",
      desc:     "Tag Address stored in cache line 1278",
      swaccess: "rw",
      hwaccess: "hrw",
      hwext:    "true",
      hwqe:     "true", // enable `qe` latched signal of software write pulse
      hwre:     "true",
      fields: [
        { bits: "5-1:0",
          name: "CL_TAG",
          desc: "Tag Address"
        }
      ]
    },
    {
      name:     "STATUS_1279",
      desc:     "Status register of cache line 1279",
      swaccess: "rw",
      hwaccess: "hrw",
      hwext:    "true",
      hwqe:     "true", // enable `qe` latched signal of software write pulse
      hwre:     "true",
      fields: [
        {
          bits: "5+3:5", // 2 bits for status
          name: "CL_STATUS",
          desc: "Contain the current status of the corresponding cache line                [0]: valid, [1]: dirty, [2]: cmpt",
        }
      ]
    },
    { name:     "TAG_1279",
      desc:     "Tag Address stored in cache line 1279",
      swaccess: "rw",
      hwaccess: "hrw",
      hwext:    "true",
      hwqe:     "true", // enable `qe` latched signal of software write pulse
      hwre:     "true",
      fields: [
        { bits: "5-1:0",
          name: "CL_TAG",
          desc: "Tag Address"
        }
      ]
    },
    {
      name:     "STATUS_1280",
      desc:     "Status register of cache line 1280",
      swaccess: "rw",
      hwaccess: "hrw",
      hwext:    "true",
      hwqe:     "true", // enable `qe` latched signal of software write pulse
      hwre:     "true",
      fields: [
        {
          bits: "5+3:5", // 2 bits for status
          name: "CL_STATUS",
          desc: "Contain the current status of the corresponding cache line                [0]: valid, [1]: dirty, [2]: cmpt",
        }
      ]
    },
    { name:     "TAG_1280",
      desc:     "Tag Address stored in cache line 1280",
      swaccess: "rw",
      hwaccess: "hrw",
      hwext:    "true",
      hwqe:     "true", // enable `qe` latched signal of software write pulse
      hwre:     "true",
      fields: [
        { bits: "5-1:0",
          name: "CL_TAG",
          desc: "Tag Address"
        }
      ]
    },
    {
      name:     "STATUS_1281",
      desc:     "Status register of cache line 1281",
      swaccess: "rw",
      hwaccess: "hrw",
      hwext:    "true",
      hwqe:     "true", // enable `qe` latched signal of software write pulse
      hwre:     "true",
      fields: [
        {
          bits: "5+3:5", // 2 bits for status
          name: "CL_STATUS",
          desc: "Contain the current status of the corresponding cache line                [0]: valid, [1]: dirty, [2]: cmpt",
        }
      ]
    },
    { name:     "TAG_1281",
      desc:     "Tag Address stored in cache line 1281",
      swaccess: "rw",
      hwaccess: "hrw",
      hwext:    "true",
      hwqe:     "true", // enable `qe` latched signal of software write pulse
      hwre:     "true",
      fields: [
        { bits: "5-1:0",
          name: "CL_TAG",
          desc: "Tag Address"
        }
      ]
    },
    {
      name:     "STATUS_1282",
      desc:     "Status register of cache line 1282",
      swaccess: "rw",
      hwaccess: "hrw",
      hwext:    "true",
      hwqe:     "true", // enable `qe` latched signal of software write pulse
      hwre:     "true",
      fields: [
        {
          bits: "5+3:5", // 2 bits for status
          name: "CL_STATUS",
          desc: "Contain the current status of the corresponding cache line                [0]: valid, [1]: dirty, [2]: cmpt",
        }
      ]
    },
    { name:     "TAG_1282",
      desc:     "Tag Address stored in cache line 1282",
      swaccess: "rw",
      hwaccess: "hrw",
      hwext:    "true",
      hwqe:     "true", // enable `qe` latched signal of software write pulse
      hwre:     "true",
      fields: [
        { bits: "5-1:0",
          name: "CL_TAG",
          desc: "Tag Address"
        }
      ]
    },
    {
      name:     "STATUS_1283",
      desc:     "Status register of cache line 1283",
      swaccess: "rw",
      hwaccess: "hrw",
      hwext:    "true",
      hwqe:     "true", // enable `qe` latched signal of software write pulse
      hwre:     "true",
      fields: [
        {
          bits: "5+3:5", // 2 bits for status
          name: "CL_STATUS",
          desc: "Contain the current status of the corresponding cache line                [0]: valid, [1]: dirty, [2]: cmpt",
        }
      ]
    },
    { name:     "TAG_1283",
      desc:     "Tag Address stored in cache line 1283",
      swaccess: "rw",
      hwaccess: "hrw",
      hwext:    "true",
      hwqe:     "true", // enable `qe` latched signal of software write pulse
      hwre:     "true",
      fields: [
        { bits: "5-1:0",
          name: "CL_TAG",
          desc: "Tag Address"
        }
      ]
    },
    {
      name:     "STATUS_1284",
      desc:     "Status register of cache line 1284",
      swaccess: "rw",
      hwaccess: "hrw",
      hwext:    "true",
      hwqe:     "true", // enable `qe` latched signal of software write pulse
      hwre:     "true",
      fields: [
        {
          bits: "5+3:5", // 2 bits for status
          name: "CL_STATUS",
          desc: "Contain the current status of the corresponding cache line                [0]: valid, [1]: dirty, [2]: cmpt",
        }
      ]
    },
    { name:     "TAG_1284",
      desc:     "Tag Address stored in cache line 1284",
      swaccess: "rw",
      hwaccess: "hrw",
      hwext:    "true",
      hwqe:     "true", // enable `qe` latched signal of software write pulse
      hwre:     "true",
      fields: [
        { bits: "5-1:0",
          name: "CL_TAG",
          desc: "Tag Address"
        }
      ]
    },
    {
      name:     "STATUS_1285",
      desc:     "Status register of cache line 1285",
      swaccess: "rw",
      hwaccess: "hrw",
      hwext:    "true",
      hwqe:     "true", // enable `qe` latched signal of software write pulse
      hwre:     "true",
      fields: [
        {
          bits: "5+3:5", // 2 bits for status
          name: "CL_STATUS",
          desc: "Contain the current status of the corresponding cache line                [0]: valid, [1]: dirty, [2]: cmpt",
        }
      ]
    },
    { name:     "TAG_1285",
      desc:     "Tag Address stored in cache line 1285",
      swaccess: "rw",
      hwaccess: "hrw",
      hwext:    "true",
      hwqe:     "true", // enable `qe` latched signal of software write pulse
      hwre:     "true",
      fields: [
        { bits: "5-1:0",
          name: "CL_TAG",
          desc: "Tag Address"
        }
      ]
    },
    {
      name:     "STATUS_1286",
      desc:     "Status register of cache line 1286",
      swaccess: "rw",
      hwaccess: "hrw",
      hwext:    "true",
      hwqe:     "true", // enable `qe` latched signal of software write pulse
      hwre:     "true",
      fields: [
        {
          bits: "5+3:5", // 2 bits for status
          name: "CL_STATUS",
          desc: "Contain the current status of the corresponding cache line                [0]: valid, [1]: dirty, [2]: cmpt",
        }
      ]
    },
    { name:     "TAG_1286",
      desc:     "Tag Address stored in cache line 1286",
      swaccess: "rw",
      hwaccess: "hrw",
      hwext:    "true",
      hwqe:     "true", // enable `qe` latched signal of software write pulse
      hwre:     "true",
      fields: [
        { bits: "5-1:0",
          name: "CL_TAG",
          desc: "Tag Address"
        }
      ]
    },
    {
      name:     "STATUS_1287",
      desc:     "Status register of cache line 1287",
      swaccess: "rw",
      hwaccess: "hrw",
      hwext:    "true",
      hwqe:     "true", // enable `qe` latched signal of software write pulse
      hwre:     "true",
      fields: [
        {
          bits: "5+3:5", // 2 bits for status
          name: "CL_STATUS",
          desc: "Contain the current status of the corresponding cache line                [0]: valid, [1]: dirty, [2]: cmpt",
        }
      ]
    },
    { name:     "TAG_1287",
      desc:     "Tag Address stored in cache line 1287",
      swaccess: "rw",
      hwaccess: "hrw",
      hwext:    "true",
      hwqe:     "true", // enable `qe` latched signal of software write pulse
      hwre:     "true",
      fields: [
        { bits: "5-1:0",
          name: "CL_TAG",
          desc: "Tag Address"
        }
      ]
    },
    {
      name:     "STATUS_1288",
      desc:     "Status register of cache line 1288",
      swaccess: "rw",
      hwaccess: "hrw",
      hwext:    "true",
      hwqe:     "true", // enable `qe` latched signal of software write pulse
      hwre:     "true",
      fields: [
        {
          bits: "5+3:5", // 2 bits for status
          name: "CL_STATUS",
          desc: "Contain the current status of the corresponding cache line                [0]: valid, [1]: dirty, [2]: cmpt",
        }
      ]
    },
    { name:     "TAG_1288",
      desc:     "Tag Address stored in cache line 1288",
      swaccess: "rw",
      hwaccess: "hrw",
      hwext:    "true",
      hwqe:     "true", // enable `qe` latched signal of software write pulse
      hwre:     "true",
      fields: [
        { bits: "5-1:0",
          name: "CL_TAG",
          desc: "Tag Address"
        }
      ]
    },
    {
      name:     "STATUS_1289",
      desc:     "Status register of cache line 1289",
      swaccess: "rw",
      hwaccess: "hrw",
      hwext:    "true",
      hwqe:     "true", // enable `qe` latched signal of software write pulse
      hwre:     "true",
      fields: [
        {
          bits: "5+3:5", // 2 bits for status
          name: "CL_STATUS",
          desc: "Contain the current status of the corresponding cache line                [0]: valid, [1]: dirty, [2]: cmpt",
        }
      ]
    },
    { name:     "TAG_1289",
      desc:     "Tag Address stored in cache line 1289",
      swaccess: "rw",
      hwaccess: "hrw",
      hwext:    "true",
      hwqe:     "true", // enable `qe` latched signal of software write pulse
      hwre:     "true",
      fields: [
        { bits: "5-1:0",
          name: "CL_TAG",
          desc: "Tag Address"
        }
      ]
    },
    {
      name:     "STATUS_1290",
      desc:     "Status register of cache line 1290",
      swaccess: "rw",
      hwaccess: "hrw",
      hwext:    "true",
      hwqe:     "true", // enable `qe` latched signal of software write pulse
      hwre:     "true",
      fields: [
        {
          bits: "5+3:5", // 2 bits for status
          name: "CL_STATUS",
          desc: "Contain the current status of the corresponding cache line                [0]: valid, [1]: dirty, [2]: cmpt",
        }
      ]
    },
    { name:     "TAG_1290",
      desc:     "Tag Address stored in cache line 1290",
      swaccess: "rw",
      hwaccess: "hrw",
      hwext:    "true",
      hwqe:     "true", // enable `qe` latched signal of software write pulse
      hwre:     "true",
      fields: [
        { bits: "5-1:0",
          name: "CL_TAG",
          desc: "Tag Address"
        }
      ]
    },
    {
      name:     "STATUS_1291",
      desc:     "Status register of cache line 1291",
      swaccess: "rw",
      hwaccess: "hrw",
      hwext:    "true",
      hwqe:     "true", // enable `qe` latched signal of software write pulse
      hwre:     "true",
      fields: [
        {
          bits: "5+3:5", // 2 bits for status
          name: "CL_STATUS",
          desc: "Contain the current status of the corresponding cache line                [0]: valid, [1]: dirty, [2]: cmpt",
        }
      ]
    },
    { name:     "TAG_1291",
      desc:     "Tag Address stored in cache line 1291",
      swaccess: "rw",
      hwaccess: "hrw",
      hwext:    "true",
      hwqe:     "true", // enable `qe` latched signal of software write pulse
      hwre:     "true",
      fields: [
        { bits: "5-1:0",
          name: "CL_TAG",
          desc: "Tag Address"
        }
      ]
    },
    {
      name:     "STATUS_1292",
      desc:     "Status register of cache line 1292",
      swaccess: "rw",
      hwaccess: "hrw",
      hwext:    "true",
      hwqe:     "true", // enable `qe` latched signal of software write pulse
      hwre:     "true",
      fields: [
        {
          bits: "5+3:5", // 2 bits for status
          name: "CL_STATUS",
          desc: "Contain the current status of the corresponding cache line                [0]: valid, [1]: dirty, [2]: cmpt",
        }
      ]
    },
    { name:     "TAG_1292",
      desc:     "Tag Address stored in cache line 1292",
      swaccess: "rw",
      hwaccess: "hrw",
      hwext:    "true",
      hwqe:     "true", // enable `qe` latched signal of software write pulse
      hwre:     "true",
      fields: [
        { bits: "5-1:0",
          name: "CL_TAG",
          desc: "Tag Address"
        }
      ]
    },
    {
      name:     "STATUS_1293",
      desc:     "Status register of cache line 1293",
      swaccess: "rw",
      hwaccess: "hrw",
      hwext:    "true",
      hwqe:     "true", // enable `qe` latched signal of software write pulse
      hwre:     "true",
      fields: [
        {
          bits: "5+3:5", // 2 bits for status
          name: "CL_STATUS",
          desc: "Contain the current status of the corresponding cache line                [0]: valid, [1]: dirty, [2]: cmpt",
        }
      ]
    },
    { name:     "TAG_1293",
      desc:     "Tag Address stored in cache line 1293",
      swaccess: "rw",
      hwaccess: "hrw",
      hwext:    "true",
      hwqe:     "true", // enable `qe` latched signal of software write pulse
      hwre:     "true",
      fields: [
        { bits: "5-1:0",
          name: "CL_TAG",
          desc: "Tag Address"
        }
      ]
    },
    {
      name:     "STATUS_1294",
      desc:     "Status register of cache line 1294",
      swaccess: "rw",
      hwaccess: "hrw",
      hwext:    "true",
      hwqe:     "true", // enable `qe` latched signal of software write pulse
      hwre:     "true",
      fields: [
        {
          bits: "5+3:5", // 2 bits for status
          name: "CL_STATUS",
          desc: "Contain the current status of the corresponding cache line                [0]: valid, [1]: dirty, [2]: cmpt",
        }
      ]
    },
    { name:     "TAG_1294",
      desc:     "Tag Address stored in cache line 1294",
      swaccess: "rw",
      hwaccess: "hrw",
      hwext:    "true",
      hwqe:     "true", // enable `qe` latched signal of software write pulse
      hwre:     "true",
      fields: [
        { bits: "5-1:0",
          name: "CL_TAG",
          desc: "Tag Address"
        }
      ]
    },
    {
      name:     "STATUS_1295",
      desc:     "Status register of cache line 1295",
      swaccess: "rw",
      hwaccess: "hrw",
      hwext:    "true",
      hwqe:     "true", // enable `qe` latched signal of software write pulse
      hwre:     "true",
      fields: [
        {
          bits: "5+3:5", // 2 bits for status
          name: "CL_STATUS",
          desc: "Contain the current status of the corresponding cache line                [0]: valid, [1]: dirty, [2]: cmpt",
        }
      ]
    },
    { name:     "TAG_1295",
      desc:     "Tag Address stored in cache line 1295",
      swaccess: "rw",
      hwaccess: "hrw",
      hwext:    "true",
      hwqe:     "true", // enable `qe` latched signal of software write pulse
      hwre:     "true",
      fields: [
        { bits: "5-1:0",
          name: "CL_TAG",
          desc: "Tag Address"
        }
      ]
    },
    {
      name:     "STATUS_1296",
      desc:     "Status register of cache line 1296",
      swaccess: "rw",
      hwaccess: "hrw",
      hwext:    "true",
      hwqe:     "true", // enable `qe` latched signal of software write pulse
      hwre:     "true",
      fields: [
        {
          bits: "5+3:5", // 2 bits for status
          name: "CL_STATUS",
          desc: "Contain the current status of the corresponding cache line                [0]: valid, [1]: dirty, [2]: cmpt",
        }
      ]
    },
    { name:     "TAG_1296",
      desc:     "Tag Address stored in cache line 1296",
      swaccess: "rw",
      hwaccess: "hrw",
      hwext:    "true",
      hwqe:     "true", // enable `qe` latched signal of software write pulse
      hwre:     "true",
      fields: [
        { bits: "5-1:0",
          name: "CL_TAG",
          desc: "Tag Address"
        }
      ]
    },
    {
      name:     "STATUS_1297",
      desc:     "Status register of cache line 1297",
      swaccess: "rw",
      hwaccess: "hrw",
      hwext:    "true",
      hwqe:     "true", // enable `qe` latched signal of software write pulse
      hwre:     "true",
      fields: [
        {
          bits: "5+3:5", // 2 bits for status
          name: "CL_STATUS",
          desc: "Contain the current status of the corresponding cache line                [0]: valid, [1]: dirty, [2]: cmpt",
        }
      ]
    },
    { name:     "TAG_1297",
      desc:     "Tag Address stored in cache line 1297",
      swaccess: "rw",
      hwaccess: "hrw",
      hwext:    "true",
      hwqe:     "true", // enable `qe` latched signal of software write pulse
      hwre:     "true",
      fields: [
        { bits: "5-1:0",
          name: "CL_TAG",
          desc: "Tag Address"
        }
      ]
    },
    {
      name:     "STATUS_1298",
      desc:     "Status register of cache line 1298",
      swaccess: "rw",
      hwaccess: "hrw",
      hwext:    "true",
      hwqe:     "true", // enable `qe` latched signal of software write pulse
      hwre:     "true",
      fields: [
        {
          bits: "5+3:5", // 2 bits for status
          name: "CL_STATUS",
          desc: "Contain the current status of the corresponding cache line                [0]: valid, [1]: dirty, [2]: cmpt",
        }
      ]
    },
    { name:     "TAG_1298",
      desc:     "Tag Address stored in cache line 1298",
      swaccess: "rw",
      hwaccess: "hrw",
      hwext:    "true",
      hwqe:     "true", // enable `qe` latched signal of software write pulse
      hwre:     "true",
      fields: [
        { bits: "5-1:0",
          name: "CL_TAG",
          desc: "Tag Address"
        }
      ]
    },
    {
      name:     "STATUS_1299",
      desc:     "Status register of cache line 1299",
      swaccess: "rw",
      hwaccess: "hrw",
      hwext:    "true",
      hwqe:     "true", // enable `qe` latched signal of software write pulse
      hwre:     "true",
      fields: [
        {
          bits: "5+3:5", // 2 bits for status
          name: "CL_STATUS",
          desc: "Contain the current status of the corresponding cache line                [0]: valid, [1]: dirty, [2]: cmpt",
        }
      ]
    },
    { name:     "TAG_1299",
      desc:     "Tag Address stored in cache line 1299",
      swaccess: "rw",
      hwaccess: "hrw",
      hwext:    "true",
      hwqe:     "true", // enable `qe` latched signal of software write pulse
      hwre:     "true",
      fields: [
        { bits: "5-1:0",
          name: "CL_TAG",
          desc: "Tag Address"
        }
      ]
    },
    {
      name:     "STATUS_1300",
      desc:     "Status register of cache line 1300",
      swaccess: "rw",
      hwaccess: "hrw",
      hwext:    "true",
      hwqe:     "true", // enable `qe` latched signal of software write pulse
      hwre:     "true",
      fields: [
        {
          bits: "5+3:5", // 2 bits for status
          name: "CL_STATUS",
          desc: "Contain the current status of the corresponding cache line                [0]: valid, [1]: dirty, [2]: cmpt",
        }
      ]
    },
    { name:     "TAG_1300",
      desc:     "Tag Address stored in cache line 1300",
      swaccess: "rw",
      hwaccess: "hrw",
      hwext:    "true",
      hwqe:     "true", // enable `qe` latched signal of software write pulse
      hwre:     "true",
      fields: [
        { bits: "5-1:0",
          name: "CL_TAG",
          desc: "Tag Address"
        }
      ]
    },
    {
      name:     "STATUS_1301",
      desc:     "Status register of cache line 1301",
      swaccess: "rw",
      hwaccess: "hrw",
      hwext:    "true",
      hwqe:     "true", // enable `qe` latched signal of software write pulse
      hwre:     "true",
      fields: [
        {
          bits: "5+3:5", // 2 bits for status
          name: "CL_STATUS",
          desc: "Contain the current status of the corresponding cache line                [0]: valid, [1]: dirty, [2]: cmpt",
        }
      ]
    },
    { name:     "TAG_1301",
      desc:     "Tag Address stored in cache line 1301",
      swaccess: "rw",
      hwaccess: "hrw",
      hwext:    "true",
      hwqe:     "true", // enable `qe` latched signal of software write pulse
      hwre:     "true",
      fields: [
        { bits: "5-1:0",
          name: "CL_TAG",
          desc: "Tag Address"
        }
      ]
    },
    {
      name:     "STATUS_1302",
      desc:     "Status register of cache line 1302",
      swaccess: "rw",
      hwaccess: "hrw",
      hwext:    "true",
      hwqe:     "true", // enable `qe` latched signal of software write pulse
      hwre:     "true",
      fields: [
        {
          bits: "5+3:5", // 2 bits for status
          name: "CL_STATUS",
          desc: "Contain the current status of the corresponding cache line                [0]: valid, [1]: dirty, [2]: cmpt",
        }
      ]
    },
    { name:     "TAG_1302",
      desc:     "Tag Address stored in cache line 1302",
      swaccess: "rw",
      hwaccess: "hrw",
      hwext:    "true",
      hwqe:     "true", // enable `qe` latched signal of software write pulse
      hwre:     "true",
      fields: [
        { bits: "5-1:0",
          name: "CL_TAG",
          desc: "Tag Address"
        }
      ]
    },
    {
      name:     "STATUS_1303",
      desc:     "Status register of cache line 1303",
      swaccess: "rw",
      hwaccess: "hrw",
      hwext:    "true",
      hwqe:     "true", // enable `qe` latched signal of software write pulse
      hwre:     "true",
      fields: [
        {
          bits: "5+3:5", // 2 bits for status
          name: "CL_STATUS",
          desc: "Contain the current status of the corresponding cache line                [0]: valid, [1]: dirty, [2]: cmpt",
        }
      ]
    },
    { name:     "TAG_1303",
      desc:     "Tag Address stored in cache line 1303",
      swaccess: "rw",
      hwaccess: "hrw",
      hwext:    "true",
      hwqe:     "true", // enable `qe` latched signal of software write pulse
      hwre:     "true",
      fields: [
        { bits: "5-1:0",
          name: "CL_TAG",
          desc: "Tag Address"
        }
      ]
    },
    {
      name:     "STATUS_1304",
      desc:     "Status register of cache line 1304",
      swaccess: "rw",
      hwaccess: "hrw",
      hwext:    "true",
      hwqe:     "true", // enable `qe` latched signal of software write pulse
      hwre:     "true",
      fields: [
        {
          bits: "5+3:5", // 2 bits for status
          name: "CL_STATUS",
          desc: "Contain the current status of the corresponding cache line                [0]: valid, [1]: dirty, [2]: cmpt",
        }
      ]
    },
    { name:     "TAG_1304",
      desc:     "Tag Address stored in cache line 1304",
      swaccess: "rw",
      hwaccess: "hrw",
      hwext:    "true",
      hwqe:     "true", // enable `qe` latched signal of software write pulse
      hwre:     "true",
      fields: [
        { bits: "5-1:0",
          name: "CL_TAG",
          desc: "Tag Address"
        }
      ]
    },
    {
      name:     "STATUS_1305",
      desc:     "Status register of cache line 1305",
      swaccess: "rw",
      hwaccess: "hrw",
      hwext:    "true",
      hwqe:     "true", // enable `qe` latched signal of software write pulse
      hwre:     "true",
      fields: [
        {
          bits: "5+3:5", // 2 bits for status
          name: "CL_STATUS",
          desc: "Contain the current status of the corresponding cache line                [0]: valid, [1]: dirty, [2]: cmpt",
        }
      ]
    },
    { name:     "TAG_1305",
      desc:     "Tag Address stored in cache line 1305",
      swaccess: "rw",
      hwaccess: "hrw",
      hwext:    "true",
      hwqe:     "true", // enable `qe` latched signal of software write pulse
      hwre:     "true",
      fields: [
        { bits: "5-1:0",
          name: "CL_TAG",
          desc: "Tag Address"
        }
      ]
    },
    {
      name:     "STATUS_1306",
      desc:     "Status register of cache line 1306",
      swaccess: "rw",
      hwaccess: "hrw",
      hwext:    "true",
      hwqe:     "true", // enable `qe` latched signal of software write pulse
      hwre:     "true",
      fields: [
        {
          bits: "5+3:5", // 2 bits for status
          name: "CL_STATUS",
          desc: "Contain the current status of the corresponding cache line                [0]: valid, [1]: dirty, [2]: cmpt",
        }
      ]
    },
    { name:     "TAG_1306",
      desc:     "Tag Address stored in cache line 1306",
      swaccess: "rw",
      hwaccess: "hrw",
      hwext:    "true",
      hwqe:     "true", // enable `qe` latched signal of software write pulse
      hwre:     "true",
      fields: [
        { bits: "5-1:0",
          name: "CL_TAG",
          desc: "Tag Address"
        }
      ]
    },
    {
      name:     "STATUS_1307",
      desc:     "Status register of cache line 1307",
      swaccess: "rw",
      hwaccess: "hrw",
      hwext:    "true",
      hwqe:     "true", // enable `qe` latched signal of software write pulse
      hwre:     "true",
      fields: [
        {
          bits: "5+3:5", // 2 bits for status
          name: "CL_STATUS",
          desc: "Contain the current status of the corresponding cache line                [0]: valid, [1]: dirty, [2]: cmpt",
        }
      ]
    },
    { name:     "TAG_1307",
      desc:     "Tag Address stored in cache line 1307",
      swaccess: "rw",
      hwaccess: "hrw",
      hwext:    "true",
      hwqe:     "true", // enable `qe` latched signal of software write pulse
      hwre:     "true",
      fields: [
        { bits: "5-1:0",
          name: "CL_TAG",
          desc: "Tag Address"
        }
      ]
    },
    {
      name:     "STATUS_1308",
      desc:     "Status register of cache line 1308",
      swaccess: "rw",
      hwaccess: "hrw",
      hwext:    "true",
      hwqe:     "true", // enable `qe` latched signal of software write pulse
      hwre:     "true",
      fields: [
        {
          bits: "5+3:5", // 2 bits for status
          name: "CL_STATUS",
          desc: "Contain the current status of the corresponding cache line                [0]: valid, [1]: dirty, [2]: cmpt",
        }
      ]
    },
    { name:     "TAG_1308",
      desc:     "Tag Address stored in cache line 1308",
      swaccess: "rw",
      hwaccess: "hrw",
      hwext:    "true",
      hwqe:     "true", // enable `qe` latched signal of software write pulse
      hwre:     "true",
      fields: [
        { bits: "5-1:0",
          name: "CL_TAG",
          desc: "Tag Address"
        }
      ]
    },
    {
      name:     "STATUS_1309",
      desc:     "Status register of cache line 1309",
      swaccess: "rw",
      hwaccess: "hrw",
      hwext:    "true",
      hwqe:     "true", // enable `qe` latched signal of software write pulse
      hwre:     "true",
      fields: [
        {
          bits: "5+3:5", // 2 bits for status
          name: "CL_STATUS",
          desc: "Contain the current status of the corresponding cache line                [0]: valid, [1]: dirty, [2]: cmpt",
        }
      ]
    },
    { name:     "TAG_1309",
      desc:     "Tag Address stored in cache line 1309",
      swaccess: "rw",
      hwaccess: "hrw",
      hwext:    "true",
      hwqe:     "true", // enable `qe` latched signal of software write pulse
      hwre:     "true",
      fields: [
        { bits: "5-1:0",
          name: "CL_TAG",
          desc: "Tag Address"
        }
      ]
    },
    {
      name:     "STATUS_1310",
      desc:     "Status register of cache line 1310",
      swaccess: "rw",
      hwaccess: "hrw",
      hwext:    "true",
      hwqe:     "true", // enable `qe` latched signal of software write pulse
      hwre:     "true",
      fields: [
        {
          bits: "5+3:5", // 2 bits for status
          name: "CL_STATUS",
          desc: "Contain the current status of the corresponding cache line                [0]: valid, [1]: dirty, [2]: cmpt",
        }
      ]
    },
    { name:     "TAG_1310",
      desc:     "Tag Address stored in cache line 1310",
      swaccess: "rw",
      hwaccess: "hrw",
      hwext:    "true",
      hwqe:     "true", // enable `qe` latched signal of software write pulse
      hwre:     "true",
      fields: [
        { bits: "5-1:0",
          name: "CL_TAG",
          desc: "Tag Address"
        }
      ]
    },
    {
      name:     "STATUS_1311",
      desc:     "Status register of cache line 1311",
      swaccess: "rw",
      hwaccess: "hrw",
      hwext:    "true",
      hwqe:     "true", // enable `qe` latched signal of software write pulse
      hwre:     "true",
      fields: [
        {
          bits: "5+3:5", // 2 bits for status
          name: "CL_STATUS",
          desc: "Contain the current status of the corresponding cache line                [0]: valid, [1]: dirty, [2]: cmpt",
        }
      ]
    },
    { name:     "TAG_1311",
      desc:     "Tag Address stored in cache line 1311",
      swaccess: "rw",
      hwaccess: "hrw",
      hwext:    "true",
      hwqe:     "true", // enable `qe` latched signal of software write pulse
      hwre:     "true",
      fields: [
        { bits: "5-1:0",
          name: "CL_TAG",
          desc: "Tag Address"
        }
      ]
    },
    {
      name:     "STATUS_1312",
      desc:     "Status register of cache line 1312",
      swaccess: "rw",
      hwaccess: "hrw",
      hwext:    "true",
      hwqe:     "true", // enable `qe` latched signal of software write pulse
      hwre:     "true",
      fields: [
        {
          bits: "5+3:5", // 2 bits for status
          name: "CL_STATUS",
          desc: "Contain the current status of the corresponding cache line                [0]: valid, [1]: dirty, [2]: cmpt",
        }
      ]
    },
    { name:     "TAG_1312",
      desc:     "Tag Address stored in cache line 1312",
      swaccess: "rw",
      hwaccess: "hrw",
      hwext:    "true",
      hwqe:     "true", // enable `qe` latched signal of software write pulse
      hwre:     "true",
      fields: [
        { bits: "5-1:0",
          name: "CL_TAG",
          desc: "Tag Address"
        }
      ]
    },
    {
      name:     "STATUS_1313",
      desc:     "Status register of cache line 1313",
      swaccess: "rw",
      hwaccess: "hrw",
      hwext:    "true",
      hwqe:     "true", // enable `qe` latched signal of software write pulse
      hwre:     "true",
      fields: [
        {
          bits: "5+3:5", // 2 bits for status
          name: "CL_STATUS",
          desc: "Contain the current status of the corresponding cache line                [0]: valid, [1]: dirty, [2]: cmpt",
        }
      ]
    },
    { name:     "TAG_1313",
      desc:     "Tag Address stored in cache line 1313",
      swaccess: "rw",
      hwaccess: "hrw",
      hwext:    "true",
      hwqe:     "true", // enable `qe` latched signal of software write pulse
      hwre:     "true",
      fields: [
        { bits: "5-1:0",
          name: "CL_TAG",
          desc: "Tag Address"
        }
      ]
    },
    {
      name:     "STATUS_1314",
      desc:     "Status register of cache line 1314",
      swaccess: "rw",
      hwaccess: "hrw",
      hwext:    "true",
      hwqe:     "true", // enable `qe` latched signal of software write pulse
      hwre:     "true",
      fields: [
        {
          bits: "5+3:5", // 2 bits for status
          name: "CL_STATUS",
          desc: "Contain the current status of the corresponding cache line                [0]: valid, [1]: dirty, [2]: cmpt",
        }
      ]
    },
    { name:     "TAG_1314",
      desc:     "Tag Address stored in cache line 1314",
      swaccess: "rw",
      hwaccess: "hrw",
      hwext:    "true",
      hwqe:     "true", // enable `qe` latched signal of software write pulse
      hwre:     "true",
      fields: [
        { bits: "5-1:0",
          name: "CL_TAG",
          desc: "Tag Address"
        }
      ]
    },
    {
      name:     "STATUS_1315",
      desc:     "Status register of cache line 1315",
      swaccess: "rw",
      hwaccess: "hrw",
      hwext:    "true",
      hwqe:     "true", // enable `qe` latched signal of software write pulse
      hwre:     "true",
      fields: [
        {
          bits: "5+3:5", // 2 bits for status
          name: "CL_STATUS",
          desc: "Contain the current status of the corresponding cache line                [0]: valid, [1]: dirty, [2]: cmpt",
        }
      ]
    },
    { name:     "TAG_1315",
      desc:     "Tag Address stored in cache line 1315",
      swaccess: "rw",
      hwaccess: "hrw",
      hwext:    "true",
      hwqe:     "true", // enable `qe` latched signal of software write pulse
      hwre:     "true",
      fields: [
        { bits: "5-1:0",
          name: "CL_TAG",
          desc: "Tag Address"
        }
      ]
    },
    {
      name:     "STATUS_1316",
      desc:     "Status register of cache line 1316",
      swaccess: "rw",
      hwaccess: "hrw",
      hwext:    "true",
      hwqe:     "true", // enable `qe` latched signal of software write pulse
      hwre:     "true",
      fields: [
        {
          bits: "5+3:5", // 2 bits for status
          name: "CL_STATUS",
          desc: "Contain the current status of the corresponding cache line                [0]: valid, [1]: dirty, [2]: cmpt",
        }
      ]
    },
    { name:     "TAG_1316",
      desc:     "Tag Address stored in cache line 1316",
      swaccess: "rw",
      hwaccess: "hrw",
      hwext:    "true",
      hwqe:     "true", // enable `qe` latched signal of software write pulse
      hwre:     "true",
      fields: [
        { bits: "5-1:0",
          name: "CL_TAG",
          desc: "Tag Address"
        }
      ]
    },
    {
      name:     "STATUS_1317",
      desc:     "Status register of cache line 1317",
      swaccess: "rw",
      hwaccess: "hrw",
      hwext:    "true",
      hwqe:     "true", // enable `qe` latched signal of software write pulse
      hwre:     "true",
      fields: [
        {
          bits: "5+3:5", // 2 bits for status
          name: "CL_STATUS",
          desc: "Contain the current status of the corresponding cache line                [0]: valid, [1]: dirty, [2]: cmpt",
        }
      ]
    },
    { name:     "TAG_1317",
      desc:     "Tag Address stored in cache line 1317",
      swaccess: "rw",
      hwaccess: "hrw",
      hwext:    "true",
      hwqe:     "true", // enable `qe` latched signal of software write pulse
      hwre:     "true",
      fields: [
        { bits: "5-1:0",
          name: "CL_TAG",
          desc: "Tag Address"
        }
      ]
    },
    {
      name:     "STATUS_1318",
      desc:     "Status register of cache line 1318",
      swaccess: "rw",
      hwaccess: "hrw",
      hwext:    "true",
      hwqe:     "true", // enable `qe` latched signal of software write pulse
      hwre:     "true",
      fields: [
        {
          bits: "5+3:5", // 2 bits for status
          name: "CL_STATUS",
          desc: "Contain the current status of the corresponding cache line                [0]: valid, [1]: dirty, [2]: cmpt",
        }
      ]
    },
    { name:     "TAG_1318",
      desc:     "Tag Address stored in cache line 1318",
      swaccess: "rw",
      hwaccess: "hrw",
      hwext:    "true",
      hwqe:     "true", // enable `qe` latched signal of software write pulse
      hwre:     "true",
      fields: [
        { bits: "5-1:0",
          name: "CL_TAG",
          desc: "Tag Address"
        }
      ]
    },
    {
      name:     "STATUS_1319",
      desc:     "Status register of cache line 1319",
      swaccess: "rw",
      hwaccess: "hrw",
      hwext:    "true",
      hwqe:     "true", // enable `qe` latched signal of software write pulse
      hwre:     "true",
      fields: [
        {
          bits: "5+3:5", // 2 bits for status
          name: "CL_STATUS",
          desc: "Contain the current status of the corresponding cache line                [0]: valid, [1]: dirty, [2]: cmpt",
        }
      ]
    },
    { name:     "TAG_1319",
      desc:     "Tag Address stored in cache line 1319",
      swaccess: "rw",
      hwaccess: "hrw",
      hwext:    "true",
      hwqe:     "true", // enable `qe` latched signal of software write pulse
      hwre:     "true",
      fields: [
        { bits: "5-1:0",
          name: "CL_TAG",
          desc: "Tag Address"
        }
      ]
    },
    {
      name:     "STATUS_1320",
      desc:     "Status register of cache line 1320",
      swaccess: "rw",
      hwaccess: "hrw",
      hwext:    "true",
      hwqe:     "true", // enable `qe` latched signal of software write pulse
      hwre:     "true",
      fields: [
        {
          bits: "5+3:5", // 2 bits for status
          name: "CL_STATUS",
          desc: "Contain the current status of the corresponding cache line                [0]: valid, [1]: dirty, [2]: cmpt",
        }
      ]
    },
    { name:     "TAG_1320",
      desc:     "Tag Address stored in cache line 1320",
      swaccess: "rw",
      hwaccess: "hrw",
      hwext:    "true",
      hwqe:     "true", // enable `qe` latched signal of software write pulse
      hwre:     "true",
      fields: [
        { bits: "5-1:0",
          name: "CL_TAG",
          desc: "Tag Address"
        }
      ]
    },
    {
      name:     "STATUS_1321",
      desc:     "Status register of cache line 1321",
      swaccess: "rw",
      hwaccess: "hrw",
      hwext:    "true",
      hwqe:     "true", // enable `qe` latched signal of software write pulse
      hwre:     "true",
      fields: [
        {
          bits: "5+3:5", // 2 bits for status
          name: "CL_STATUS",
          desc: "Contain the current status of the corresponding cache line                [0]: valid, [1]: dirty, [2]: cmpt",
        }
      ]
    },
    { name:     "TAG_1321",
      desc:     "Tag Address stored in cache line 1321",
      swaccess: "rw",
      hwaccess: "hrw",
      hwext:    "true",
      hwqe:     "true", // enable `qe` latched signal of software write pulse
      hwre:     "true",
      fields: [
        { bits: "5-1:0",
          name: "CL_TAG",
          desc: "Tag Address"
        }
      ]
    },
    {
      name:     "STATUS_1322",
      desc:     "Status register of cache line 1322",
      swaccess: "rw",
      hwaccess: "hrw",
      hwext:    "true",
      hwqe:     "true", // enable `qe` latched signal of software write pulse
      hwre:     "true",
      fields: [
        {
          bits: "5+3:5", // 2 bits for status
          name: "CL_STATUS",
          desc: "Contain the current status of the corresponding cache line                [0]: valid, [1]: dirty, [2]: cmpt",
        }
      ]
    },
    { name:     "TAG_1322",
      desc:     "Tag Address stored in cache line 1322",
      swaccess: "rw",
      hwaccess: "hrw",
      hwext:    "true",
      hwqe:     "true", // enable `qe` latched signal of software write pulse
      hwre:     "true",
      fields: [
        { bits: "5-1:0",
          name: "CL_TAG",
          desc: "Tag Address"
        }
      ]
    },
    {
      name:     "STATUS_1323",
      desc:     "Status register of cache line 1323",
      swaccess: "rw",
      hwaccess: "hrw",
      hwext:    "true",
      hwqe:     "true", // enable `qe` latched signal of software write pulse
      hwre:     "true",
      fields: [
        {
          bits: "5+3:5", // 2 bits for status
          name: "CL_STATUS",
          desc: "Contain the current status of the corresponding cache line                [0]: valid, [1]: dirty, [2]: cmpt",
        }
      ]
    },
    { name:     "TAG_1323",
      desc:     "Tag Address stored in cache line 1323",
      swaccess: "rw",
      hwaccess: "hrw",
      hwext:    "true",
      hwqe:     "true", // enable `qe` latched signal of software write pulse
      hwre:     "true",
      fields: [
        { bits: "5-1:0",
          name: "CL_TAG",
          desc: "Tag Address"
        }
      ]
    },
    {
      name:     "STATUS_1324",
      desc:     "Status register of cache line 1324",
      swaccess: "rw",
      hwaccess: "hrw",
      hwext:    "true",
      hwqe:     "true", // enable `qe` latched signal of software write pulse
      hwre:     "true",
      fields: [
        {
          bits: "5+3:5", // 2 bits for status
          name: "CL_STATUS",
          desc: "Contain the current status of the corresponding cache line                [0]: valid, [1]: dirty, [2]: cmpt",
        }
      ]
    },
    { name:     "TAG_1324",
      desc:     "Tag Address stored in cache line 1324",
      swaccess: "rw",
      hwaccess: "hrw",
      hwext:    "true",
      hwqe:     "true", // enable `qe` latched signal of software write pulse
      hwre:     "true",
      fields: [
        { bits: "5-1:0",
          name: "CL_TAG",
          desc: "Tag Address"
        }
      ]
    },
    {
      name:     "STATUS_1325",
      desc:     "Status register of cache line 1325",
      swaccess: "rw",
      hwaccess: "hrw",
      hwext:    "true",
      hwqe:     "true", // enable `qe` latched signal of software write pulse
      hwre:     "true",
      fields: [
        {
          bits: "5+3:5", // 2 bits for status
          name: "CL_STATUS",
          desc: "Contain the current status of the corresponding cache line                [0]: valid, [1]: dirty, [2]: cmpt",
        }
      ]
    },
    { name:     "TAG_1325",
      desc:     "Tag Address stored in cache line 1325",
      swaccess: "rw",
      hwaccess: "hrw",
      hwext:    "true",
      hwqe:     "true", // enable `qe` latched signal of software write pulse
      hwre:     "true",
      fields: [
        { bits: "5-1:0",
          name: "CL_TAG",
          desc: "Tag Address"
        }
      ]
    },
    {
      name:     "STATUS_1326",
      desc:     "Status register of cache line 1326",
      swaccess: "rw",
      hwaccess: "hrw",
      hwext:    "true",
      hwqe:     "true", // enable `qe` latched signal of software write pulse
      hwre:     "true",
      fields: [
        {
          bits: "5+3:5", // 2 bits for status
          name: "CL_STATUS",
          desc: "Contain the current status of the corresponding cache line                [0]: valid, [1]: dirty, [2]: cmpt",
        }
      ]
    },
    { name:     "TAG_1326",
      desc:     "Tag Address stored in cache line 1326",
      swaccess: "rw",
      hwaccess: "hrw",
      hwext:    "true",
      hwqe:     "true", // enable `qe` latched signal of software write pulse
      hwre:     "true",
      fields: [
        { bits: "5-1:0",
          name: "CL_TAG",
          desc: "Tag Address"
        }
      ]
    },
    {
      name:     "STATUS_1327",
      desc:     "Status register of cache line 1327",
      swaccess: "rw",
      hwaccess: "hrw",
      hwext:    "true",
      hwqe:     "true", // enable `qe` latched signal of software write pulse
      hwre:     "true",
      fields: [
        {
          bits: "5+3:5", // 2 bits for status
          name: "CL_STATUS",
          desc: "Contain the current status of the corresponding cache line                [0]: valid, [1]: dirty, [2]: cmpt",
        }
      ]
    },
    { name:     "TAG_1327",
      desc:     "Tag Address stored in cache line 1327",
      swaccess: "rw",
      hwaccess: "hrw",
      hwext:    "true",
      hwqe:     "true", // enable `qe` latched signal of software write pulse
      hwre:     "true",
      fields: [
        { bits: "5-1:0",
          name: "CL_TAG",
          desc: "Tag Address"
        }
      ]
    },
    {
      name:     "STATUS_1328",
      desc:     "Status register of cache line 1328",
      swaccess: "rw",
      hwaccess: "hrw",
      hwext:    "true",
      hwqe:     "true", // enable `qe` latched signal of software write pulse
      hwre:     "true",
      fields: [
        {
          bits: "5+3:5", // 2 bits for status
          name: "CL_STATUS",
          desc: "Contain the current status of the corresponding cache line                [0]: valid, [1]: dirty, [2]: cmpt",
        }
      ]
    },
    { name:     "TAG_1328",
      desc:     "Tag Address stored in cache line 1328",
      swaccess: "rw",
      hwaccess: "hrw",
      hwext:    "true",
      hwqe:     "true", // enable `qe` latched signal of software write pulse
      hwre:     "true",
      fields: [
        { bits: "5-1:0",
          name: "CL_TAG",
          desc: "Tag Address"
        }
      ]
    },
    {
      name:     "STATUS_1329",
      desc:     "Status register of cache line 1329",
      swaccess: "rw",
      hwaccess: "hrw",
      hwext:    "true",
      hwqe:     "true", // enable `qe` latched signal of software write pulse
      hwre:     "true",
      fields: [
        {
          bits: "5+3:5", // 2 bits for status
          name: "CL_STATUS",
          desc: "Contain the current status of the corresponding cache line                [0]: valid, [1]: dirty, [2]: cmpt",
        }
      ]
    },
    { name:     "TAG_1329",
      desc:     "Tag Address stored in cache line 1329",
      swaccess: "rw",
      hwaccess: "hrw",
      hwext:    "true",
      hwqe:     "true", // enable `qe` latched signal of software write pulse
      hwre:     "true",
      fields: [
        { bits: "5-1:0",
          name: "CL_TAG",
          desc: "Tag Address"
        }
      ]
    },
    {
      name:     "STATUS_1330",
      desc:     "Status register of cache line 1330",
      swaccess: "rw",
      hwaccess: "hrw",
      hwext:    "true",
      hwqe:     "true", // enable `qe` latched signal of software write pulse
      hwre:     "true",
      fields: [
        {
          bits: "5+3:5", // 2 bits for status
          name: "CL_STATUS",
          desc: "Contain the current status of the corresponding cache line                [0]: valid, [1]: dirty, [2]: cmpt",
        }
      ]
    },
    { name:     "TAG_1330",
      desc:     "Tag Address stored in cache line 1330",
      swaccess: "rw",
      hwaccess: "hrw",
      hwext:    "true",
      hwqe:     "true", // enable `qe` latched signal of software write pulse
      hwre:     "true",
      fields: [
        { bits: "5-1:0",
          name: "CL_TAG",
          desc: "Tag Address"
        }
      ]
    },
    {
      name:     "STATUS_1331",
      desc:     "Status register of cache line 1331",
      swaccess: "rw",
      hwaccess: "hrw",
      hwext:    "true",
      hwqe:     "true", // enable `qe` latched signal of software write pulse
      hwre:     "true",
      fields: [
        {
          bits: "5+3:5", // 2 bits for status
          name: "CL_STATUS",
          desc: "Contain the current status of the corresponding cache line                [0]: valid, [1]: dirty, [2]: cmpt",
        }
      ]
    },
    { name:     "TAG_1331",
      desc:     "Tag Address stored in cache line 1331",
      swaccess: "rw",
      hwaccess: "hrw",
      hwext:    "true",
      hwqe:     "true", // enable `qe` latched signal of software write pulse
      hwre:     "true",
      fields: [
        { bits: "5-1:0",
          name: "CL_TAG",
          desc: "Tag Address"
        }
      ]
    },
    {
      name:     "STATUS_1332",
      desc:     "Status register of cache line 1332",
      swaccess: "rw",
      hwaccess: "hrw",
      hwext:    "true",
      hwqe:     "true", // enable `qe` latched signal of software write pulse
      hwre:     "true",
      fields: [
        {
          bits: "5+3:5", // 2 bits for status
          name: "CL_STATUS",
          desc: "Contain the current status of the corresponding cache line                [0]: valid, [1]: dirty, [2]: cmpt",
        }
      ]
    },
    { name:     "TAG_1332",
      desc:     "Tag Address stored in cache line 1332",
      swaccess: "rw",
      hwaccess: "hrw",
      hwext:    "true",
      hwqe:     "true", // enable `qe` latched signal of software write pulse
      hwre:     "true",
      fields: [
        { bits: "5-1:0",
          name: "CL_TAG",
          desc: "Tag Address"
        }
      ]
    },
    {
      name:     "STATUS_1333",
      desc:     "Status register of cache line 1333",
      swaccess: "rw",
      hwaccess: "hrw",
      hwext:    "true",
      hwqe:     "true", // enable `qe` latched signal of software write pulse
      hwre:     "true",
      fields: [
        {
          bits: "5+3:5", // 2 bits for status
          name: "CL_STATUS",
          desc: "Contain the current status of the corresponding cache line                [0]: valid, [1]: dirty, [2]: cmpt",
        }
      ]
    },
    { name:     "TAG_1333",
      desc:     "Tag Address stored in cache line 1333",
      swaccess: "rw",
      hwaccess: "hrw",
      hwext:    "true",
      hwqe:     "true", // enable `qe` latched signal of software write pulse
      hwre:     "true",
      fields: [
        { bits: "5-1:0",
          name: "CL_TAG",
          desc: "Tag Address"
        }
      ]
    },
    {
      name:     "STATUS_1334",
      desc:     "Status register of cache line 1334",
      swaccess: "rw",
      hwaccess: "hrw",
      hwext:    "true",
      hwqe:     "true", // enable `qe` latched signal of software write pulse
      hwre:     "true",
      fields: [
        {
          bits: "5+3:5", // 2 bits for status
          name: "CL_STATUS",
          desc: "Contain the current status of the corresponding cache line                [0]: valid, [1]: dirty, [2]: cmpt",
        }
      ]
    },
    { name:     "TAG_1334",
      desc:     "Tag Address stored in cache line 1334",
      swaccess: "rw",
      hwaccess: "hrw",
      hwext:    "true",
      hwqe:     "true", // enable `qe` latched signal of software write pulse
      hwre:     "true",
      fields: [
        { bits: "5-1:0",
          name: "CL_TAG",
          desc: "Tag Address"
        }
      ]
    },
    {
      name:     "STATUS_1335",
      desc:     "Status register of cache line 1335",
      swaccess: "rw",
      hwaccess: "hrw",
      hwext:    "true",
      hwqe:     "true", // enable `qe` latched signal of software write pulse
      hwre:     "true",
      fields: [
        {
          bits: "5+3:5", // 2 bits for status
          name: "CL_STATUS",
          desc: "Contain the current status of the corresponding cache line                [0]: valid, [1]: dirty, [2]: cmpt",
        }
      ]
    },
    { name:     "TAG_1335",
      desc:     "Tag Address stored in cache line 1335",
      swaccess: "rw",
      hwaccess: "hrw",
      hwext:    "true",
      hwqe:     "true", // enable `qe` latched signal of software write pulse
      hwre:     "true",
      fields: [
        { bits: "5-1:0",
          name: "CL_TAG",
          desc: "Tag Address"
        }
      ]
    },
    {
      name:     "STATUS_1336",
      desc:     "Status register of cache line 1336",
      swaccess: "rw",
      hwaccess: "hrw",
      hwext:    "true",
      hwqe:     "true", // enable `qe` latched signal of software write pulse
      hwre:     "true",
      fields: [
        {
          bits: "5+3:5", // 2 bits for status
          name: "CL_STATUS",
          desc: "Contain the current status of the corresponding cache line                [0]: valid, [1]: dirty, [2]: cmpt",
        }
      ]
    },
    { name:     "TAG_1336",
      desc:     "Tag Address stored in cache line 1336",
      swaccess: "rw",
      hwaccess: "hrw",
      hwext:    "true",
      hwqe:     "true", // enable `qe` latched signal of software write pulse
      hwre:     "true",
      fields: [
        { bits: "5-1:0",
          name: "CL_TAG",
          desc: "Tag Address"
        }
      ]
    },
    {
      name:     "STATUS_1337",
      desc:     "Status register of cache line 1337",
      swaccess: "rw",
      hwaccess: "hrw",
      hwext:    "true",
      hwqe:     "true", // enable `qe` latched signal of software write pulse
      hwre:     "true",
      fields: [
        {
          bits: "5+3:5", // 2 bits for status
          name: "CL_STATUS",
          desc: "Contain the current status of the corresponding cache line                [0]: valid, [1]: dirty, [2]: cmpt",
        }
      ]
    },
    { name:     "TAG_1337",
      desc:     "Tag Address stored in cache line 1337",
      swaccess: "rw",
      hwaccess: "hrw",
      hwext:    "true",
      hwqe:     "true", // enable `qe` latched signal of software write pulse
      hwre:     "true",
      fields: [
        { bits: "5-1:0",
          name: "CL_TAG",
          desc: "Tag Address"
        }
      ]
    },
    {
      name:     "STATUS_1338",
      desc:     "Status register of cache line 1338",
      swaccess: "rw",
      hwaccess: "hrw",
      hwext:    "true",
      hwqe:     "true", // enable `qe` latched signal of software write pulse
      hwre:     "true",
      fields: [
        {
          bits: "5+3:5", // 2 bits for status
          name: "CL_STATUS",
          desc: "Contain the current status of the corresponding cache line                [0]: valid, [1]: dirty, [2]: cmpt",
        }
      ]
    },
    { name:     "TAG_1338",
      desc:     "Tag Address stored in cache line 1338",
      swaccess: "rw",
      hwaccess: "hrw",
      hwext:    "true",
      hwqe:     "true", // enable `qe` latched signal of software write pulse
      hwre:     "true",
      fields: [
        { bits: "5-1:0",
          name: "CL_TAG",
          desc: "Tag Address"
        }
      ]
    },
    {
      name:     "STATUS_1339",
      desc:     "Status register of cache line 1339",
      swaccess: "rw",
      hwaccess: "hrw",
      hwext:    "true",
      hwqe:     "true", // enable `qe` latched signal of software write pulse
      hwre:     "true",
      fields: [
        {
          bits: "5+3:5", // 2 bits for status
          name: "CL_STATUS",
          desc: "Contain the current status of the corresponding cache line                [0]: valid, [1]: dirty, [2]: cmpt",
        }
      ]
    },
    { name:     "TAG_1339",
      desc:     "Tag Address stored in cache line 1339",
      swaccess: "rw",
      hwaccess: "hrw",
      hwext:    "true",
      hwqe:     "true", // enable `qe` latched signal of software write pulse
      hwre:     "true",
      fields: [
        { bits: "5-1:0",
          name: "CL_TAG",
          desc: "Tag Address"
        }
      ]
    },
    {
      name:     "STATUS_1340",
      desc:     "Status register of cache line 1340",
      swaccess: "rw",
      hwaccess: "hrw",
      hwext:    "true",
      hwqe:     "true", // enable `qe` latched signal of software write pulse
      hwre:     "true",
      fields: [
        {
          bits: "5+3:5", // 2 bits for status
          name: "CL_STATUS",
          desc: "Contain the current status of the corresponding cache line                [0]: valid, [1]: dirty, [2]: cmpt",
        }
      ]
    },
    { name:     "TAG_1340",
      desc:     "Tag Address stored in cache line 1340",
      swaccess: "rw",
      hwaccess: "hrw",
      hwext:    "true",
      hwqe:     "true", // enable `qe` latched signal of software write pulse
      hwre:     "true",
      fields: [
        { bits: "5-1:0",
          name: "CL_TAG",
          desc: "Tag Address"
        }
      ]
    },
    {
      name:     "STATUS_1341",
      desc:     "Status register of cache line 1341",
      swaccess: "rw",
      hwaccess: "hrw",
      hwext:    "true",
      hwqe:     "true", // enable `qe` latched signal of software write pulse
      hwre:     "true",
      fields: [
        {
          bits: "5+3:5", // 2 bits for status
          name: "CL_STATUS",
          desc: "Contain the current status of the corresponding cache line                [0]: valid, [1]: dirty, [2]: cmpt",
        }
      ]
    },
    { name:     "TAG_1341",
      desc:     "Tag Address stored in cache line 1341",
      swaccess: "rw",
      hwaccess: "hrw",
      hwext:    "true",
      hwqe:     "true", // enable `qe` latched signal of software write pulse
      hwre:     "true",
      fields: [
        { bits: "5-1:0",
          name: "CL_TAG",
          desc: "Tag Address"
        }
      ]
    },
    {
      name:     "STATUS_1342",
      desc:     "Status register of cache line 1342",
      swaccess: "rw",
      hwaccess: "hrw",
      hwext:    "true",
      hwqe:     "true", // enable `qe` latched signal of software write pulse
      hwre:     "true",
      fields: [
        {
          bits: "5+3:5", // 2 bits for status
          name: "CL_STATUS",
          desc: "Contain the current status of the corresponding cache line                [0]: valid, [1]: dirty, [2]: cmpt",
        }
      ]
    },
    { name:     "TAG_1342",
      desc:     "Tag Address stored in cache line 1342",
      swaccess: "rw",
      hwaccess: "hrw",
      hwext:    "true",
      hwqe:     "true", // enable `qe` latched signal of software write pulse
      hwre:     "true",
      fields: [
        { bits: "5-1:0",
          name: "CL_TAG",
          desc: "Tag Address"
        }
      ]
    },
    {
      name:     "STATUS_1343",
      desc:     "Status register of cache line 1343",
      swaccess: "rw",
      hwaccess: "hrw",
      hwext:    "true",
      hwqe:     "true", // enable `qe` latched signal of software write pulse
      hwre:     "true",
      fields: [
        {
          bits: "5+3:5", // 2 bits for status
          name: "CL_STATUS",
          desc: "Contain the current status of the corresponding cache line                [0]: valid, [1]: dirty, [2]: cmpt",
        }
      ]
    },
    { name:     "TAG_1343",
      desc:     "Tag Address stored in cache line 1343",
      swaccess: "rw",
      hwaccess: "hrw",
      hwext:    "true",
      hwqe:     "true", // enable `qe` latched signal of software write pulse
      hwre:     "true",
      fields: [
        { bits: "5-1:0",
          name: "CL_TAG",
          desc: "Tag Address"
        }
      ]
    },
    {
      name:     "STATUS_1344",
      desc:     "Status register of cache line 1344",
      swaccess: "rw",
      hwaccess: "hrw",
      hwext:    "true",
      hwqe:     "true", // enable `qe` latched signal of software write pulse
      hwre:     "true",
      fields: [
        {
          bits: "5+3:5", // 2 bits for status
          name: "CL_STATUS",
          desc: "Contain the current status of the corresponding cache line                [0]: valid, [1]: dirty, [2]: cmpt",
        }
      ]
    },
    { name:     "TAG_1344",
      desc:     "Tag Address stored in cache line 1344",
      swaccess: "rw",
      hwaccess: "hrw",
      hwext:    "true",
      hwqe:     "true", // enable `qe` latched signal of software write pulse
      hwre:     "true",
      fields: [
        { bits: "5-1:0",
          name: "CL_TAG",
          desc: "Tag Address"
        }
      ]
    },
    {
      name:     "STATUS_1345",
      desc:     "Status register of cache line 1345",
      swaccess: "rw",
      hwaccess: "hrw",
      hwext:    "true",
      hwqe:     "true", // enable `qe` latched signal of software write pulse
      hwre:     "true",
      fields: [
        {
          bits: "5+3:5", // 2 bits for status
          name: "CL_STATUS",
          desc: "Contain the current status of the corresponding cache line                [0]: valid, [1]: dirty, [2]: cmpt",
        }
      ]
    },
    { name:     "TAG_1345",
      desc:     "Tag Address stored in cache line 1345",
      swaccess: "rw",
      hwaccess: "hrw",
      hwext:    "true",
      hwqe:     "true", // enable `qe` latched signal of software write pulse
      hwre:     "true",
      fields: [
        { bits: "5-1:0",
          name: "CL_TAG",
          desc: "Tag Address"
        }
      ]
    },
    {
      name:     "STATUS_1346",
      desc:     "Status register of cache line 1346",
      swaccess: "rw",
      hwaccess: "hrw",
      hwext:    "true",
      hwqe:     "true", // enable `qe` latched signal of software write pulse
      hwre:     "true",
      fields: [
        {
          bits: "5+3:5", // 2 bits for status
          name: "CL_STATUS",
          desc: "Contain the current status of the corresponding cache line                [0]: valid, [1]: dirty, [2]: cmpt",
        }
      ]
    },
    { name:     "TAG_1346",
      desc:     "Tag Address stored in cache line 1346",
      swaccess: "rw",
      hwaccess: "hrw",
      hwext:    "true",
      hwqe:     "true", // enable `qe` latched signal of software write pulse
      hwre:     "true",
      fields: [
        { bits: "5-1:0",
          name: "CL_TAG",
          desc: "Tag Address"
        }
      ]
    },
    {
      name:     "STATUS_1347",
      desc:     "Status register of cache line 1347",
      swaccess: "rw",
      hwaccess: "hrw",
      hwext:    "true",
      hwqe:     "true", // enable `qe` latched signal of software write pulse
      hwre:     "true",
      fields: [
        {
          bits: "5+3:5", // 2 bits for status
          name: "CL_STATUS",
          desc: "Contain the current status of the corresponding cache line                [0]: valid, [1]: dirty, [2]: cmpt",
        }
      ]
    },
    { name:     "TAG_1347",
      desc:     "Tag Address stored in cache line 1347",
      swaccess: "rw",
      hwaccess: "hrw",
      hwext:    "true",
      hwqe:     "true", // enable `qe` latched signal of software write pulse
      hwre:     "true",
      fields: [
        { bits: "5-1:0",
          name: "CL_TAG",
          desc: "Tag Address"
        }
      ]
    },
    {
      name:     "STATUS_1348",
      desc:     "Status register of cache line 1348",
      swaccess: "rw",
      hwaccess: "hrw",
      hwext:    "true",
      hwqe:     "true", // enable `qe` latched signal of software write pulse
      hwre:     "true",
      fields: [
        {
          bits: "5+3:5", // 2 bits for status
          name: "CL_STATUS",
          desc: "Contain the current status of the corresponding cache line                [0]: valid, [1]: dirty, [2]: cmpt",
        }
      ]
    },
    { name:     "TAG_1348",
      desc:     "Tag Address stored in cache line 1348",
      swaccess: "rw",
      hwaccess: "hrw",
      hwext:    "true",
      hwqe:     "true", // enable `qe` latched signal of software write pulse
      hwre:     "true",
      fields: [
        { bits: "5-1:0",
          name: "CL_TAG",
          desc: "Tag Address"
        }
      ]
    },
    {
      name:     "STATUS_1349",
      desc:     "Status register of cache line 1349",
      swaccess: "rw",
      hwaccess: "hrw",
      hwext:    "true",
      hwqe:     "true", // enable `qe` latched signal of software write pulse
      hwre:     "true",
      fields: [
        {
          bits: "5+3:5", // 2 bits for status
          name: "CL_STATUS",
          desc: "Contain the current status of the corresponding cache line                [0]: valid, [1]: dirty, [2]: cmpt",
        }
      ]
    },
    { name:     "TAG_1349",
      desc:     "Tag Address stored in cache line 1349",
      swaccess: "rw",
      hwaccess: "hrw",
      hwext:    "true",
      hwqe:     "true", // enable `qe` latched signal of software write pulse
      hwre:     "true",
      fields: [
        { bits: "5-1:0",
          name: "CL_TAG",
          desc: "Tag Address"
        }
      ]
    },
    {
      name:     "STATUS_1350",
      desc:     "Status register of cache line 1350",
      swaccess: "rw",
      hwaccess: "hrw",
      hwext:    "true",
      hwqe:     "true", // enable `qe` latched signal of software write pulse
      hwre:     "true",
      fields: [
        {
          bits: "5+3:5", // 2 bits for status
          name: "CL_STATUS",
          desc: "Contain the current status of the corresponding cache line                [0]: valid, [1]: dirty, [2]: cmpt",
        }
      ]
    },
    { name:     "TAG_1350",
      desc:     "Tag Address stored in cache line 1350",
      swaccess: "rw",
      hwaccess: "hrw",
      hwext:    "true",
      hwqe:     "true", // enable `qe` latched signal of software write pulse
      hwre:     "true",
      fields: [
        { bits: "5-1:0",
          name: "CL_TAG",
          desc: "Tag Address"
        }
      ]
    },
    {
      name:     "STATUS_1351",
      desc:     "Status register of cache line 1351",
      swaccess: "rw",
      hwaccess: "hrw",
      hwext:    "true",
      hwqe:     "true", // enable `qe` latched signal of software write pulse
      hwre:     "true",
      fields: [
        {
          bits: "5+3:5", // 2 bits for status
          name: "CL_STATUS",
          desc: "Contain the current status of the corresponding cache line                [0]: valid, [1]: dirty, [2]: cmpt",
        }
      ]
    },
    { name:     "TAG_1351",
      desc:     "Tag Address stored in cache line 1351",
      swaccess: "rw",
      hwaccess: "hrw",
      hwext:    "true",
      hwqe:     "true", // enable `qe` latched signal of software write pulse
      hwre:     "true",
      fields: [
        { bits: "5-1:0",
          name: "CL_TAG",
          desc: "Tag Address"
        }
      ]
    },
    {
      name:     "STATUS_1352",
      desc:     "Status register of cache line 1352",
      swaccess: "rw",
      hwaccess: "hrw",
      hwext:    "true",
      hwqe:     "true", // enable `qe` latched signal of software write pulse
      hwre:     "true",
      fields: [
        {
          bits: "5+3:5", // 2 bits for status
          name: "CL_STATUS",
          desc: "Contain the current status of the corresponding cache line                [0]: valid, [1]: dirty, [2]: cmpt",
        }
      ]
    },
    { name:     "TAG_1352",
      desc:     "Tag Address stored in cache line 1352",
      swaccess: "rw",
      hwaccess: "hrw",
      hwext:    "true",
      hwqe:     "true", // enable `qe` latched signal of software write pulse
      hwre:     "true",
      fields: [
        { bits: "5-1:0",
          name: "CL_TAG",
          desc: "Tag Address"
        }
      ]
    },
    {
      name:     "STATUS_1353",
      desc:     "Status register of cache line 1353",
      swaccess: "rw",
      hwaccess: "hrw",
      hwext:    "true",
      hwqe:     "true", // enable `qe` latched signal of software write pulse
      hwre:     "true",
      fields: [
        {
          bits: "5+3:5", // 2 bits for status
          name: "CL_STATUS",
          desc: "Contain the current status of the corresponding cache line                [0]: valid, [1]: dirty, [2]: cmpt",
        }
      ]
    },
    { name:     "TAG_1353",
      desc:     "Tag Address stored in cache line 1353",
      swaccess: "rw",
      hwaccess: "hrw",
      hwext:    "true",
      hwqe:     "true", // enable `qe` latched signal of software write pulse
      hwre:     "true",
      fields: [
        { bits: "5-1:0",
          name: "CL_TAG",
          desc: "Tag Address"
        }
      ]
    },
    {
      name:     "STATUS_1354",
      desc:     "Status register of cache line 1354",
      swaccess: "rw",
      hwaccess: "hrw",
      hwext:    "true",
      hwqe:     "true", // enable `qe` latched signal of software write pulse
      hwre:     "true",
      fields: [
        {
          bits: "5+3:5", // 2 bits for status
          name: "CL_STATUS",
          desc: "Contain the current status of the corresponding cache line                [0]: valid, [1]: dirty, [2]: cmpt",
        }
      ]
    },
    { name:     "TAG_1354",
      desc:     "Tag Address stored in cache line 1354",
      swaccess: "rw",
      hwaccess: "hrw",
      hwext:    "true",
      hwqe:     "true", // enable `qe` latched signal of software write pulse
      hwre:     "true",
      fields: [
        { bits: "5-1:0",
          name: "CL_TAG",
          desc: "Tag Address"
        }
      ]
    },
    {
      name:     "STATUS_1355",
      desc:     "Status register of cache line 1355",
      swaccess: "rw",
      hwaccess: "hrw",
      hwext:    "true",
      hwqe:     "true", // enable `qe` latched signal of software write pulse
      hwre:     "true",
      fields: [
        {
          bits: "5+3:5", // 2 bits for status
          name: "CL_STATUS",
          desc: "Contain the current status of the corresponding cache line                [0]: valid, [1]: dirty, [2]: cmpt",
        }
      ]
    },
    { name:     "TAG_1355",
      desc:     "Tag Address stored in cache line 1355",
      swaccess: "rw",
      hwaccess: "hrw",
      hwext:    "true",
      hwqe:     "true", // enable `qe` latched signal of software write pulse
      hwre:     "true",
      fields: [
        { bits: "5-1:0",
          name: "CL_TAG",
          desc: "Tag Address"
        }
      ]
    },
    {
      name:     "STATUS_1356",
      desc:     "Status register of cache line 1356",
      swaccess: "rw",
      hwaccess: "hrw",
      hwext:    "true",
      hwqe:     "true", // enable `qe` latched signal of software write pulse
      hwre:     "true",
      fields: [
        {
          bits: "5+3:5", // 2 bits for status
          name: "CL_STATUS",
          desc: "Contain the current status of the corresponding cache line                [0]: valid, [1]: dirty, [2]: cmpt",
        }
      ]
    },
    { name:     "TAG_1356",
      desc:     "Tag Address stored in cache line 1356",
      swaccess: "rw",
      hwaccess: "hrw",
      hwext:    "true",
      hwqe:     "true", // enable `qe` latched signal of software write pulse
      hwre:     "true",
      fields: [
        { bits: "5-1:0",
          name: "CL_TAG",
          desc: "Tag Address"
        }
      ]
    },
    {
      name:     "STATUS_1357",
      desc:     "Status register of cache line 1357",
      swaccess: "rw",
      hwaccess: "hrw",
      hwext:    "true",
      hwqe:     "true", // enable `qe` latched signal of software write pulse
      hwre:     "true",
      fields: [
        {
          bits: "5+3:5", // 2 bits for status
          name: "CL_STATUS",
          desc: "Contain the current status of the corresponding cache line                [0]: valid, [1]: dirty, [2]: cmpt",
        }
      ]
    },
    { name:     "TAG_1357",
      desc:     "Tag Address stored in cache line 1357",
      swaccess: "rw",
      hwaccess: "hrw",
      hwext:    "true",
      hwqe:     "true", // enable `qe` latched signal of software write pulse
      hwre:     "true",
      fields: [
        { bits: "5-1:0",
          name: "CL_TAG",
          desc: "Tag Address"
        }
      ]
    },
    {
      name:     "STATUS_1358",
      desc:     "Status register of cache line 1358",
      swaccess: "rw",
      hwaccess: "hrw",
      hwext:    "true",
      hwqe:     "true", // enable `qe` latched signal of software write pulse
      hwre:     "true",
      fields: [
        {
          bits: "5+3:5", // 2 bits for status
          name: "CL_STATUS",
          desc: "Contain the current status of the corresponding cache line                [0]: valid, [1]: dirty, [2]: cmpt",
        }
      ]
    },
    { name:     "TAG_1358",
      desc:     "Tag Address stored in cache line 1358",
      swaccess: "rw",
      hwaccess: "hrw",
      hwext:    "true",
      hwqe:     "true", // enable `qe` latched signal of software write pulse
      hwre:     "true",
      fields: [
        { bits: "5-1:0",
          name: "CL_TAG",
          desc: "Tag Address"
        }
      ]
    },
    {
      name:     "STATUS_1359",
      desc:     "Status register of cache line 1359",
      swaccess: "rw",
      hwaccess: "hrw",
      hwext:    "true",
      hwqe:     "true", // enable `qe` latched signal of software write pulse
      hwre:     "true",
      fields: [
        {
          bits: "5+3:5", // 2 bits for status
          name: "CL_STATUS",
          desc: "Contain the current status of the corresponding cache line                [0]: valid, [1]: dirty, [2]: cmpt",
        }
      ]
    },
    { name:     "TAG_1359",
      desc:     "Tag Address stored in cache line 1359",
      swaccess: "rw",
      hwaccess: "hrw",
      hwext:    "true",
      hwqe:     "true", // enable `qe` latched signal of software write pulse
      hwre:     "true",
      fields: [
        { bits: "5-1:0",
          name: "CL_TAG",
          desc: "Tag Address"
        }
      ]
    },
    {
      name:     "STATUS_1360",
      desc:     "Status register of cache line 1360",
      swaccess: "rw",
      hwaccess: "hrw",
      hwext:    "true",
      hwqe:     "true", // enable `qe` latched signal of software write pulse
      hwre:     "true",
      fields: [
        {
          bits: "5+3:5", // 2 bits for status
          name: "CL_STATUS",
          desc: "Contain the current status of the corresponding cache line                [0]: valid, [1]: dirty, [2]: cmpt",
        }
      ]
    },
    { name:     "TAG_1360",
      desc:     "Tag Address stored in cache line 1360",
      swaccess: "rw",
      hwaccess: "hrw",
      hwext:    "true",
      hwqe:     "true", // enable `qe` latched signal of software write pulse
      hwre:     "true",
      fields: [
        { bits: "5-1:0",
          name: "CL_TAG",
          desc: "Tag Address"
        }
      ]
    },
    {
      name:     "STATUS_1361",
      desc:     "Status register of cache line 1361",
      swaccess: "rw",
      hwaccess: "hrw",
      hwext:    "true",
      hwqe:     "true", // enable `qe` latched signal of software write pulse
      hwre:     "true",
      fields: [
        {
          bits: "5+3:5", // 2 bits for status
          name: "CL_STATUS",
          desc: "Contain the current status of the corresponding cache line                [0]: valid, [1]: dirty, [2]: cmpt",
        }
      ]
    },
    { name:     "TAG_1361",
      desc:     "Tag Address stored in cache line 1361",
      swaccess: "rw",
      hwaccess: "hrw",
      hwext:    "true",
      hwqe:     "true", // enable `qe` latched signal of software write pulse
      hwre:     "true",
      fields: [
        { bits: "5-1:0",
          name: "CL_TAG",
          desc: "Tag Address"
        }
      ]
    },
    {
      name:     "STATUS_1362",
      desc:     "Status register of cache line 1362",
      swaccess: "rw",
      hwaccess: "hrw",
      hwext:    "true",
      hwqe:     "true", // enable `qe` latched signal of software write pulse
      hwre:     "true",
      fields: [
        {
          bits: "5+3:5", // 2 bits for status
          name: "CL_STATUS",
          desc: "Contain the current status of the corresponding cache line                [0]: valid, [1]: dirty, [2]: cmpt",
        }
      ]
    },
    { name:     "TAG_1362",
      desc:     "Tag Address stored in cache line 1362",
      swaccess: "rw",
      hwaccess: "hrw",
      hwext:    "true",
      hwqe:     "true", // enable `qe` latched signal of software write pulse
      hwre:     "true",
      fields: [
        { bits: "5-1:0",
          name: "CL_TAG",
          desc: "Tag Address"
        }
      ]
    },
    {
      name:     "STATUS_1363",
      desc:     "Status register of cache line 1363",
      swaccess: "rw",
      hwaccess: "hrw",
      hwext:    "true",
      hwqe:     "true", // enable `qe` latched signal of software write pulse
      hwre:     "true",
      fields: [
        {
          bits: "5+3:5", // 2 bits for status
          name: "CL_STATUS",
          desc: "Contain the current status of the corresponding cache line                [0]: valid, [1]: dirty, [2]: cmpt",
        }
      ]
    },
    { name:     "TAG_1363",
      desc:     "Tag Address stored in cache line 1363",
      swaccess: "rw",
      hwaccess: "hrw",
      hwext:    "true",
      hwqe:     "true", // enable `qe` latched signal of software write pulse
      hwre:     "true",
      fields: [
        { bits: "5-1:0",
          name: "CL_TAG",
          desc: "Tag Address"
        }
      ]
    },
    {
      name:     "STATUS_1364",
      desc:     "Status register of cache line 1364",
      swaccess: "rw",
      hwaccess: "hrw",
      hwext:    "true",
      hwqe:     "true", // enable `qe` latched signal of software write pulse
      hwre:     "true",
      fields: [
        {
          bits: "5+3:5", // 2 bits for status
          name: "CL_STATUS",
          desc: "Contain the current status of the corresponding cache line                [0]: valid, [1]: dirty, [2]: cmpt",
        }
      ]
    },
    { name:     "TAG_1364",
      desc:     "Tag Address stored in cache line 1364",
      swaccess: "rw",
      hwaccess: "hrw",
      hwext:    "true",
      hwqe:     "true", // enable `qe` latched signal of software write pulse
      hwre:     "true",
      fields: [
        { bits: "5-1:0",
          name: "CL_TAG",
          desc: "Tag Address"
        }
      ]
    },
    {
      name:     "STATUS_1365",
      desc:     "Status register of cache line 1365",
      swaccess: "rw",
      hwaccess: "hrw",
      hwext:    "true",
      hwqe:     "true", // enable `qe` latched signal of software write pulse
      hwre:     "true",
      fields: [
        {
          bits: "5+3:5", // 2 bits for status
          name: "CL_STATUS",
          desc: "Contain the current status of the corresponding cache line                [0]: valid, [1]: dirty, [2]: cmpt",
        }
      ]
    },
    { name:     "TAG_1365",
      desc:     "Tag Address stored in cache line 1365",
      swaccess: "rw",
      hwaccess: "hrw",
      hwext:    "true",
      hwqe:     "true", // enable `qe` latched signal of software write pulse
      hwre:     "true",
      fields: [
        { bits: "5-1:0",
          name: "CL_TAG",
          desc: "Tag Address"
        }
      ]
    },
    {
      name:     "STATUS_1366",
      desc:     "Status register of cache line 1366",
      swaccess: "rw",
      hwaccess: "hrw",
      hwext:    "true",
      hwqe:     "true", // enable `qe` latched signal of software write pulse
      hwre:     "true",
      fields: [
        {
          bits: "5+3:5", // 2 bits for status
          name: "CL_STATUS",
          desc: "Contain the current status of the corresponding cache line                [0]: valid, [1]: dirty, [2]: cmpt",
        }
      ]
    },
    { name:     "TAG_1366",
      desc:     "Tag Address stored in cache line 1366",
      swaccess: "rw",
      hwaccess: "hrw",
      hwext:    "true",
      hwqe:     "true", // enable `qe` latched signal of software write pulse
      hwre:     "true",
      fields: [
        { bits: "5-1:0",
          name: "CL_TAG",
          desc: "Tag Address"
        }
      ]
    },
    {
      name:     "STATUS_1367",
      desc:     "Status register of cache line 1367",
      swaccess: "rw",
      hwaccess: "hrw",
      hwext:    "true",
      hwqe:     "true", // enable `qe` latched signal of software write pulse
      hwre:     "true",
      fields: [
        {
          bits: "5+3:5", // 2 bits for status
          name: "CL_STATUS",
          desc: "Contain the current status of the corresponding cache line                [0]: valid, [1]: dirty, [2]: cmpt",
        }
      ]
    },
    { name:     "TAG_1367",
      desc:     "Tag Address stored in cache line 1367",
      swaccess: "rw",
      hwaccess: "hrw",
      hwext:    "true",
      hwqe:     "true", // enable `qe` latched signal of software write pulse
      hwre:     "true",
      fields: [
        { bits: "5-1:0",
          name: "CL_TAG",
          desc: "Tag Address"
        }
      ]
    },
    {
      name:     "STATUS_1368",
      desc:     "Status register of cache line 1368",
      swaccess: "rw",
      hwaccess: "hrw",
      hwext:    "true",
      hwqe:     "true", // enable `qe` latched signal of software write pulse
      hwre:     "true",
      fields: [
        {
          bits: "5+3:5", // 2 bits for status
          name: "CL_STATUS",
          desc: "Contain the current status of the corresponding cache line                [0]: valid, [1]: dirty, [2]: cmpt",
        }
      ]
    },
    { name:     "TAG_1368",
      desc:     "Tag Address stored in cache line 1368",
      swaccess: "rw",
      hwaccess: "hrw",
      hwext:    "true",
      hwqe:     "true", // enable `qe` latched signal of software write pulse
      hwre:     "true",
      fields: [
        { bits: "5-1:0",
          name: "CL_TAG",
          desc: "Tag Address"
        }
      ]
    },
    {
      name:     "STATUS_1369",
      desc:     "Status register of cache line 1369",
      swaccess: "rw",
      hwaccess: "hrw",
      hwext:    "true",
      hwqe:     "true", // enable `qe` latched signal of software write pulse
      hwre:     "true",
      fields: [
        {
          bits: "5+3:5", // 2 bits for status
          name: "CL_STATUS",
          desc: "Contain the current status of the corresponding cache line                [0]: valid, [1]: dirty, [2]: cmpt",
        }
      ]
    },
    { name:     "TAG_1369",
      desc:     "Tag Address stored in cache line 1369",
      swaccess: "rw",
      hwaccess: "hrw",
      hwext:    "true",
      hwqe:     "true", // enable `qe` latched signal of software write pulse
      hwre:     "true",
      fields: [
        { bits: "5-1:0",
          name: "CL_TAG",
          desc: "Tag Address"
        }
      ]
    },
    {
      name:     "STATUS_1370",
      desc:     "Status register of cache line 1370",
      swaccess: "rw",
      hwaccess: "hrw",
      hwext:    "true",
      hwqe:     "true", // enable `qe` latched signal of software write pulse
      hwre:     "true",
      fields: [
        {
          bits: "5+3:5", // 2 bits for status
          name: "CL_STATUS",
          desc: "Contain the current status of the corresponding cache line                [0]: valid, [1]: dirty, [2]: cmpt",
        }
      ]
    },
    { name:     "TAG_1370",
      desc:     "Tag Address stored in cache line 1370",
      swaccess: "rw",
      hwaccess: "hrw",
      hwext:    "true",
      hwqe:     "true", // enable `qe` latched signal of software write pulse
      hwre:     "true",
      fields: [
        { bits: "5-1:0",
          name: "CL_TAG",
          desc: "Tag Address"
        }
      ]
    },
    {
      name:     "STATUS_1371",
      desc:     "Status register of cache line 1371",
      swaccess: "rw",
      hwaccess: "hrw",
      hwext:    "true",
      hwqe:     "true", // enable `qe` latched signal of software write pulse
      hwre:     "true",
      fields: [
        {
          bits: "5+3:5", // 2 bits for status
          name: "CL_STATUS",
          desc: "Contain the current status of the corresponding cache line                [0]: valid, [1]: dirty, [2]: cmpt",
        }
      ]
    },
    { name:     "TAG_1371",
      desc:     "Tag Address stored in cache line 1371",
      swaccess: "rw",
      hwaccess: "hrw",
      hwext:    "true",
      hwqe:     "true", // enable `qe` latched signal of software write pulse
      hwre:     "true",
      fields: [
        { bits: "5-1:0",
          name: "CL_TAG",
          desc: "Tag Address"
        }
      ]
    },
    {
      name:     "STATUS_1372",
      desc:     "Status register of cache line 1372",
      swaccess: "rw",
      hwaccess: "hrw",
      hwext:    "true",
      hwqe:     "true", // enable `qe` latched signal of software write pulse
      hwre:     "true",
      fields: [
        {
          bits: "5+3:5", // 2 bits for status
          name: "CL_STATUS",
          desc: "Contain the current status of the corresponding cache line                [0]: valid, [1]: dirty, [2]: cmpt",
        }
      ]
    },
    { name:     "TAG_1372",
      desc:     "Tag Address stored in cache line 1372",
      swaccess: "rw",
      hwaccess: "hrw",
      hwext:    "true",
      hwqe:     "true", // enable `qe` latched signal of software write pulse
      hwre:     "true",
      fields: [
        { bits: "5-1:0",
          name: "CL_TAG",
          desc: "Tag Address"
        }
      ]
    },
    {
      name:     "STATUS_1373",
      desc:     "Status register of cache line 1373",
      swaccess: "rw",
      hwaccess: "hrw",
      hwext:    "true",
      hwqe:     "true", // enable `qe` latched signal of software write pulse
      hwre:     "true",
      fields: [
        {
          bits: "5+3:5", // 2 bits for status
          name: "CL_STATUS",
          desc: "Contain the current status of the corresponding cache line                [0]: valid, [1]: dirty, [2]: cmpt",
        }
      ]
    },
    { name:     "TAG_1373",
      desc:     "Tag Address stored in cache line 1373",
      swaccess: "rw",
      hwaccess: "hrw",
      hwext:    "true",
      hwqe:     "true", // enable `qe` latched signal of software write pulse
      hwre:     "true",
      fields: [
        { bits: "5-1:0",
          name: "CL_TAG",
          desc: "Tag Address"
        }
      ]
    },
    {
      name:     "STATUS_1374",
      desc:     "Status register of cache line 1374",
      swaccess: "rw",
      hwaccess: "hrw",
      hwext:    "true",
      hwqe:     "true", // enable `qe` latched signal of software write pulse
      hwre:     "true",
      fields: [
        {
          bits: "5+3:5", // 2 bits for status
          name: "CL_STATUS",
          desc: "Contain the current status of the corresponding cache line                [0]: valid, [1]: dirty, [2]: cmpt",
        }
      ]
    },
    { name:     "TAG_1374",
      desc:     "Tag Address stored in cache line 1374",
      swaccess: "rw",
      hwaccess: "hrw",
      hwext:    "true",
      hwqe:     "true", // enable `qe` latched signal of software write pulse
      hwre:     "true",
      fields: [
        { bits: "5-1:0",
          name: "CL_TAG",
          desc: "Tag Address"
        }
      ]
    },
    {
      name:     "STATUS_1375",
      desc:     "Status register of cache line 1375",
      swaccess: "rw",
      hwaccess: "hrw",
      hwext:    "true",
      hwqe:     "true", // enable `qe` latched signal of software write pulse
      hwre:     "true",
      fields: [
        {
          bits: "5+3:5", // 2 bits for status
          name: "CL_STATUS",
          desc: "Contain the current status of the corresponding cache line                [0]: valid, [1]: dirty, [2]: cmpt",
        }
      ]
    },
    { name:     "TAG_1375",
      desc:     "Tag Address stored in cache line 1375",
      swaccess: "rw",
      hwaccess: "hrw",
      hwext:    "true",
      hwqe:     "true", // enable `qe` latched signal of software write pulse
      hwre:     "true",
      fields: [
        { bits: "5-1:0",
          name: "CL_TAG",
          desc: "Tag Address"
        }
      ]
    },
    {
      name:     "STATUS_1376",
      desc:     "Status register of cache line 1376",
      swaccess: "rw",
      hwaccess: "hrw",
      hwext:    "true",
      hwqe:     "true", // enable `qe` latched signal of software write pulse
      hwre:     "true",
      fields: [
        {
          bits: "5+3:5", // 2 bits for status
          name: "CL_STATUS",
          desc: "Contain the current status of the corresponding cache line                [0]: valid, [1]: dirty, [2]: cmpt",
        }
      ]
    },
    { name:     "TAG_1376",
      desc:     "Tag Address stored in cache line 1376",
      swaccess: "rw",
      hwaccess: "hrw",
      hwext:    "true",
      hwqe:     "true", // enable `qe` latched signal of software write pulse
      hwre:     "true",
      fields: [
        { bits: "5-1:0",
          name: "CL_TAG",
          desc: "Tag Address"
        }
      ]
    },
    {
      name:     "STATUS_1377",
      desc:     "Status register of cache line 1377",
      swaccess: "rw",
      hwaccess: "hrw",
      hwext:    "true",
      hwqe:     "true", // enable `qe` latched signal of software write pulse
      hwre:     "true",
      fields: [
        {
          bits: "5+3:5", // 2 bits for status
          name: "CL_STATUS",
          desc: "Contain the current status of the corresponding cache line                [0]: valid, [1]: dirty, [2]: cmpt",
        }
      ]
    },
    { name:     "TAG_1377",
      desc:     "Tag Address stored in cache line 1377",
      swaccess: "rw",
      hwaccess: "hrw",
      hwext:    "true",
      hwqe:     "true", // enable `qe` latched signal of software write pulse
      hwre:     "true",
      fields: [
        { bits: "5-1:0",
          name: "CL_TAG",
          desc: "Tag Address"
        }
      ]
    },
    {
      name:     "STATUS_1378",
      desc:     "Status register of cache line 1378",
      swaccess: "rw",
      hwaccess: "hrw",
      hwext:    "true",
      hwqe:     "true", // enable `qe` latched signal of software write pulse
      hwre:     "true",
      fields: [
        {
          bits: "5+3:5", // 2 bits for status
          name: "CL_STATUS",
          desc: "Contain the current status of the corresponding cache line                [0]: valid, [1]: dirty, [2]: cmpt",
        }
      ]
    },
    { name:     "TAG_1378",
      desc:     "Tag Address stored in cache line 1378",
      swaccess: "rw",
      hwaccess: "hrw",
      hwext:    "true",
      hwqe:     "true", // enable `qe` latched signal of software write pulse
      hwre:     "true",
      fields: [
        { bits: "5-1:0",
          name: "CL_TAG",
          desc: "Tag Address"
        }
      ]
    },
    {
      name:     "STATUS_1379",
      desc:     "Status register of cache line 1379",
      swaccess: "rw",
      hwaccess: "hrw",
      hwext:    "true",
      hwqe:     "true", // enable `qe` latched signal of software write pulse
      hwre:     "true",
      fields: [
        {
          bits: "5+3:5", // 2 bits for status
          name: "CL_STATUS",
          desc: "Contain the current status of the corresponding cache line                [0]: valid, [1]: dirty, [2]: cmpt",
        }
      ]
    },
    { name:     "TAG_1379",
      desc:     "Tag Address stored in cache line 1379",
      swaccess: "rw",
      hwaccess: "hrw",
      hwext:    "true",
      hwqe:     "true", // enable `qe` latched signal of software write pulse
      hwre:     "true",
      fields: [
        { bits: "5-1:0",
          name: "CL_TAG",
          desc: "Tag Address"
        }
      ]
    },
    {
      name:     "STATUS_1380",
      desc:     "Status register of cache line 1380",
      swaccess: "rw",
      hwaccess: "hrw",
      hwext:    "true",
      hwqe:     "true", // enable `qe` latched signal of software write pulse
      hwre:     "true",
      fields: [
        {
          bits: "5+3:5", // 2 bits for status
          name: "CL_STATUS",
          desc: "Contain the current status of the corresponding cache line                [0]: valid, [1]: dirty, [2]: cmpt",
        }
      ]
    },
    { name:     "TAG_1380",
      desc:     "Tag Address stored in cache line 1380",
      swaccess: "rw",
      hwaccess: "hrw",
      hwext:    "true",
      hwqe:     "true", // enable `qe` latched signal of software write pulse
      hwre:     "true",
      fields: [
        { bits: "5-1:0",
          name: "CL_TAG",
          desc: "Tag Address"
        }
      ]
    },
    {
      name:     "STATUS_1381",
      desc:     "Status register of cache line 1381",
      swaccess: "rw",
      hwaccess: "hrw",
      hwext:    "true",
      hwqe:     "true", // enable `qe` latched signal of software write pulse
      hwre:     "true",
      fields: [
        {
          bits: "5+3:5", // 2 bits for status
          name: "CL_STATUS",
          desc: "Contain the current status of the corresponding cache line                [0]: valid, [1]: dirty, [2]: cmpt",
        }
      ]
    },
    { name:     "TAG_1381",
      desc:     "Tag Address stored in cache line 1381",
      swaccess: "rw",
      hwaccess: "hrw",
      hwext:    "true",
      hwqe:     "true", // enable `qe` latched signal of software write pulse
      hwre:     "true",
      fields: [
        { bits: "5-1:0",
          name: "CL_TAG",
          desc: "Tag Address"
        }
      ]
    },
    {
      name:     "STATUS_1382",
      desc:     "Status register of cache line 1382",
      swaccess: "rw",
      hwaccess: "hrw",
      hwext:    "true",
      hwqe:     "true", // enable `qe` latched signal of software write pulse
      hwre:     "true",
      fields: [
        {
          bits: "5+3:5", // 2 bits for status
          name: "CL_STATUS",
          desc: "Contain the current status of the corresponding cache line                [0]: valid, [1]: dirty, [2]: cmpt",
        }
      ]
    },
    { name:     "TAG_1382",
      desc:     "Tag Address stored in cache line 1382",
      swaccess: "rw",
      hwaccess: "hrw",
      hwext:    "true",
      hwqe:     "true", // enable `qe` latched signal of software write pulse
      hwre:     "true",
      fields: [
        { bits: "5-1:0",
          name: "CL_TAG",
          desc: "Tag Address"
        }
      ]
    },
    {
      name:     "STATUS_1383",
      desc:     "Status register of cache line 1383",
      swaccess: "rw",
      hwaccess: "hrw",
      hwext:    "true",
      hwqe:     "true", // enable `qe` latched signal of software write pulse
      hwre:     "true",
      fields: [
        {
          bits: "5+3:5", // 2 bits for status
          name: "CL_STATUS",
          desc: "Contain the current status of the corresponding cache line                [0]: valid, [1]: dirty, [2]: cmpt",
        }
      ]
    },
    { name:     "TAG_1383",
      desc:     "Tag Address stored in cache line 1383",
      swaccess: "rw",
      hwaccess: "hrw",
      hwext:    "true",
      hwqe:     "true", // enable `qe` latched signal of software write pulse
      hwre:     "true",
      fields: [
        { bits: "5-1:0",
          name: "CL_TAG",
          desc: "Tag Address"
        }
      ]
    },
    {
      name:     "STATUS_1384",
      desc:     "Status register of cache line 1384",
      swaccess: "rw",
      hwaccess: "hrw",
      hwext:    "true",
      hwqe:     "true", // enable `qe` latched signal of software write pulse
      hwre:     "true",
      fields: [
        {
          bits: "5+3:5", // 2 bits for status
          name: "CL_STATUS",
          desc: "Contain the current status of the corresponding cache line                [0]: valid, [1]: dirty, [2]: cmpt",
        }
      ]
    },
    { name:     "TAG_1384",
      desc:     "Tag Address stored in cache line 1384",
      swaccess: "rw",
      hwaccess: "hrw",
      hwext:    "true",
      hwqe:     "true", // enable `qe` latched signal of software write pulse
      hwre:     "true",
      fields: [
        { bits: "5-1:0",
          name: "CL_TAG",
          desc: "Tag Address"
        }
      ]
    },
    {
      name:     "STATUS_1385",
      desc:     "Status register of cache line 1385",
      swaccess: "rw",
      hwaccess: "hrw",
      hwext:    "true",
      hwqe:     "true", // enable `qe` latched signal of software write pulse
      hwre:     "true",
      fields: [
        {
          bits: "5+3:5", // 2 bits for status
          name: "CL_STATUS",
          desc: "Contain the current status of the corresponding cache line                [0]: valid, [1]: dirty, [2]: cmpt",
        }
      ]
    },
    { name:     "TAG_1385",
      desc:     "Tag Address stored in cache line 1385",
      swaccess: "rw",
      hwaccess: "hrw",
      hwext:    "true",
      hwqe:     "true", // enable `qe` latched signal of software write pulse
      hwre:     "true",
      fields: [
        { bits: "5-1:0",
          name: "CL_TAG",
          desc: "Tag Address"
        }
      ]
    },
    {
      name:     "STATUS_1386",
      desc:     "Status register of cache line 1386",
      swaccess: "rw",
      hwaccess: "hrw",
      hwext:    "true",
      hwqe:     "true", // enable `qe` latched signal of software write pulse
      hwre:     "true",
      fields: [
        {
          bits: "5+3:5", // 2 bits for status
          name: "CL_STATUS",
          desc: "Contain the current status of the corresponding cache line                [0]: valid, [1]: dirty, [2]: cmpt",
        }
      ]
    },
    { name:     "TAG_1386",
      desc:     "Tag Address stored in cache line 1386",
      swaccess: "rw",
      hwaccess: "hrw",
      hwext:    "true",
      hwqe:     "true", // enable `qe` latched signal of software write pulse
      hwre:     "true",
      fields: [
        { bits: "5-1:0",
          name: "CL_TAG",
          desc: "Tag Address"
        }
      ]
    },
    {
      name:     "STATUS_1387",
      desc:     "Status register of cache line 1387",
      swaccess: "rw",
      hwaccess: "hrw",
      hwext:    "true",
      hwqe:     "true", // enable `qe` latched signal of software write pulse
      hwre:     "true",
      fields: [
        {
          bits: "5+3:5", // 2 bits for status
          name: "CL_STATUS",
          desc: "Contain the current status of the corresponding cache line                [0]: valid, [1]: dirty, [2]: cmpt",
        }
      ]
    },
    { name:     "TAG_1387",
      desc:     "Tag Address stored in cache line 1387",
      swaccess: "rw",
      hwaccess: "hrw",
      hwext:    "true",
      hwqe:     "true", // enable `qe` latched signal of software write pulse
      hwre:     "true",
      fields: [
        { bits: "5-1:0",
          name: "CL_TAG",
          desc: "Tag Address"
        }
      ]
    },
    {
      name:     "STATUS_1388",
      desc:     "Status register of cache line 1388",
      swaccess: "rw",
      hwaccess: "hrw",
      hwext:    "true",
      hwqe:     "true", // enable `qe` latched signal of software write pulse
      hwre:     "true",
      fields: [
        {
          bits: "5+3:5", // 2 bits for status
          name: "CL_STATUS",
          desc: "Contain the current status of the corresponding cache line                [0]: valid, [1]: dirty, [2]: cmpt",
        }
      ]
    },
    { name:     "TAG_1388",
      desc:     "Tag Address stored in cache line 1388",
      swaccess: "rw",
      hwaccess: "hrw",
      hwext:    "true",
      hwqe:     "true", // enable `qe` latched signal of software write pulse
      hwre:     "true",
      fields: [
        { bits: "5-1:0",
          name: "CL_TAG",
          desc: "Tag Address"
        }
      ]
    },
    {
      name:     "STATUS_1389",
      desc:     "Status register of cache line 1389",
      swaccess: "rw",
      hwaccess: "hrw",
      hwext:    "true",
      hwqe:     "true", // enable `qe` latched signal of software write pulse
      hwre:     "true",
      fields: [
        {
          bits: "5+3:5", // 2 bits for status
          name: "CL_STATUS",
          desc: "Contain the current status of the corresponding cache line                [0]: valid, [1]: dirty, [2]: cmpt",
        }
      ]
    },
    { name:     "TAG_1389",
      desc:     "Tag Address stored in cache line 1389",
      swaccess: "rw",
      hwaccess: "hrw",
      hwext:    "true",
      hwqe:     "true", // enable `qe` latched signal of software write pulse
      hwre:     "true",
      fields: [
        { bits: "5-1:0",
          name: "CL_TAG",
          desc: "Tag Address"
        }
      ]
    },
    {
      name:     "STATUS_1390",
      desc:     "Status register of cache line 1390",
      swaccess: "rw",
      hwaccess: "hrw",
      hwext:    "true",
      hwqe:     "true", // enable `qe` latched signal of software write pulse
      hwre:     "true",
      fields: [
        {
          bits: "5+3:5", // 2 bits for status
          name: "CL_STATUS",
          desc: "Contain the current status of the corresponding cache line                [0]: valid, [1]: dirty, [2]: cmpt",
        }
      ]
    },
    { name:     "TAG_1390",
      desc:     "Tag Address stored in cache line 1390",
      swaccess: "rw",
      hwaccess: "hrw",
      hwext:    "true",
      hwqe:     "true", // enable `qe` latched signal of software write pulse
      hwre:     "true",
      fields: [
        { bits: "5-1:0",
          name: "CL_TAG",
          desc: "Tag Address"
        }
      ]
    },
    {
      name:     "STATUS_1391",
      desc:     "Status register of cache line 1391",
      swaccess: "rw",
      hwaccess: "hrw",
      hwext:    "true",
      hwqe:     "true", // enable `qe` latched signal of software write pulse
      hwre:     "true",
      fields: [
        {
          bits: "5+3:5", // 2 bits for status
          name: "CL_STATUS",
          desc: "Contain the current status of the corresponding cache line                [0]: valid, [1]: dirty, [2]: cmpt",
        }
      ]
    },
    { name:     "TAG_1391",
      desc:     "Tag Address stored in cache line 1391",
      swaccess: "rw",
      hwaccess: "hrw",
      hwext:    "true",
      hwqe:     "true", // enable `qe` latched signal of software write pulse
      hwre:     "true",
      fields: [
        { bits: "5-1:0",
          name: "CL_TAG",
          desc: "Tag Address"
        }
      ]
    },
    {
      name:     "STATUS_1392",
      desc:     "Status register of cache line 1392",
      swaccess: "rw",
      hwaccess: "hrw",
      hwext:    "true",
      hwqe:     "true", // enable `qe` latched signal of software write pulse
      hwre:     "true",
      fields: [
        {
          bits: "5+3:5", // 2 bits for status
          name: "CL_STATUS",
          desc: "Contain the current status of the corresponding cache line                [0]: valid, [1]: dirty, [2]: cmpt",
        }
      ]
    },
    { name:     "TAG_1392",
      desc:     "Tag Address stored in cache line 1392",
      swaccess: "rw",
      hwaccess: "hrw",
      hwext:    "true",
      hwqe:     "true", // enable `qe` latched signal of software write pulse
      hwre:     "true",
      fields: [
        { bits: "5-1:0",
          name: "CL_TAG",
          desc: "Tag Address"
        }
      ]
    },
    {
      name:     "STATUS_1393",
      desc:     "Status register of cache line 1393",
      swaccess: "rw",
      hwaccess: "hrw",
      hwext:    "true",
      hwqe:     "true", // enable `qe` latched signal of software write pulse
      hwre:     "true",
      fields: [
        {
          bits: "5+3:5", // 2 bits for status
          name: "CL_STATUS",
          desc: "Contain the current status of the corresponding cache line                [0]: valid, [1]: dirty, [2]: cmpt",
        }
      ]
    },
    { name:     "TAG_1393",
      desc:     "Tag Address stored in cache line 1393",
      swaccess: "rw",
      hwaccess: "hrw",
      hwext:    "true",
      hwqe:     "true", // enable `qe` latched signal of software write pulse
      hwre:     "true",
      fields: [
        { bits: "5-1:0",
          name: "CL_TAG",
          desc: "Tag Address"
        }
      ]
    },
    {
      name:     "STATUS_1394",
      desc:     "Status register of cache line 1394",
      swaccess: "rw",
      hwaccess: "hrw",
      hwext:    "true",
      hwqe:     "true", // enable `qe` latched signal of software write pulse
      hwre:     "true",
      fields: [
        {
          bits: "5+3:5", // 2 bits for status
          name: "CL_STATUS",
          desc: "Contain the current status of the corresponding cache line                [0]: valid, [1]: dirty, [2]: cmpt",
        }
      ]
    },
    { name:     "TAG_1394",
      desc:     "Tag Address stored in cache line 1394",
      swaccess: "rw",
      hwaccess: "hrw",
      hwext:    "true",
      hwqe:     "true", // enable `qe` latched signal of software write pulse
      hwre:     "true",
      fields: [
        { bits: "5-1:0",
          name: "CL_TAG",
          desc: "Tag Address"
        }
      ]
    },
    {
      name:     "STATUS_1395",
      desc:     "Status register of cache line 1395",
      swaccess: "rw",
      hwaccess: "hrw",
      hwext:    "true",
      hwqe:     "true", // enable `qe` latched signal of software write pulse
      hwre:     "true",
      fields: [
        {
          bits: "5+3:5", // 2 bits for status
          name: "CL_STATUS",
          desc: "Contain the current status of the corresponding cache line                [0]: valid, [1]: dirty, [2]: cmpt",
        }
      ]
    },
    { name:     "TAG_1395",
      desc:     "Tag Address stored in cache line 1395",
      swaccess: "rw",
      hwaccess: "hrw",
      hwext:    "true",
      hwqe:     "true", // enable `qe` latched signal of software write pulse
      hwre:     "true",
      fields: [
        { bits: "5-1:0",
          name: "CL_TAG",
          desc: "Tag Address"
        }
      ]
    },
    {
      name:     "STATUS_1396",
      desc:     "Status register of cache line 1396",
      swaccess: "rw",
      hwaccess: "hrw",
      hwext:    "true",
      hwqe:     "true", // enable `qe` latched signal of software write pulse
      hwre:     "true",
      fields: [
        {
          bits: "5+3:5", // 2 bits for status
          name: "CL_STATUS",
          desc: "Contain the current status of the corresponding cache line                [0]: valid, [1]: dirty, [2]: cmpt",
        }
      ]
    },
    { name:     "TAG_1396",
      desc:     "Tag Address stored in cache line 1396",
      swaccess: "rw",
      hwaccess: "hrw",
      hwext:    "true",
      hwqe:     "true", // enable `qe` latched signal of software write pulse
      hwre:     "true",
      fields: [
        { bits: "5-1:0",
          name: "CL_TAG",
          desc: "Tag Address"
        }
      ]
    },
    {
      name:     "STATUS_1397",
      desc:     "Status register of cache line 1397",
      swaccess: "rw",
      hwaccess: "hrw",
      hwext:    "true",
      hwqe:     "true", // enable `qe` latched signal of software write pulse
      hwre:     "true",
      fields: [
        {
          bits: "5+3:5", // 2 bits for status
          name: "CL_STATUS",
          desc: "Contain the current status of the corresponding cache line                [0]: valid, [1]: dirty, [2]: cmpt",
        }
      ]
    },
    { name:     "TAG_1397",
      desc:     "Tag Address stored in cache line 1397",
      swaccess: "rw",
      hwaccess: "hrw",
      hwext:    "true",
      hwqe:     "true", // enable `qe` latched signal of software write pulse
      hwre:     "true",
      fields: [
        { bits: "5-1:0",
          name: "CL_TAG",
          desc: "Tag Address"
        }
      ]
    },
    {
      name:     "STATUS_1398",
      desc:     "Status register of cache line 1398",
      swaccess: "rw",
      hwaccess: "hrw",
      hwext:    "true",
      hwqe:     "true", // enable `qe` latched signal of software write pulse
      hwre:     "true",
      fields: [
        {
          bits: "5+3:5", // 2 bits for status
          name: "CL_STATUS",
          desc: "Contain the current status of the corresponding cache line                [0]: valid, [1]: dirty, [2]: cmpt",
        }
      ]
    },
    { name:     "TAG_1398",
      desc:     "Tag Address stored in cache line 1398",
      swaccess: "rw",
      hwaccess: "hrw",
      hwext:    "true",
      hwqe:     "true", // enable `qe` latched signal of software write pulse
      hwre:     "true",
      fields: [
        { bits: "5-1:0",
          name: "CL_TAG",
          desc: "Tag Address"
        }
      ]
    },
    {
      name:     "STATUS_1399",
      desc:     "Status register of cache line 1399",
      swaccess: "rw",
      hwaccess: "hrw",
      hwext:    "true",
      hwqe:     "true", // enable `qe` latched signal of software write pulse
      hwre:     "true",
      fields: [
        {
          bits: "5+3:5", // 2 bits for status
          name: "CL_STATUS",
          desc: "Contain the current status of the corresponding cache line                [0]: valid, [1]: dirty, [2]: cmpt",
        }
      ]
    },
    { name:     "TAG_1399",
      desc:     "Tag Address stored in cache line 1399",
      swaccess: "rw",
      hwaccess: "hrw",
      hwext:    "true",
      hwqe:     "true", // enable `qe` latched signal of software write pulse
      hwre:     "true",
      fields: [
        { bits: "5-1:0",
          name: "CL_TAG",
          desc: "Tag Address"
        }
      ]
    },
    {
      name:     "STATUS_1400",
      desc:     "Status register of cache line 1400",
      swaccess: "rw",
      hwaccess: "hrw",
      hwext:    "true",
      hwqe:     "true", // enable `qe` latched signal of software write pulse
      hwre:     "true",
      fields: [
        {
          bits: "5+3:5", // 2 bits for status
          name: "CL_STATUS",
          desc: "Contain the current status of the corresponding cache line                [0]: valid, [1]: dirty, [2]: cmpt",
        }
      ]
    },
    { name:     "TAG_1400",
      desc:     "Tag Address stored in cache line 1400",
      swaccess: "rw",
      hwaccess: "hrw",
      hwext:    "true",
      hwqe:     "true", // enable `qe` latched signal of software write pulse
      hwre:     "true",
      fields: [
        { bits: "5-1:0",
          name: "CL_TAG",
          desc: "Tag Address"
        }
      ]
    },
    {
      name:     "STATUS_1401",
      desc:     "Status register of cache line 1401",
      swaccess: "rw",
      hwaccess: "hrw",
      hwext:    "true",
      hwqe:     "true", // enable `qe` latched signal of software write pulse
      hwre:     "true",
      fields: [
        {
          bits: "5+3:5", // 2 bits for status
          name: "CL_STATUS",
          desc: "Contain the current status of the corresponding cache line                [0]: valid, [1]: dirty, [2]: cmpt",
        }
      ]
    },
    { name:     "TAG_1401",
      desc:     "Tag Address stored in cache line 1401",
      swaccess: "rw",
      hwaccess: "hrw",
      hwext:    "true",
      hwqe:     "true", // enable `qe` latched signal of software write pulse
      hwre:     "true",
      fields: [
        { bits: "5-1:0",
          name: "CL_TAG",
          desc: "Tag Address"
        }
      ]
    },
    {
      name:     "STATUS_1402",
      desc:     "Status register of cache line 1402",
      swaccess: "rw",
      hwaccess: "hrw",
      hwext:    "true",
      hwqe:     "true", // enable `qe` latched signal of software write pulse
      hwre:     "true",
      fields: [
        {
          bits: "5+3:5", // 2 bits for status
          name: "CL_STATUS",
          desc: "Contain the current status of the corresponding cache line                [0]: valid, [1]: dirty, [2]: cmpt",
        }
      ]
    },
    { name:     "TAG_1402",
      desc:     "Tag Address stored in cache line 1402",
      swaccess: "rw",
      hwaccess: "hrw",
      hwext:    "true",
      hwqe:     "true", // enable `qe` latched signal of software write pulse
      hwre:     "true",
      fields: [
        { bits: "5-1:0",
          name: "CL_TAG",
          desc: "Tag Address"
        }
      ]
    },
    {
      name:     "STATUS_1403",
      desc:     "Status register of cache line 1403",
      swaccess: "rw",
      hwaccess: "hrw",
      hwext:    "true",
      hwqe:     "true", // enable `qe` latched signal of software write pulse
      hwre:     "true",
      fields: [
        {
          bits: "5+3:5", // 2 bits for status
          name: "CL_STATUS",
          desc: "Contain the current status of the corresponding cache line                [0]: valid, [1]: dirty, [2]: cmpt",
        }
      ]
    },
    { name:     "TAG_1403",
      desc:     "Tag Address stored in cache line 1403",
      swaccess: "rw",
      hwaccess: "hrw",
      hwext:    "true",
      hwqe:     "true", // enable `qe` latched signal of software write pulse
      hwre:     "true",
      fields: [
        { bits: "5-1:0",
          name: "CL_TAG",
          desc: "Tag Address"
        }
      ]
    },
    {
      name:     "STATUS_1404",
      desc:     "Status register of cache line 1404",
      swaccess: "rw",
      hwaccess: "hrw",
      hwext:    "true",
      hwqe:     "true", // enable `qe` latched signal of software write pulse
      hwre:     "true",
      fields: [
        {
          bits: "5+3:5", // 2 bits for status
          name: "CL_STATUS",
          desc: "Contain the current status of the corresponding cache line                [0]: valid, [1]: dirty, [2]: cmpt",
        }
      ]
    },
    { name:     "TAG_1404",
      desc:     "Tag Address stored in cache line 1404",
      swaccess: "rw",
      hwaccess: "hrw",
      hwext:    "true",
      hwqe:     "true", // enable `qe` latched signal of software write pulse
      hwre:     "true",
      fields: [
        { bits: "5-1:0",
          name: "CL_TAG",
          desc: "Tag Address"
        }
      ]
    },
    {
      name:     "STATUS_1405",
      desc:     "Status register of cache line 1405",
      swaccess: "rw",
      hwaccess: "hrw",
      hwext:    "true",
      hwqe:     "true", // enable `qe` latched signal of software write pulse
      hwre:     "true",
      fields: [
        {
          bits: "5+3:5", // 2 bits for status
          name: "CL_STATUS",
          desc: "Contain the current status of the corresponding cache line                [0]: valid, [1]: dirty, [2]: cmpt",
        }
      ]
    },
    { name:     "TAG_1405",
      desc:     "Tag Address stored in cache line 1405",
      swaccess: "rw",
      hwaccess: "hrw",
      hwext:    "true",
      hwqe:     "true", // enable `qe` latched signal of software write pulse
      hwre:     "true",
      fields: [
        { bits: "5-1:0",
          name: "CL_TAG",
          desc: "Tag Address"
        }
      ]
    },
    {
      name:     "STATUS_1406",
      desc:     "Status register of cache line 1406",
      swaccess: "rw",
      hwaccess: "hrw",
      hwext:    "true",
      hwqe:     "true", // enable `qe` latched signal of software write pulse
      hwre:     "true",
      fields: [
        {
          bits: "5+3:5", // 2 bits for status
          name: "CL_STATUS",
          desc: "Contain the current status of the corresponding cache line                [0]: valid, [1]: dirty, [2]: cmpt",
        }
      ]
    },
    { name:     "TAG_1406",
      desc:     "Tag Address stored in cache line 1406",
      swaccess: "rw",
      hwaccess: "hrw",
      hwext:    "true",
      hwqe:     "true", // enable `qe` latched signal of software write pulse
      hwre:     "true",
      fields: [
        { bits: "5-1:0",
          name: "CL_TAG",
          desc: "Tag Address"
        }
      ]
    },
    {
      name:     "STATUS_1407",
      desc:     "Status register of cache line 1407",
      swaccess: "rw",
      hwaccess: "hrw",
      hwext:    "true",
      hwqe:     "true", // enable `qe` latched signal of software write pulse
      hwre:     "true",
      fields: [
        {
          bits: "5+3:5", // 2 bits for status
          name: "CL_STATUS",
          desc: "Contain the current status of the corresponding cache line                [0]: valid, [1]: dirty, [2]: cmpt",
        }
      ]
    },
    { name:     "TAG_1407",
      desc:     "Tag Address stored in cache line 1407",
      swaccess: "rw",
      hwaccess: "hrw",
      hwext:    "true",
      hwqe:     "true", // enable `qe` latched signal of software write pulse
      hwre:     "true",
      fields: [
        { bits: "5-1:0",
          name: "CL_TAG",
          desc: "Tag Address"
        }
      ]
    },
    {
      name:     "STATUS_1408",
      desc:     "Status register of cache line 1408",
      swaccess: "rw",
      hwaccess: "hrw",
      hwext:    "true",
      hwqe:     "true", // enable `qe` latched signal of software write pulse
      hwre:     "true",
      fields: [
        {
          bits: "5+3:5", // 2 bits for status
          name: "CL_STATUS",
          desc: "Contain the current status of the corresponding cache line                [0]: valid, [1]: dirty, [2]: cmpt",
        }
      ]
    },
    { name:     "TAG_1408",
      desc:     "Tag Address stored in cache line 1408",
      swaccess: "rw",
      hwaccess: "hrw",
      hwext:    "true",
      hwqe:     "true", // enable `qe` latched signal of software write pulse
      hwre:     "true",
      fields: [
        { bits: "5-1:0",
          name: "CL_TAG",
          desc: "Tag Address"
        }
      ]
    },
    {
      name:     "STATUS_1409",
      desc:     "Status register of cache line 1409",
      swaccess: "rw",
      hwaccess: "hrw",
      hwext:    "true",
      hwqe:     "true", // enable `qe` latched signal of software write pulse
      hwre:     "true",
      fields: [
        {
          bits: "5+3:5", // 2 bits for status
          name: "CL_STATUS",
          desc: "Contain the current status of the corresponding cache line                [0]: valid, [1]: dirty, [2]: cmpt",
        }
      ]
    },
    { name:     "TAG_1409",
      desc:     "Tag Address stored in cache line 1409",
      swaccess: "rw",
      hwaccess: "hrw",
      hwext:    "true",
      hwqe:     "true", // enable `qe` latched signal of software write pulse
      hwre:     "true",
      fields: [
        { bits: "5-1:0",
          name: "CL_TAG",
          desc: "Tag Address"
        }
      ]
    },
    {
      name:     "STATUS_1410",
      desc:     "Status register of cache line 1410",
      swaccess: "rw",
      hwaccess: "hrw",
      hwext:    "true",
      hwqe:     "true", // enable `qe` latched signal of software write pulse
      hwre:     "true",
      fields: [
        {
          bits: "5+3:5", // 2 bits for status
          name: "CL_STATUS",
          desc: "Contain the current status of the corresponding cache line                [0]: valid, [1]: dirty, [2]: cmpt",
        }
      ]
    },
    { name:     "TAG_1410",
      desc:     "Tag Address stored in cache line 1410",
      swaccess: "rw",
      hwaccess: "hrw",
      hwext:    "true",
      hwqe:     "true", // enable `qe` latched signal of software write pulse
      hwre:     "true",
      fields: [
        { bits: "5-1:0",
          name: "CL_TAG",
          desc: "Tag Address"
        }
      ]
    },
    {
      name:     "STATUS_1411",
      desc:     "Status register of cache line 1411",
      swaccess: "rw",
      hwaccess: "hrw",
      hwext:    "true",
      hwqe:     "true", // enable `qe` latched signal of software write pulse
      hwre:     "true",
      fields: [
        {
          bits: "5+3:5", // 2 bits for status
          name: "CL_STATUS",
          desc: "Contain the current status of the corresponding cache line                [0]: valid, [1]: dirty, [2]: cmpt",
        }
      ]
    },
    { name:     "TAG_1411",
      desc:     "Tag Address stored in cache line 1411",
      swaccess: "rw",
      hwaccess: "hrw",
      hwext:    "true",
      hwqe:     "true", // enable `qe` latched signal of software write pulse
      hwre:     "true",
      fields: [
        { bits: "5-1:0",
          name: "CL_TAG",
          desc: "Tag Address"
        }
      ]
    },
    {
      name:     "STATUS_1412",
      desc:     "Status register of cache line 1412",
      swaccess: "rw",
      hwaccess: "hrw",
      hwext:    "true",
      hwqe:     "true", // enable `qe` latched signal of software write pulse
      hwre:     "true",
      fields: [
        {
          bits: "5+3:5", // 2 bits for status
          name: "CL_STATUS",
          desc: "Contain the current status of the corresponding cache line                [0]: valid, [1]: dirty, [2]: cmpt",
        }
      ]
    },
    { name:     "TAG_1412",
      desc:     "Tag Address stored in cache line 1412",
      swaccess: "rw",
      hwaccess: "hrw",
      hwext:    "true",
      hwqe:     "true", // enable `qe` latched signal of software write pulse
      hwre:     "true",
      fields: [
        { bits: "5-1:0",
          name: "CL_TAG",
          desc: "Tag Address"
        }
      ]
    },
    {
      name:     "STATUS_1413",
      desc:     "Status register of cache line 1413",
      swaccess: "rw",
      hwaccess: "hrw",
      hwext:    "true",
      hwqe:     "true", // enable `qe` latched signal of software write pulse
      hwre:     "true",
      fields: [
        {
          bits: "5+3:5", // 2 bits for status
          name: "CL_STATUS",
          desc: "Contain the current status of the corresponding cache line                [0]: valid, [1]: dirty, [2]: cmpt",
        }
      ]
    },
    { name:     "TAG_1413",
      desc:     "Tag Address stored in cache line 1413",
      swaccess: "rw",
      hwaccess: "hrw",
      hwext:    "true",
      hwqe:     "true", // enable `qe` latched signal of software write pulse
      hwre:     "true",
      fields: [
        { bits: "5-1:0",
          name: "CL_TAG",
          desc: "Tag Address"
        }
      ]
    },
    {
      name:     "STATUS_1414",
      desc:     "Status register of cache line 1414",
      swaccess: "rw",
      hwaccess: "hrw",
      hwext:    "true",
      hwqe:     "true", // enable `qe` latched signal of software write pulse
      hwre:     "true",
      fields: [
        {
          bits: "5+3:5", // 2 bits for status
          name: "CL_STATUS",
          desc: "Contain the current status of the corresponding cache line                [0]: valid, [1]: dirty, [2]: cmpt",
        }
      ]
    },
    { name:     "TAG_1414",
      desc:     "Tag Address stored in cache line 1414",
      swaccess: "rw",
      hwaccess: "hrw",
      hwext:    "true",
      hwqe:     "true", // enable `qe` latched signal of software write pulse
      hwre:     "true",
      fields: [
        { bits: "5-1:0",
          name: "CL_TAG",
          desc: "Tag Address"
        }
      ]
    },
    {
      name:     "STATUS_1415",
      desc:     "Status register of cache line 1415",
      swaccess: "rw",
      hwaccess: "hrw",
      hwext:    "true",
      hwqe:     "true", // enable `qe` latched signal of software write pulse
      hwre:     "true",
      fields: [
        {
          bits: "5+3:5", // 2 bits for status
          name: "CL_STATUS",
          desc: "Contain the current status of the corresponding cache line                [0]: valid, [1]: dirty, [2]: cmpt",
        }
      ]
    },
    { name:     "TAG_1415",
      desc:     "Tag Address stored in cache line 1415",
      swaccess: "rw",
      hwaccess: "hrw",
      hwext:    "true",
      hwqe:     "true", // enable `qe` latched signal of software write pulse
      hwre:     "true",
      fields: [
        { bits: "5-1:0",
          name: "CL_TAG",
          desc: "Tag Address"
        }
      ]
    },
    {
      name:     "STATUS_1416",
      desc:     "Status register of cache line 1416",
      swaccess: "rw",
      hwaccess: "hrw",
      hwext:    "true",
      hwqe:     "true", // enable `qe` latched signal of software write pulse
      hwre:     "true",
      fields: [
        {
          bits: "5+3:5", // 2 bits for status
          name: "CL_STATUS",
          desc: "Contain the current status of the corresponding cache line                [0]: valid, [1]: dirty, [2]: cmpt",
        }
      ]
    },
    { name:     "TAG_1416",
      desc:     "Tag Address stored in cache line 1416",
      swaccess: "rw",
      hwaccess: "hrw",
      hwext:    "true",
      hwqe:     "true", // enable `qe` latched signal of software write pulse
      hwre:     "true",
      fields: [
        { bits: "5-1:0",
          name: "CL_TAG",
          desc: "Tag Address"
        }
      ]
    },
    {
      name:     "STATUS_1417",
      desc:     "Status register of cache line 1417",
      swaccess: "rw",
      hwaccess: "hrw",
      hwext:    "true",
      hwqe:     "true", // enable `qe` latched signal of software write pulse
      hwre:     "true",
      fields: [
        {
          bits: "5+3:5", // 2 bits for status
          name: "CL_STATUS",
          desc: "Contain the current status of the corresponding cache line                [0]: valid, [1]: dirty, [2]: cmpt",
        }
      ]
    },
    { name:     "TAG_1417",
      desc:     "Tag Address stored in cache line 1417",
      swaccess: "rw",
      hwaccess: "hrw",
      hwext:    "true",
      hwqe:     "true", // enable `qe` latched signal of software write pulse
      hwre:     "true",
      fields: [
        { bits: "5-1:0",
          name: "CL_TAG",
          desc: "Tag Address"
        }
      ]
    },
    {
      name:     "STATUS_1418",
      desc:     "Status register of cache line 1418",
      swaccess: "rw",
      hwaccess: "hrw",
      hwext:    "true",
      hwqe:     "true", // enable `qe` latched signal of software write pulse
      hwre:     "true",
      fields: [
        {
          bits: "5+3:5", // 2 bits for status
          name: "CL_STATUS",
          desc: "Contain the current status of the corresponding cache line                [0]: valid, [1]: dirty, [2]: cmpt",
        }
      ]
    },
    { name:     "TAG_1418",
      desc:     "Tag Address stored in cache line 1418",
      swaccess: "rw",
      hwaccess: "hrw",
      hwext:    "true",
      hwqe:     "true", // enable `qe` latched signal of software write pulse
      hwre:     "true",
      fields: [
        { bits: "5-1:0",
          name: "CL_TAG",
          desc: "Tag Address"
        }
      ]
    },
    {
      name:     "STATUS_1419",
      desc:     "Status register of cache line 1419",
      swaccess: "rw",
      hwaccess: "hrw",
      hwext:    "true",
      hwqe:     "true", // enable `qe` latched signal of software write pulse
      hwre:     "true",
      fields: [
        {
          bits: "5+3:5", // 2 bits for status
          name: "CL_STATUS",
          desc: "Contain the current status of the corresponding cache line                [0]: valid, [1]: dirty, [2]: cmpt",
        }
      ]
    },
    { name:     "TAG_1419",
      desc:     "Tag Address stored in cache line 1419",
      swaccess: "rw",
      hwaccess: "hrw",
      hwext:    "true",
      hwqe:     "true", // enable `qe` latched signal of software write pulse
      hwre:     "true",
      fields: [
        { bits: "5-1:0",
          name: "CL_TAG",
          desc: "Tag Address"
        }
      ]
    },
    {
      name:     "STATUS_1420",
      desc:     "Status register of cache line 1420",
      swaccess: "rw",
      hwaccess: "hrw",
      hwext:    "true",
      hwqe:     "true", // enable `qe` latched signal of software write pulse
      hwre:     "true",
      fields: [
        {
          bits: "5+3:5", // 2 bits for status
          name: "CL_STATUS",
          desc: "Contain the current status of the corresponding cache line                [0]: valid, [1]: dirty, [2]: cmpt",
        }
      ]
    },
    { name:     "TAG_1420",
      desc:     "Tag Address stored in cache line 1420",
      swaccess: "rw",
      hwaccess: "hrw",
      hwext:    "true",
      hwqe:     "true", // enable `qe` latched signal of software write pulse
      hwre:     "true",
      fields: [
        { bits: "5-1:0",
          name: "CL_TAG",
          desc: "Tag Address"
        }
      ]
    },
    {
      name:     "STATUS_1421",
      desc:     "Status register of cache line 1421",
      swaccess: "rw",
      hwaccess: "hrw",
      hwext:    "true",
      hwqe:     "true", // enable `qe` latched signal of software write pulse
      hwre:     "true",
      fields: [
        {
          bits: "5+3:5", // 2 bits for status
          name: "CL_STATUS",
          desc: "Contain the current status of the corresponding cache line                [0]: valid, [1]: dirty, [2]: cmpt",
        }
      ]
    },
    { name:     "TAG_1421",
      desc:     "Tag Address stored in cache line 1421",
      swaccess: "rw",
      hwaccess: "hrw",
      hwext:    "true",
      hwqe:     "true", // enable `qe` latched signal of software write pulse
      hwre:     "true",
      fields: [
        { bits: "5-1:0",
          name: "CL_TAG",
          desc: "Tag Address"
        }
      ]
    },
    {
      name:     "STATUS_1422",
      desc:     "Status register of cache line 1422",
      swaccess: "rw",
      hwaccess: "hrw",
      hwext:    "true",
      hwqe:     "true", // enable `qe` latched signal of software write pulse
      hwre:     "true",
      fields: [
        {
          bits: "5+3:5", // 2 bits for status
          name: "CL_STATUS",
          desc: "Contain the current status of the corresponding cache line                [0]: valid, [1]: dirty, [2]: cmpt",
        }
      ]
    },
    { name:     "TAG_1422",
      desc:     "Tag Address stored in cache line 1422",
      swaccess: "rw",
      hwaccess: "hrw",
      hwext:    "true",
      hwqe:     "true", // enable `qe` latched signal of software write pulse
      hwre:     "true",
      fields: [
        { bits: "5-1:0",
          name: "CL_TAG",
          desc: "Tag Address"
        }
      ]
    },
    {
      name:     "STATUS_1423",
      desc:     "Status register of cache line 1423",
      swaccess: "rw",
      hwaccess: "hrw",
      hwext:    "true",
      hwqe:     "true", // enable `qe` latched signal of software write pulse
      hwre:     "true",
      fields: [
        {
          bits: "5+3:5", // 2 bits for status
          name: "CL_STATUS",
          desc: "Contain the current status of the corresponding cache line                [0]: valid, [1]: dirty, [2]: cmpt",
        }
      ]
    },
    { name:     "TAG_1423",
      desc:     "Tag Address stored in cache line 1423",
      swaccess: "rw",
      hwaccess: "hrw",
      hwext:    "true",
      hwqe:     "true", // enable `qe` latched signal of software write pulse
      hwre:     "true",
      fields: [
        { bits: "5-1:0",
          name: "CL_TAG",
          desc: "Tag Address"
        }
      ]
    },
    {
      name:     "STATUS_1424",
      desc:     "Status register of cache line 1424",
      swaccess: "rw",
      hwaccess: "hrw",
      hwext:    "true",
      hwqe:     "true", // enable `qe` latched signal of software write pulse
      hwre:     "true",
      fields: [
        {
          bits: "5+3:5", // 2 bits for status
          name: "CL_STATUS",
          desc: "Contain the current status of the corresponding cache line                [0]: valid, [1]: dirty, [2]: cmpt",
        }
      ]
    },
    { name:     "TAG_1424",
      desc:     "Tag Address stored in cache line 1424",
      swaccess: "rw",
      hwaccess: "hrw",
      hwext:    "true",
      hwqe:     "true", // enable `qe` latched signal of software write pulse
      hwre:     "true",
      fields: [
        { bits: "5-1:0",
          name: "CL_TAG",
          desc: "Tag Address"
        }
      ]
    },
    {
      name:     "STATUS_1425",
      desc:     "Status register of cache line 1425",
      swaccess: "rw",
      hwaccess: "hrw",
      hwext:    "true",
      hwqe:     "true", // enable `qe` latched signal of software write pulse
      hwre:     "true",
      fields: [
        {
          bits: "5+3:5", // 2 bits for status
          name: "CL_STATUS",
          desc: "Contain the current status of the corresponding cache line                [0]: valid, [1]: dirty, [2]: cmpt",
        }
      ]
    },
    { name:     "TAG_1425",
      desc:     "Tag Address stored in cache line 1425",
      swaccess: "rw",
      hwaccess: "hrw",
      hwext:    "true",
      hwqe:     "true", // enable `qe` latched signal of software write pulse
      hwre:     "true",
      fields: [
        { bits: "5-1:0",
          name: "CL_TAG",
          desc: "Tag Address"
        }
      ]
    },
    {
      name:     "STATUS_1426",
      desc:     "Status register of cache line 1426",
      swaccess: "rw",
      hwaccess: "hrw",
      hwext:    "true",
      hwqe:     "true", // enable `qe` latched signal of software write pulse
      hwre:     "true",
      fields: [
        {
          bits: "5+3:5", // 2 bits for status
          name: "CL_STATUS",
          desc: "Contain the current status of the corresponding cache line                [0]: valid, [1]: dirty, [2]: cmpt",
        }
      ]
    },
    { name:     "TAG_1426",
      desc:     "Tag Address stored in cache line 1426",
      swaccess: "rw",
      hwaccess: "hrw",
      hwext:    "true",
      hwqe:     "true", // enable `qe` latched signal of software write pulse
      hwre:     "true",
      fields: [
        { bits: "5-1:0",
          name: "CL_TAG",
          desc: "Tag Address"
        }
      ]
    },
    {
      name:     "STATUS_1427",
      desc:     "Status register of cache line 1427",
      swaccess: "rw",
      hwaccess: "hrw",
      hwext:    "true",
      hwqe:     "true", // enable `qe` latched signal of software write pulse
      hwre:     "true",
      fields: [
        {
          bits: "5+3:5", // 2 bits for status
          name: "CL_STATUS",
          desc: "Contain the current status of the corresponding cache line                [0]: valid, [1]: dirty, [2]: cmpt",
        }
      ]
    },
    { name:     "TAG_1427",
      desc:     "Tag Address stored in cache line 1427",
      swaccess: "rw",
      hwaccess: "hrw",
      hwext:    "true",
      hwqe:     "true", // enable `qe` latched signal of software write pulse
      hwre:     "true",
      fields: [
        { bits: "5-1:0",
          name: "CL_TAG",
          desc: "Tag Address"
        }
      ]
    },
    {
      name:     "STATUS_1428",
      desc:     "Status register of cache line 1428",
      swaccess: "rw",
      hwaccess: "hrw",
      hwext:    "true",
      hwqe:     "true", // enable `qe` latched signal of software write pulse
      hwre:     "true",
      fields: [
        {
          bits: "5+3:5", // 2 bits for status
          name: "CL_STATUS",
          desc: "Contain the current status of the corresponding cache line                [0]: valid, [1]: dirty, [2]: cmpt",
        }
      ]
    },
    { name:     "TAG_1428",
      desc:     "Tag Address stored in cache line 1428",
      swaccess: "rw",
      hwaccess: "hrw",
      hwext:    "true",
      hwqe:     "true", // enable `qe` latched signal of software write pulse
      hwre:     "true",
      fields: [
        { bits: "5-1:0",
          name: "CL_TAG",
          desc: "Tag Address"
        }
      ]
    },
    {
      name:     "STATUS_1429",
      desc:     "Status register of cache line 1429",
      swaccess: "rw",
      hwaccess: "hrw",
      hwext:    "true",
      hwqe:     "true", // enable `qe` latched signal of software write pulse
      hwre:     "true",
      fields: [
        {
          bits: "5+3:5", // 2 bits for status
          name: "CL_STATUS",
          desc: "Contain the current status of the corresponding cache line                [0]: valid, [1]: dirty, [2]: cmpt",
        }
      ]
    },
    { name:     "TAG_1429",
      desc:     "Tag Address stored in cache line 1429",
      swaccess: "rw",
      hwaccess: "hrw",
      hwext:    "true",
      hwqe:     "true", // enable `qe` latched signal of software write pulse
      hwre:     "true",
      fields: [
        { bits: "5-1:0",
          name: "CL_TAG",
          desc: "Tag Address"
        }
      ]
    },
    {
      name:     "STATUS_1430",
      desc:     "Status register of cache line 1430",
      swaccess: "rw",
      hwaccess: "hrw",
      hwext:    "true",
      hwqe:     "true", // enable `qe` latched signal of software write pulse
      hwre:     "true",
      fields: [
        {
          bits: "5+3:5", // 2 bits for status
          name: "CL_STATUS",
          desc: "Contain the current status of the corresponding cache line                [0]: valid, [1]: dirty, [2]: cmpt",
        }
      ]
    },
    { name:     "TAG_1430",
      desc:     "Tag Address stored in cache line 1430",
      swaccess: "rw",
      hwaccess: "hrw",
      hwext:    "true",
      hwqe:     "true", // enable `qe` latched signal of software write pulse
      hwre:     "true",
      fields: [
        { bits: "5-1:0",
          name: "CL_TAG",
          desc: "Tag Address"
        }
      ]
    },
    {
      name:     "STATUS_1431",
      desc:     "Status register of cache line 1431",
      swaccess: "rw",
      hwaccess: "hrw",
      hwext:    "true",
      hwqe:     "true", // enable `qe` latched signal of software write pulse
      hwre:     "true",
      fields: [
        {
          bits: "5+3:5", // 2 bits for status
          name: "CL_STATUS",
          desc: "Contain the current status of the corresponding cache line                [0]: valid, [1]: dirty, [2]: cmpt",
        }
      ]
    },
    { name:     "TAG_1431",
      desc:     "Tag Address stored in cache line 1431",
      swaccess: "rw",
      hwaccess: "hrw",
      hwext:    "true",
      hwqe:     "true", // enable `qe` latched signal of software write pulse
      hwre:     "true",
      fields: [
        { bits: "5-1:0",
          name: "CL_TAG",
          desc: "Tag Address"
        }
      ]
    },
    {
      name:     "STATUS_1432",
      desc:     "Status register of cache line 1432",
      swaccess: "rw",
      hwaccess: "hrw",
      hwext:    "true",
      hwqe:     "true", // enable `qe` latched signal of software write pulse
      hwre:     "true",
      fields: [
        {
          bits: "5+3:5", // 2 bits for status
          name: "CL_STATUS",
          desc: "Contain the current status of the corresponding cache line                [0]: valid, [1]: dirty, [2]: cmpt",
        }
      ]
    },
    { name:     "TAG_1432",
      desc:     "Tag Address stored in cache line 1432",
      swaccess: "rw",
      hwaccess: "hrw",
      hwext:    "true",
      hwqe:     "true", // enable `qe` latched signal of software write pulse
      hwre:     "true",
      fields: [
        { bits: "5-1:0",
          name: "CL_TAG",
          desc: "Tag Address"
        }
      ]
    },
    {
      name:     "STATUS_1433",
      desc:     "Status register of cache line 1433",
      swaccess: "rw",
      hwaccess: "hrw",
      hwext:    "true",
      hwqe:     "true", // enable `qe` latched signal of software write pulse
      hwre:     "true",
      fields: [
        {
          bits: "5+3:5", // 2 bits for status
          name: "CL_STATUS",
          desc: "Contain the current status of the corresponding cache line                [0]: valid, [1]: dirty, [2]: cmpt",
        }
      ]
    },
    { name:     "TAG_1433",
      desc:     "Tag Address stored in cache line 1433",
      swaccess: "rw",
      hwaccess: "hrw",
      hwext:    "true",
      hwqe:     "true", // enable `qe` latched signal of software write pulse
      hwre:     "true",
      fields: [
        { bits: "5-1:0",
          name: "CL_TAG",
          desc: "Tag Address"
        }
      ]
    },
    {
      name:     "STATUS_1434",
      desc:     "Status register of cache line 1434",
      swaccess: "rw",
      hwaccess: "hrw",
      hwext:    "true",
      hwqe:     "true", // enable `qe` latched signal of software write pulse
      hwre:     "true",
      fields: [
        {
          bits: "5+3:5", // 2 bits for status
          name: "CL_STATUS",
          desc: "Contain the current status of the corresponding cache line                [0]: valid, [1]: dirty, [2]: cmpt",
        }
      ]
    },
    { name:     "TAG_1434",
      desc:     "Tag Address stored in cache line 1434",
      swaccess: "rw",
      hwaccess: "hrw",
      hwext:    "true",
      hwqe:     "true", // enable `qe` latched signal of software write pulse
      hwre:     "true",
      fields: [
        { bits: "5-1:0",
          name: "CL_TAG",
          desc: "Tag Address"
        }
      ]
    },
    {
      name:     "STATUS_1435",
      desc:     "Status register of cache line 1435",
      swaccess: "rw",
      hwaccess: "hrw",
      hwext:    "true",
      hwqe:     "true", // enable `qe` latched signal of software write pulse
      hwre:     "true",
      fields: [
        {
          bits: "5+3:5", // 2 bits for status
          name: "CL_STATUS",
          desc: "Contain the current status of the corresponding cache line                [0]: valid, [1]: dirty, [2]: cmpt",
        }
      ]
    },
    { name:     "TAG_1435",
      desc:     "Tag Address stored in cache line 1435",
      swaccess: "rw",
      hwaccess: "hrw",
      hwext:    "true",
      hwqe:     "true", // enable `qe` latched signal of software write pulse
      hwre:     "true",
      fields: [
        { bits: "5-1:0",
          name: "CL_TAG",
          desc: "Tag Address"
        }
      ]
    },
    {
      name:     "STATUS_1436",
      desc:     "Status register of cache line 1436",
      swaccess: "rw",
      hwaccess: "hrw",
      hwext:    "true",
      hwqe:     "true", // enable `qe` latched signal of software write pulse
      hwre:     "true",
      fields: [
        {
          bits: "5+3:5", // 2 bits for status
          name: "CL_STATUS",
          desc: "Contain the current status of the corresponding cache line                [0]: valid, [1]: dirty, [2]: cmpt",
        }
      ]
    },
    { name:     "TAG_1436",
      desc:     "Tag Address stored in cache line 1436",
      swaccess: "rw",
      hwaccess: "hrw",
      hwext:    "true",
      hwqe:     "true", // enable `qe` latched signal of software write pulse
      hwre:     "true",
      fields: [
        { bits: "5-1:0",
          name: "CL_TAG",
          desc: "Tag Address"
        }
      ]
    },
    {
      name:     "STATUS_1437",
      desc:     "Status register of cache line 1437",
      swaccess: "rw",
      hwaccess: "hrw",
      hwext:    "true",
      hwqe:     "true", // enable `qe` latched signal of software write pulse
      hwre:     "true",
      fields: [
        {
          bits: "5+3:5", // 2 bits for status
          name: "CL_STATUS",
          desc: "Contain the current status of the corresponding cache line                [0]: valid, [1]: dirty, [2]: cmpt",
        }
      ]
    },
    { name:     "TAG_1437",
      desc:     "Tag Address stored in cache line 1437",
      swaccess: "rw",
      hwaccess: "hrw",
      hwext:    "true",
      hwqe:     "true", // enable `qe` latched signal of software write pulse
      hwre:     "true",
      fields: [
        { bits: "5-1:0",
          name: "CL_TAG",
          desc: "Tag Address"
        }
      ]
    },
    {
      name:     "STATUS_1438",
      desc:     "Status register of cache line 1438",
      swaccess: "rw",
      hwaccess: "hrw",
      hwext:    "true",
      hwqe:     "true", // enable `qe` latched signal of software write pulse
      hwre:     "true",
      fields: [
        {
          bits: "5+3:5", // 2 bits for status
          name: "CL_STATUS",
          desc: "Contain the current status of the corresponding cache line                [0]: valid, [1]: dirty, [2]: cmpt",
        }
      ]
    },
    { name:     "TAG_1438",
      desc:     "Tag Address stored in cache line 1438",
      swaccess: "rw",
      hwaccess: "hrw",
      hwext:    "true",
      hwqe:     "true", // enable `qe` latched signal of software write pulse
      hwre:     "true",
      fields: [
        { bits: "5-1:0",
          name: "CL_TAG",
          desc: "Tag Address"
        }
      ]
    },
    {
      name:     "STATUS_1439",
      desc:     "Status register of cache line 1439",
      swaccess: "rw",
      hwaccess: "hrw",
      hwext:    "true",
      hwqe:     "true", // enable `qe` latched signal of software write pulse
      hwre:     "true",
      fields: [
        {
          bits: "5+3:5", // 2 bits for status
          name: "CL_STATUS",
          desc: "Contain the current status of the corresponding cache line                [0]: valid, [1]: dirty, [2]: cmpt",
        }
      ]
    },
    { name:     "TAG_1439",
      desc:     "Tag Address stored in cache line 1439",
      swaccess: "rw",
      hwaccess: "hrw",
      hwext:    "true",
      hwqe:     "true", // enable `qe` latched signal of software write pulse
      hwre:     "true",
      fields: [
        { bits: "5-1:0",
          name: "CL_TAG",
          desc: "Tag Address"
        }
      ]
    },
    {
      name:     "STATUS_1440",
      desc:     "Status register of cache line 1440",
      swaccess: "rw",
      hwaccess: "hrw",
      hwext:    "true",
      hwqe:     "true", // enable `qe` latched signal of software write pulse
      hwre:     "true",
      fields: [
        {
          bits: "5+3:5", // 2 bits for status
          name: "CL_STATUS",
          desc: "Contain the current status of the corresponding cache line                [0]: valid, [1]: dirty, [2]: cmpt",
        }
      ]
    },
    { name:     "TAG_1440",
      desc:     "Tag Address stored in cache line 1440",
      swaccess: "rw",
      hwaccess: "hrw",
      hwext:    "true",
      hwqe:     "true", // enable `qe` latched signal of software write pulse
      hwre:     "true",
      fields: [
        { bits: "5-1:0",
          name: "CL_TAG",
          desc: "Tag Address"
        }
      ]
    },
    {
      name:     "STATUS_1441",
      desc:     "Status register of cache line 1441",
      swaccess: "rw",
      hwaccess: "hrw",
      hwext:    "true",
      hwqe:     "true", // enable `qe` latched signal of software write pulse
      hwre:     "true",
      fields: [
        {
          bits: "5+3:5", // 2 bits for status
          name: "CL_STATUS",
          desc: "Contain the current status of the corresponding cache line                [0]: valid, [1]: dirty, [2]: cmpt",
        }
      ]
    },
    { name:     "TAG_1441",
      desc:     "Tag Address stored in cache line 1441",
      swaccess: "rw",
      hwaccess: "hrw",
      hwext:    "true",
      hwqe:     "true", // enable `qe` latched signal of software write pulse
      hwre:     "true",
      fields: [
        { bits: "5-1:0",
          name: "CL_TAG",
          desc: "Tag Address"
        }
      ]
    },
    {
      name:     "STATUS_1442",
      desc:     "Status register of cache line 1442",
      swaccess: "rw",
      hwaccess: "hrw",
      hwext:    "true",
      hwqe:     "true", // enable `qe` latched signal of software write pulse
      hwre:     "true",
      fields: [
        {
          bits: "5+3:5", // 2 bits for status
          name: "CL_STATUS",
          desc: "Contain the current status of the corresponding cache line                [0]: valid, [1]: dirty, [2]: cmpt",
        }
      ]
    },
    { name:     "TAG_1442",
      desc:     "Tag Address stored in cache line 1442",
      swaccess: "rw",
      hwaccess: "hrw",
      hwext:    "true",
      hwqe:     "true", // enable `qe` latched signal of software write pulse
      hwre:     "true",
      fields: [
        { bits: "5-1:0",
          name: "CL_TAG",
          desc: "Tag Address"
        }
      ]
    },
    {
      name:     "STATUS_1443",
      desc:     "Status register of cache line 1443",
      swaccess: "rw",
      hwaccess: "hrw",
      hwext:    "true",
      hwqe:     "true", // enable `qe` latched signal of software write pulse
      hwre:     "true",
      fields: [
        {
          bits: "5+3:5", // 2 bits for status
          name: "CL_STATUS",
          desc: "Contain the current status of the corresponding cache line                [0]: valid, [1]: dirty, [2]: cmpt",
        }
      ]
    },
    { name:     "TAG_1443",
      desc:     "Tag Address stored in cache line 1443",
      swaccess: "rw",
      hwaccess: "hrw",
      hwext:    "true",
      hwqe:     "true", // enable `qe` latched signal of software write pulse
      hwre:     "true",
      fields: [
        { bits: "5-1:0",
          name: "CL_TAG",
          desc: "Tag Address"
        }
      ]
    },
    {
      name:     "STATUS_1444",
      desc:     "Status register of cache line 1444",
      swaccess: "rw",
      hwaccess: "hrw",
      hwext:    "true",
      hwqe:     "true", // enable `qe` latched signal of software write pulse
      hwre:     "true",
      fields: [
        {
          bits: "5+3:5", // 2 bits for status
          name: "CL_STATUS",
          desc: "Contain the current status of the corresponding cache line                [0]: valid, [1]: dirty, [2]: cmpt",
        }
      ]
    },
    { name:     "TAG_1444",
      desc:     "Tag Address stored in cache line 1444",
      swaccess: "rw",
      hwaccess: "hrw",
      hwext:    "true",
      hwqe:     "true", // enable `qe` latched signal of software write pulse
      hwre:     "true",
      fields: [
        { bits: "5-1:0",
          name: "CL_TAG",
          desc: "Tag Address"
        }
      ]
    },
    {
      name:     "STATUS_1445",
      desc:     "Status register of cache line 1445",
      swaccess: "rw",
      hwaccess: "hrw",
      hwext:    "true",
      hwqe:     "true", // enable `qe` latched signal of software write pulse
      hwre:     "true",
      fields: [
        {
          bits: "5+3:5", // 2 bits for status
          name: "CL_STATUS",
          desc: "Contain the current status of the corresponding cache line                [0]: valid, [1]: dirty, [2]: cmpt",
        }
      ]
    },
    { name:     "TAG_1445",
      desc:     "Tag Address stored in cache line 1445",
      swaccess: "rw",
      hwaccess: "hrw",
      hwext:    "true",
      hwqe:     "true", // enable `qe` latched signal of software write pulse
      hwre:     "true",
      fields: [
        { bits: "5-1:0",
          name: "CL_TAG",
          desc: "Tag Address"
        }
      ]
    },
    {
      name:     "STATUS_1446",
      desc:     "Status register of cache line 1446",
      swaccess: "rw",
      hwaccess: "hrw",
      hwext:    "true",
      hwqe:     "true", // enable `qe` latched signal of software write pulse
      hwre:     "true",
      fields: [
        {
          bits: "5+3:5", // 2 bits for status
          name: "CL_STATUS",
          desc: "Contain the current status of the corresponding cache line                [0]: valid, [1]: dirty, [2]: cmpt",
        }
      ]
    },
    { name:     "TAG_1446",
      desc:     "Tag Address stored in cache line 1446",
      swaccess: "rw",
      hwaccess: "hrw",
      hwext:    "true",
      hwqe:     "true", // enable `qe` latched signal of software write pulse
      hwre:     "true",
      fields: [
        { bits: "5-1:0",
          name: "CL_TAG",
          desc: "Tag Address"
        }
      ]
    },
    {
      name:     "STATUS_1447",
      desc:     "Status register of cache line 1447",
      swaccess: "rw",
      hwaccess: "hrw",
      hwext:    "true",
      hwqe:     "true", // enable `qe` latched signal of software write pulse
      hwre:     "true",
      fields: [
        {
          bits: "5+3:5", // 2 bits for status
          name: "CL_STATUS",
          desc: "Contain the current status of the corresponding cache line                [0]: valid, [1]: dirty, [2]: cmpt",
        }
      ]
    },
    { name:     "TAG_1447",
      desc:     "Tag Address stored in cache line 1447",
      swaccess: "rw",
      hwaccess: "hrw",
      hwext:    "true",
      hwqe:     "true", // enable `qe` latched signal of software write pulse
      hwre:     "true",
      fields: [
        { bits: "5-1:0",
          name: "CL_TAG",
          desc: "Tag Address"
        }
      ]
    },
    {
      name:     "STATUS_1448",
      desc:     "Status register of cache line 1448",
      swaccess: "rw",
      hwaccess: "hrw",
      hwext:    "true",
      hwqe:     "true", // enable `qe` latched signal of software write pulse
      hwre:     "true",
      fields: [
        {
          bits: "5+3:5", // 2 bits for status
          name: "CL_STATUS",
          desc: "Contain the current status of the corresponding cache line                [0]: valid, [1]: dirty, [2]: cmpt",
        }
      ]
    },
    { name:     "TAG_1448",
      desc:     "Tag Address stored in cache line 1448",
      swaccess: "rw",
      hwaccess: "hrw",
      hwext:    "true",
      hwqe:     "true", // enable `qe` latched signal of software write pulse
      hwre:     "true",
      fields: [
        { bits: "5-1:0",
          name: "CL_TAG",
          desc: "Tag Address"
        }
      ]
    },
    {
      name:     "STATUS_1449",
      desc:     "Status register of cache line 1449",
      swaccess: "rw",
      hwaccess: "hrw",
      hwext:    "true",
      hwqe:     "true", // enable `qe` latched signal of software write pulse
      hwre:     "true",
      fields: [
        {
          bits: "5+3:5", // 2 bits for status
          name: "CL_STATUS",
          desc: "Contain the current status of the corresponding cache line                [0]: valid, [1]: dirty, [2]: cmpt",
        }
      ]
    },
    { name:     "TAG_1449",
      desc:     "Tag Address stored in cache line 1449",
      swaccess: "rw",
      hwaccess: "hrw",
      hwext:    "true",
      hwqe:     "true", // enable `qe` latched signal of software write pulse
      hwre:     "true",
      fields: [
        { bits: "5-1:0",
          name: "CL_TAG",
          desc: "Tag Address"
        }
      ]
    },
    {
      name:     "STATUS_1450",
      desc:     "Status register of cache line 1450",
      swaccess: "rw",
      hwaccess: "hrw",
      hwext:    "true",
      hwqe:     "true", // enable `qe` latched signal of software write pulse
      hwre:     "true",
      fields: [
        {
          bits: "5+3:5", // 2 bits for status
          name: "CL_STATUS",
          desc: "Contain the current status of the corresponding cache line                [0]: valid, [1]: dirty, [2]: cmpt",
        }
      ]
    },
    { name:     "TAG_1450",
      desc:     "Tag Address stored in cache line 1450",
      swaccess: "rw",
      hwaccess: "hrw",
      hwext:    "true",
      hwqe:     "true", // enable `qe` latched signal of software write pulse
      hwre:     "true",
      fields: [
        { bits: "5-1:0",
          name: "CL_TAG",
          desc: "Tag Address"
        }
      ]
    },
    {
      name:     "STATUS_1451",
      desc:     "Status register of cache line 1451",
      swaccess: "rw",
      hwaccess: "hrw",
      hwext:    "true",
      hwqe:     "true", // enable `qe` latched signal of software write pulse
      hwre:     "true",
      fields: [
        {
          bits: "5+3:5", // 2 bits for status
          name: "CL_STATUS",
          desc: "Contain the current status of the corresponding cache line                [0]: valid, [1]: dirty, [2]: cmpt",
        }
      ]
    },
    { name:     "TAG_1451",
      desc:     "Tag Address stored in cache line 1451",
      swaccess: "rw",
      hwaccess: "hrw",
      hwext:    "true",
      hwqe:     "true", // enable `qe` latched signal of software write pulse
      hwre:     "true",
      fields: [
        { bits: "5-1:0",
          name: "CL_TAG",
          desc: "Tag Address"
        }
      ]
    },
    {
      name:     "STATUS_1452",
      desc:     "Status register of cache line 1452",
      swaccess: "rw",
      hwaccess: "hrw",
      hwext:    "true",
      hwqe:     "true", // enable `qe` latched signal of software write pulse
      hwre:     "true",
      fields: [
        {
          bits: "5+3:5", // 2 bits for status
          name: "CL_STATUS",
          desc: "Contain the current status of the corresponding cache line                [0]: valid, [1]: dirty, [2]: cmpt",
        }
      ]
    },
    { name:     "TAG_1452",
      desc:     "Tag Address stored in cache line 1452",
      swaccess: "rw",
      hwaccess: "hrw",
      hwext:    "true",
      hwqe:     "true", // enable `qe` latched signal of software write pulse
      hwre:     "true",
      fields: [
        { bits: "5-1:0",
          name: "CL_TAG",
          desc: "Tag Address"
        }
      ]
    },
    {
      name:     "STATUS_1453",
      desc:     "Status register of cache line 1453",
      swaccess: "rw",
      hwaccess: "hrw",
      hwext:    "true",
      hwqe:     "true", // enable `qe` latched signal of software write pulse
      hwre:     "true",
      fields: [
        {
          bits: "5+3:5", // 2 bits for status
          name: "CL_STATUS",
          desc: "Contain the current status of the corresponding cache line                [0]: valid, [1]: dirty, [2]: cmpt",
        }
      ]
    },
    { name:     "TAG_1453",
      desc:     "Tag Address stored in cache line 1453",
      swaccess: "rw",
      hwaccess: "hrw",
      hwext:    "true",
      hwqe:     "true", // enable `qe` latched signal of software write pulse
      hwre:     "true",
      fields: [
        { bits: "5-1:0",
          name: "CL_TAG",
          desc: "Tag Address"
        }
      ]
    },
    {
      name:     "STATUS_1454",
      desc:     "Status register of cache line 1454",
      swaccess: "rw",
      hwaccess: "hrw",
      hwext:    "true",
      hwqe:     "true", // enable `qe` latched signal of software write pulse
      hwre:     "true",
      fields: [
        {
          bits: "5+3:5", // 2 bits for status
          name: "CL_STATUS",
          desc: "Contain the current status of the corresponding cache line                [0]: valid, [1]: dirty, [2]: cmpt",
        }
      ]
    },
    { name:     "TAG_1454",
      desc:     "Tag Address stored in cache line 1454",
      swaccess: "rw",
      hwaccess: "hrw",
      hwext:    "true",
      hwqe:     "true", // enable `qe` latched signal of software write pulse
      hwre:     "true",
      fields: [
        { bits: "5-1:0",
          name: "CL_TAG",
          desc: "Tag Address"
        }
      ]
    },
    {
      name:     "STATUS_1455",
      desc:     "Status register of cache line 1455",
      swaccess: "rw",
      hwaccess: "hrw",
      hwext:    "true",
      hwqe:     "true", // enable `qe` latched signal of software write pulse
      hwre:     "true",
      fields: [
        {
          bits: "5+3:5", // 2 bits for status
          name: "CL_STATUS",
          desc: "Contain the current status of the corresponding cache line                [0]: valid, [1]: dirty, [2]: cmpt",
        }
      ]
    },
    { name:     "TAG_1455",
      desc:     "Tag Address stored in cache line 1455",
      swaccess: "rw",
      hwaccess: "hrw",
      hwext:    "true",
      hwqe:     "true", // enable `qe` latched signal of software write pulse
      hwre:     "true",
      fields: [
        { bits: "5-1:0",
          name: "CL_TAG",
          desc: "Tag Address"
        }
      ]
    },
    {
      name:     "STATUS_1456",
      desc:     "Status register of cache line 1456",
      swaccess: "rw",
      hwaccess: "hrw",
      hwext:    "true",
      hwqe:     "true", // enable `qe` latched signal of software write pulse
      hwre:     "true",
      fields: [
        {
          bits: "5+3:5", // 2 bits for status
          name: "CL_STATUS",
          desc: "Contain the current status of the corresponding cache line                [0]: valid, [1]: dirty, [2]: cmpt",
        }
      ]
    },
    { name:     "TAG_1456",
      desc:     "Tag Address stored in cache line 1456",
      swaccess: "rw",
      hwaccess: "hrw",
      hwext:    "true",
      hwqe:     "true", // enable `qe` latched signal of software write pulse
      hwre:     "true",
      fields: [
        { bits: "5-1:0",
          name: "CL_TAG",
          desc: "Tag Address"
        }
      ]
    },
    {
      name:     "STATUS_1457",
      desc:     "Status register of cache line 1457",
      swaccess: "rw",
      hwaccess: "hrw",
      hwext:    "true",
      hwqe:     "true", // enable `qe` latched signal of software write pulse
      hwre:     "true",
      fields: [
        {
          bits: "5+3:5", // 2 bits for status
          name: "CL_STATUS",
          desc: "Contain the current status of the corresponding cache line                [0]: valid, [1]: dirty, [2]: cmpt",
        }
      ]
    },
    { name:     "TAG_1457",
      desc:     "Tag Address stored in cache line 1457",
      swaccess: "rw",
      hwaccess: "hrw",
      hwext:    "true",
      hwqe:     "true", // enable `qe` latched signal of software write pulse
      hwre:     "true",
      fields: [
        { bits: "5-1:0",
          name: "CL_TAG",
          desc: "Tag Address"
        }
      ]
    },
    {
      name:     "STATUS_1458",
      desc:     "Status register of cache line 1458",
      swaccess: "rw",
      hwaccess: "hrw",
      hwext:    "true",
      hwqe:     "true", // enable `qe` latched signal of software write pulse
      hwre:     "true",
      fields: [
        {
          bits: "5+3:5", // 2 bits for status
          name: "CL_STATUS",
          desc: "Contain the current status of the corresponding cache line                [0]: valid, [1]: dirty, [2]: cmpt",
        }
      ]
    },
    { name:     "TAG_1458",
      desc:     "Tag Address stored in cache line 1458",
      swaccess: "rw",
      hwaccess: "hrw",
      hwext:    "true",
      hwqe:     "true", // enable `qe` latched signal of software write pulse
      hwre:     "true",
      fields: [
        { bits: "5-1:0",
          name: "CL_TAG",
          desc: "Tag Address"
        }
      ]
    },
    {
      name:     "STATUS_1459",
      desc:     "Status register of cache line 1459",
      swaccess: "rw",
      hwaccess: "hrw",
      hwext:    "true",
      hwqe:     "true", // enable `qe` latched signal of software write pulse
      hwre:     "true",
      fields: [
        {
          bits: "5+3:5", // 2 bits for status
          name: "CL_STATUS",
          desc: "Contain the current status of the corresponding cache line                [0]: valid, [1]: dirty, [2]: cmpt",
        }
      ]
    },
    { name:     "TAG_1459",
      desc:     "Tag Address stored in cache line 1459",
      swaccess: "rw",
      hwaccess: "hrw",
      hwext:    "true",
      hwqe:     "true", // enable `qe` latched signal of software write pulse
      hwre:     "true",
      fields: [
        { bits: "5-1:0",
          name: "CL_TAG",
          desc: "Tag Address"
        }
      ]
    },
    {
      name:     "STATUS_1460",
      desc:     "Status register of cache line 1460",
      swaccess: "rw",
      hwaccess: "hrw",
      hwext:    "true",
      hwqe:     "true", // enable `qe` latched signal of software write pulse
      hwre:     "true",
      fields: [
        {
          bits: "5+3:5", // 2 bits for status
          name: "CL_STATUS",
          desc: "Contain the current status of the corresponding cache line                [0]: valid, [1]: dirty, [2]: cmpt",
        }
      ]
    },
    { name:     "TAG_1460",
      desc:     "Tag Address stored in cache line 1460",
      swaccess: "rw",
      hwaccess: "hrw",
      hwext:    "true",
      hwqe:     "true", // enable `qe` latched signal of software write pulse
      hwre:     "true",
      fields: [
        { bits: "5-1:0",
          name: "CL_TAG",
          desc: "Tag Address"
        }
      ]
    },
    {
      name:     "STATUS_1461",
      desc:     "Status register of cache line 1461",
      swaccess: "rw",
      hwaccess: "hrw",
      hwext:    "true",
      hwqe:     "true", // enable `qe` latched signal of software write pulse
      hwre:     "true",
      fields: [
        {
          bits: "5+3:5", // 2 bits for status
          name: "CL_STATUS",
          desc: "Contain the current status of the corresponding cache line                [0]: valid, [1]: dirty, [2]: cmpt",
        }
      ]
    },
    { name:     "TAG_1461",
      desc:     "Tag Address stored in cache line 1461",
      swaccess: "rw",
      hwaccess: "hrw",
      hwext:    "true",
      hwqe:     "true", // enable `qe` latched signal of software write pulse
      hwre:     "true",
      fields: [
        { bits: "5-1:0",
          name: "CL_TAG",
          desc: "Tag Address"
        }
      ]
    },
    {
      name:     "STATUS_1462",
      desc:     "Status register of cache line 1462",
      swaccess: "rw",
      hwaccess: "hrw",
      hwext:    "true",
      hwqe:     "true", // enable `qe` latched signal of software write pulse
      hwre:     "true",
      fields: [
        {
          bits: "5+3:5", // 2 bits for status
          name: "CL_STATUS",
          desc: "Contain the current status of the corresponding cache line                [0]: valid, [1]: dirty, [2]: cmpt",
        }
      ]
    },
    { name:     "TAG_1462",
      desc:     "Tag Address stored in cache line 1462",
      swaccess: "rw",
      hwaccess: "hrw",
      hwext:    "true",
      hwqe:     "true", // enable `qe` latched signal of software write pulse
      hwre:     "true",
      fields: [
        { bits: "5-1:0",
          name: "CL_TAG",
          desc: "Tag Address"
        }
      ]
    },
    {
      name:     "STATUS_1463",
      desc:     "Status register of cache line 1463",
      swaccess: "rw",
      hwaccess: "hrw",
      hwext:    "true",
      hwqe:     "true", // enable `qe` latched signal of software write pulse
      hwre:     "true",
      fields: [
        {
          bits: "5+3:5", // 2 bits for status
          name: "CL_STATUS",
          desc: "Contain the current status of the corresponding cache line                [0]: valid, [1]: dirty, [2]: cmpt",
        }
      ]
    },
    { name:     "TAG_1463",
      desc:     "Tag Address stored in cache line 1463",
      swaccess: "rw",
      hwaccess: "hrw",
      hwext:    "true",
      hwqe:     "true", // enable `qe` latched signal of software write pulse
      hwre:     "true",
      fields: [
        { bits: "5-1:0",
          name: "CL_TAG",
          desc: "Tag Address"
        }
      ]
    },
    {
      name:     "STATUS_1464",
      desc:     "Status register of cache line 1464",
      swaccess: "rw",
      hwaccess: "hrw",
      hwext:    "true",
      hwqe:     "true", // enable `qe` latched signal of software write pulse
      hwre:     "true",
      fields: [
        {
          bits: "5+3:5", // 2 bits for status
          name: "CL_STATUS",
          desc: "Contain the current status of the corresponding cache line                [0]: valid, [1]: dirty, [2]: cmpt",
        }
      ]
    },
    { name:     "TAG_1464",
      desc:     "Tag Address stored in cache line 1464",
      swaccess: "rw",
      hwaccess: "hrw",
      hwext:    "true",
      hwqe:     "true", // enable `qe` latched signal of software write pulse
      hwre:     "true",
      fields: [
        { bits: "5-1:0",
          name: "CL_TAG",
          desc: "Tag Address"
        }
      ]
    },
    {
      name:     "STATUS_1465",
      desc:     "Status register of cache line 1465",
      swaccess: "rw",
      hwaccess: "hrw",
      hwext:    "true",
      hwqe:     "true", // enable `qe` latched signal of software write pulse
      hwre:     "true",
      fields: [
        {
          bits: "5+3:5", // 2 bits for status
          name: "CL_STATUS",
          desc: "Contain the current status of the corresponding cache line                [0]: valid, [1]: dirty, [2]: cmpt",
        }
      ]
    },
    { name:     "TAG_1465",
      desc:     "Tag Address stored in cache line 1465",
      swaccess: "rw",
      hwaccess: "hrw",
      hwext:    "true",
      hwqe:     "true", // enable `qe` latched signal of software write pulse
      hwre:     "true",
      fields: [
        { bits: "5-1:0",
          name: "CL_TAG",
          desc: "Tag Address"
        }
      ]
    },
    {
      name:     "STATUS_1466",
      desc:     "Status register of cache line 1466",
      swaccess: "rw",
      hwaccess: "hrw",
      hwext:    "true",
      hwqe:     "true", // enable `qe` latched signal of software write pulse
      hwre:     "true",
      fields: [
        {
          bits: "5+3:5", // 2 bits for status
          name: "CL_STATUS",
          desc: "Contain the current status of the corresponding cache line                [0]: valid, [1]: dirty, [2]: cmpt",
        }
      ]
    },
    { name:     "TAG_1466",
      desc:     "Tag Address stored in cache line 1466",
      swaccess: "rw",
      hwaccess: "hrw",
      hwext:    "true",
      hwqe:     "true", // enable `qe` latched signal of software write pulse
      hwre:     "true",
      fields: [
        { bits: "5-1:0",
          name: "CL_TAG",
          desc: "Tag Address"
        }
      ]
    },
    {
      name:     "STATUS_1467",
      desc:     "Status register of cache line 1467",
      swaccess: "rw",
      hwaccess: "hrw",
      hwext:    "true",
      hwqe:     "true", // enable `qe` latched signal of software write pulse
      hwre:     "true",
      fields: [
        {
          bits: "5+3:5", // 2 bits for status
          name: "CL_STATUS",
          desc: "Contain the current status of the corresponding cache line                [0]: valid, [1]: dirty, [2]: cmpt",
        }
      ]
    },
    { name:     "TAG_1467",
      desc:     "Tag Address stored in cache line 1467",
      swaccess: "rw",
      hwaccess: "hrw",
      hwext:    "true",
      hwqe:     "true", // enable `qe` latched signal of software write pulse
      hwre:     "true",
      fields: [
        { bits: "5-1:0",
          name: "CL_TAG",
          desc: "Tag Address"
        }
      ]
    },
    {
      name:     "STATUS_1468",
      desc:     "Status register of cache line 1468",
      swaccess: "rw",
      hwaccess: "hrw",
      hwext:    "true",
      hwqe:     "true", // enable `qe` latched signal of software write pulse
      hwre:     "true",
      fields: [
        {
          bits: "5+3:5", // 2 bits for status
          name: "CL_STATUS",
          desc: "Contain the current status of the corresponding cache line                [0]: valid, [1]: dirty, [2]: cmpt",
        }
      ]
    },
    { name:     "TAG_1468",
      desc:     "Tag Address stored in cache line 1468",
      swaccess: "rw",
      hwaccess: "hrw",
      hwext:    "true",
      hwqe:     "true", // enable `qe` latched signal of software write pulse
      hwre:     "true",
      fields: [
        { bits: "5-1:0",
          name: "CL_TAG",
          desc: "Tag Address"
        }
      ]
    },
    {
      name:     "STATUS_1469",
      desc:     "Status register of cache line 1469",
      swaccess: "rw",
      hwaccess: "hrw",
      hwext:    "true",
      hwqe:     "true", // enable `qe` latched signal of software write pulse
      hwre:     "true",
      fields: [
        {
          bits: "5+3:5", // 2 bits for status
          name: "CL_STATUS",
          desc: "Contain the current status of the corresponding cache line                [0]: valid, [1]: dirty, [2]: cmpt",
        }
      ]
    },
    { name:     "TAG_1469",
      desc:     "Tag Address stored in cache line 1469",
      swaccess: "rw",
      hwaccess: "hrw",
      hwext:    "true",
      hwqe:     "true", // enable `qe` latched signal of software write pulse
      hwre:     "true",
      fields: [
        { bits: "5-1:0",
          name: "CL_TAG",
          desc: "Tag Address"
        }
      ]
    },
    {
      name:     "STATUS_1470",
      desc:     "Status register of cache line 1470",
      swaccess: "rw",
      hwaccess: "hrw",
      hwext:    "true",
      hwqe:     "true", // enable `qe` latched signal of software write pulse
      hwre:     "true",
      fields: [
        {
          bits: "5+3:5", // 2 bits for status
          name: "CL_STATUS",
          desc: "Contain the current status of the corresponding cache line                [0]: valid, [1]: dirty, [2]: cmpt",
        }
      ]
    },
    { name:     "TAG_1470",
      desc:     "Tag Address stored in cache line 1470",
      swaccess: "rw",
      hwaccess: "hrw",
      hwext:    "true",
      hwqe:     "true", // enable `qe` latched signal of software write pulse
      hwre:     "true",
      fields: [
        { bits: "5-1:0",
          name: "CL_TAG",
          desc: "Tag Address"
        }
      ]
    },
    {
      name:     "STATUS_1471",
      desc:     "Status register of cache line 1471",
      swaccess: "rw",
      hwaccess: "hrw",
      hwext:    "true",
      hwqe:     "true", // enable `qe` latched signal of software write pulse
      hwre:     "true",
      fields: [
        {
          bits: "5+3:5", // 2 bits for status
          name: "CL_STATUS",
          desc: "Contain the current status of the corresponding cache line                [0]: valid, [1]: dirty, [2]: cmpt",
        }
      ]
    },
    { name:     "TAG_1471",
      desc:     "Tag Address stored in cache line 1471",
      swaccess: "rw",
      hwaccess: "hrw",
      hwext:    "true",
      hwqe:     "true", // enable `qe` latched signal of software write pulse
      hwre:     "true",
      fields: [
        { bits: "5-1:0",
          name: "CL_TAG",
          desc: "Tag Address"
        }
      ]
    },
    {
      name:     "STATUS_1472",
      desc:     "Status register of cache line 1472",
      swaccess: "rw",
      hwaccess: "hrw",
      hwext:    "true",
      hwqe:     "true", // enable `qe` latched signal of software write pulse
      hwre:     "true",
      fields: [
        {
          bits: "5+3:5", // 2 bits for status
          name: "CL_STATUS",
          desc: "Contain the current status of the corresponding cache line                [0]: valid, [1]: dirty, [2]: cmpt",
        }
      ]
    },
    { name:     "TAG_1472",
      desc:     "Tag Address stored in cache line 1472",
      swaccess: "rw",
      hwaccess: "hrw",
      hwext:    "true",
      hwqe:     "true", // enable `qe` latched signal of software write pulse
      hwre:     "true",
      fields: [
        { bits: "5-1:0",
          name: "CL_TAG",
          desc: "Tag Address"
        }
      ]
    },
    {
      name:     "STATUS_1473",
      desc:     "Status register of cache line 1473",
      swaccess: "rw",
      hwaccess: "hrw",
      hwext:    "true",
      hwqe:     "true", // enable `qe` latched signal of software write pulse
      hwre:     "true",
      fields: [
        {
          bits: "5+3:5", // 2 bits for status
          name: "CL_STATUS",
          desc: "Contain the current status of the corresponding cache line                [0]: valid, [1]: dirty, [2]: cmpt",
        }
      ]
    },
    { name:     "TAG_1473",
      desc:     "Tag Address stored in cache line 1473",
      swaccess: "rw",
      hwaccess: "hrw",
      hwext:    "true",
      hwqe:     "true", // enable `qe` latched signal of software write pulse
      hwre:     "true",
      fields: [
        { bits: "5-1:0",
          name: "CL_TAG",
          desc: "Tag Address"
        }
      ]
    },
    {
      name:     "STATUS_1474",
      desc:     "Status register of cache line 1474",
      swaccess: "rw",
      hwaccess: "hrw",
      hwext:    "true",
      hwqe:     "true", // enable `qe` latched signal of software write pulse
      hwre:     "true",
      fields: [
        {
          bits: "5+3:5", // 2 bits for status
          name: "CL_STATUS",
          desc: "Contain the current status of the corresponding cache line                [0]: valid, [1]: dirty, [2]: cmpt",
        }
      ]
    },
    { name:     "TAG_1474",
      desc:     "Tag Address stored in cache line 1474",
      swaccess: "rw",
      hwaccess: "hrw",
      hwext:    "true",
      hwqe:     "true", // enable `qe` latched signal of software write pulse
      hwre:     "true",
      fields: [
        { bits: "5-1:0",
          name: "CL_TAG",
          desc: "Tag Address"
        }
      ]
    },
    {
      name:     "STATUS_1475",
      desc:     "Status register of cache line 1475",
      swaccess: "rw",
      hwaccess: "hrw",
      hwext:    "true",
      hwqe:     "true", // enable `qe` latched signal of software write pulse
      hwre:     "true",
      fields: [
        {
          bits: "5+3:5", // 2 bits for status
          name: "CL_STATUS",
          desc: "Contain the current status of the corresponding cache line                [0]: valid, [1]: dirty, [2]: cmpt",
        }
      ]
    },
    { name:     "TAG_1475",
      desc:     "Tag Address stored in cache line 1475",
      swaccess: "rw",
      hwaccess: "hrw",
      hwext:    "true",
      hwqe:     "true", // enable `qe` latched signal of software write pulse
      hwre:     "true",
      fields: [
        { bits: "5-1:0",
          name: "CL_TAG",
          desc: "Tag Address"
        }
      ]
    },
    {
      name:     "STATUS_1476",
      desc:     "Status register of cache line 1476",
      swaccess: "rw",
      hwaccess: "hrw",
      hwext:    "true",
      hwqe:     "true", // enable `qe` latched signal of software write pulse
      hwre:     "true",
      fields: [
        {
          bits: "5+3:5", // 2 bits for status
          name: "CL_STATUS",
          desc: "Contain the current status of the corresponding cache line                [0]: valid, [1]: dirty, [2]: cmpt",
        }
      ]
    },
    { name:     "TAG_1476",
      desc:     "Tag Address stored in cache line 1476",
      swaccess: "rw",
      hwaccess: "hrw",
      hwext:    "true",
      hwqe:     "true", // enable `qe` latched signal of software write pulse
      hwre:     "true",
      fields: [
        { bits: "5-1:0",
          name: "CL_TAG",
          desc: "Tag Address"
        }
      ]
    },
    {
      name:     "STATUS_1477",
      desc:     "Status register of cache line 1477",
      swaccess: "rw",
      hwaccess: "hrw",
      hwext:    "true",
      hwqe:     "true", // enable `qe` latched signal of software write pulse
      hwre:     "true",
      fields: [
        {
          bits: "5+3:5", // 2 bits for status
          name: "CL_STATUS",
          desc: "Contain the current status of the corresponding cache line                [0]: valid, [1]: dirty, [2]: cmpt",
        }
      ]
    },
    { name:     "TAG_1477",
      desc:     "Tag Address stored in cache line 1477",
      swaccess: "rw",
      hwaccess: "hrw",
      hwext:    "true",
      hwqe:     "true", // enable `qe` latched signal of software write pulse
      hwre:     "true",
      fields: [
        { bits: "5-1:0",
          name: "CL_TAG",
          desc: "Tag Address"
        }
      ]
    },
    {
      name:     "STATUS_1478",
      desc:     "Status register of cache line 1478",
      swaccess: "rw",
      hwaccess: "hrw",
      hwext:    "true",
      hwqe:     "true", // enable `qe` latched signal of software write pulse
      hwre:     "true",
      fields: [
        {
          bits: "5+3:5", // 2 bits for status
          name: "CL_STATUS",
          desc: "Contain the current status of the corresponding cache line                [0]: valid, [1]: dirty, [2]: cmpt",
        }
      ]
    },
    { name:     "TAG_1478",
      desc:     "Tag Address stored in cache line 1478",
      swaccess: "rw",
      hwaccess: "hrw",
      hwext:    "true",
      hwqe:     "true", // enable `qe` latched signal of software write pulse
      hwre:     "true",
      fields: [
        { bits: "5-1:0",
          name: "CL_TAG",
          desc: "Tag Address"
        }
      ]
    },
    {
      name:     "STATUS_1479",
      desc:     "Status register of cache line 1479",
      swaccess: "rw",
      hwaccess: "hrw",
      hwext:    "true",
      hwqe:     "true", // enable `qe` latched signal of software write pulse
      hwre:     "true",
      fields: [
        {
          bits: "5+3:5", // 2 bits for status
          name: "CL_STATUS",
          desc: "Contain the current status of the corresponding cache line                [0]: valid, [1]: dirty, [2]: cmpt",
        }
      ]
    },
    { name:     "TAG_1479",
      desc:     "Tag Address stored in cache line 1479",
      swaccess: "rw",
      hwaccess: "hrw",
      hwext:    "true",
      hwqe:     "true", // enable `qe` latched signal of software write pulse
      hwre:     "true",
      fields: [
        { bits: "5-1:0",
          name: "CL_TAG",
          desc: "Tag Address"
        }
      ]
    },
    {
      name:     "STATUS_1480",
      desc:     "Status register of cache line 1480",
      swaccess: "rw",
      hwaccess: "hrw",
      hwext:    "true",
      hwqe:     "true", // enable `qe` latched signal of software write pulse
      hwre:     "true",
      fields: [
        {
          bits: "5+3:5", // 2 bits for status
          name: "CL_STATUS",
          desc: "Contain the current status of the corresponding cache line                [0]: valid, [1]: dirty, [2]: cmpt",
        }
      ]
    },
    { name:     "TAG_1480",
      desc:     "Tag Address stored in cache line 1480",
      swaccess: "rw",
      hwaccess: "hrw",
      hwext:    "true",
      hwqe:     "true", // enable `qe` latched signal of software write pulse
      hwre:     "true",
      fields: [
        { bits: "5-1:0",
          name: "CL_TAG",
          desc: "Tag Address"
        }
      ]
    },
    {
      name:     "STATUS_1481",
      desc:     "Status register of cache line 1481",
      swaccess: "rw",
      hwaccess: "hrw",
      hwext:    "true",
      hwqe:     "true", // enable `qe` latched signal of software write pulse
      hwre:     "true",
      fields: [
        {
          bits: "5+3:5", // 2 bits for status
          name: "CL_STATUS",
          desc: "Contain the current status of the corresponding cache line                [0]: valid, [1]: dirty, [2]: cmpt",
        }
      ]
    },
    { name:     "TAG_1481",
      desc:     "Tag Address stored in cache line 1481",
      swaccess: "rw",
      hwaccess: "hrw",
      hwext:    "true",
      hwqe:     "true", // enable `qe` latched signal of software write pulse
      hwre:     "true",
      fields: [
        { bits: "5-1:0",
          name: "CL_TAG",
          desc: "Tag Address"
        }
      ]
    },
    {
      name:     "STATUS_1482",
      desc:     "Status register of cache line 1482",
      swaccess: "rw",
      hwaccess: "hrw",
      hwext:    "true",
      hwqe:     "true", // enable `qe` latched signal of software write pulse
      hwre:     "true",
      fields: [
        {
          bits: "5+3:5", // 2 bits for status
          name: "CL_STATUS",
          desc: "Contain the current status of the corresponding cache line                [0]: valid, [1]: dirty, [2]: cmpt",
        }
      ]
    },
    { name:     "TAG_1482",
      desc:     "Tag Address stored in cache line 1482",
      swaccess: "rw",
      hwaccess: "hrw",
      hwext:    "true",
      hwqe:     "true", // enable `qe` latched signal of software write pulse
      hwre:     "true",
      fields: [
        { bits: "5-1:0",
          name: "CL_TAG",
          desc: "Tag Address"
        }
      ]
    },
    {
      name:     "STATUS_1483",
      desc:     "Status register of cache line 1483",
      swaccess: "rw",
      hwaccess: "hrw",
      hwext:    "true",
      hwqe:     "true", // enable `qe` latched signal of software write pulse
      hwre:     "true",
      fields: [
        {
          bits: "5+3:5", // 2 bits for status
          name: "CL_STATUS",
          desc: "Contain the current status of the corresponding cache line                [0]: valid, [1]: dirty, [2]: cmpt",
        }
      ]
    },
    { name:     "TAG_1483",
      desc:     "Tag Address stored in cache line 1483",
      swaccess: "rw",
      hwaccess: "hrw",
      hwext:    "true",
      hwqe:     "true", // enable `qe` latched signal of software write pulse
      hwre:     "true",
      fields: [
        { bits: "5-1:0",
          name: "CL_TAG",
          desc: "Tag Address"
        }
      ]
    },
    {
      name:     "STATUS_1484",
      desc:     "Status register of cache line 1484",
      swaccess: "rw",
      hwaccess: "hrw",
      hwext:    "true",
      hwqe:     "true", // enable `qe` latched signal of software write pulse
      hwre:     "true",
      fields: [
        {
          bits: "5+3:5", // 2 bits for status
          name: "CL_STATUS",
          desc: "Contain the current status of the corresponding cache line                [0]: valid, [1]: dirty, [2]: cmpt",
        }
      ]
    },
    { name:     "TAG_1484",
      desc:     "Tag Address stored in cache line 1484",
      swaccess: "rw",
      hwaccess: "hrw",
      hwext:    "true",
      hwqe:     "true", // enable `qe` latched signal of software write pulse
      hwre:     "true",
      fields: [
        { bits: "5-1:0",
          name: "CL_TAG",
          desc: "Tag Address"
        }
      ]
    },
    {
      name:     "STATUS_1485",
      desc:     "Status register of cache line 1485",
      swaccess: "rw",
      hwaccess: "hrw",
      hwext:    "true",
      hwqe:     "true", // enable `qe` latched signal of software write pulse
      hwre:     "true",
      fields: [
        {
          bits: "5+3:5", // 2 bits for status
          name: "CL_STATUS",
          desc: "Contain the current status of the corresponding cache line                [0]: valid, [1]: dirty, [2]: cmpt",
        }
      ]
    },
    { name:     "TAG_1485",
      desc:     "Tag Address stored in cache line 1485",
      swaccess: "rw",
      hwaccess: "hrw",
      hwext:    "true",
      hwqe:     "true", // enable `qe` latched signal of software write pulse
      hwre:     "true",
      fields: [
        { bits: "5-1:0",
          name: "CL_TAG",
          desc: "Tag Address"
        }
      ]
    },
    {
      name:     "STATUS_1486",
      desc:     "Status register of cache line 1486",
      swaccess: "rw",
      hwaccess: "hrw",
      hwext:    "true",
      hwqe:     "true", // enable `qe` latched signal of software write pulse
      hwre:     "true",
      fields: [
        {
          bits: "5+3:5", // 2 bits for status
          name: "CL_STATUS",
          desc: "Contain the current status of the corresponding cache line                [0]: valid, [1]: dirty, [2]: cmpt",
        }
      ]
    },
    { name:     "TAG_1486",
      desc:     "Tag Address stored in cache line 1486",
      swaccess: "rw",
      hwaccess: "hrw",
      hwext:    "true",
      hwqe:     "true", // enable `qe` latched signal of software write pulse
      hwre:     "true",
      fields: [
        { bits: "5-1:0",
          name: "CL_TAG",
          desc: "Tag Address"
        }
      ]
    },
    {
      name:     "STATUS_1487",
      desc:     "Status register of cache line 1487",
      swaccess: "rw",
      hwaccess: "hrw",
      hwext:    "true",
      hwqe:     "true", // enable `qe` latched signal of software write pulse
      hwre:     "true",
      fields: [
        {
          bits: "5+3:5", // 2 bits for status
          name: "CL_STATUS",
          desc: "Contain the current status of the corresponding cache line                [0]: valid, [1]: dirty, [2]: cmpt",
        }
      ]
    },
    { name:     "TAG_1487",
      desc:     "Tag Address stored in cache line 1487",
      swaccess: "rw",
      hwaccess: "hrw",
      hwext:    "true",
      hwqe:     "true", // enable `qe` latched signal of software write pulse
      hwre:     "true",
      fields: [
        { bits: "5-1:0",
          name: "CL_TAG",
          desc: "Tag Address"
        }
      ]
    },
    {
      name:     "STATUS_1488",
      desc:     "Status register of cache line 1488",
      swaccess: "rw",
      hwaccess: "hrw",
      hwext:    "true",
      hwqe:     "true", // enable `qe` latched signal of software write pulse
      hwre:     "true",
      fields: [
        {
          bits: "5+3:5", // 2 bits for status
          name: "CL_STATUS",
          desc: "Contain the current status of the corresponding cache line                [0]: valid, [1]: dirty, [2]: cmpt",
        }
      ]
    },
    { name:     "TAG_1488",
      desc:     "Tag Address stored in cache line 1488",
      swaccess: "rw",
      hwaccess: "hrw",
      hwext:    "true",
      hwqe:     "true", // enable `qe` latched signal of software write pulse
      hwre:     "true",
      fields: [
        { bits: "5-1:0",
          name: "CL_TAG",
          desc: "Tag Address"
        }
      ]
    },
    {
      name:     "STATUS_1489",
      desc:     "Status register of cache line 1489",
      swaccess: "rw",
      hwaccess: "hrw",
      hwext:    "true",
      hwqe:     "true", // enable `qe` latched signal of software write pulse
      hwre:     "true",
      fields: [
        {
          bits: "5+3:5", // 2 bits for status
          name: "CL_STATUS",
          desc: "Contain the current status of the corresponding cache line                [0]: valid, [1]: dirty, [2]: cmpt",
        }
      ]
    },
    { name:     "TAG_1489",
      desc:     "Tag Address stored in cache line 1489",
      swaccess: "rw",
      hwaccess: "hrw",
      hwext:    "true",
      hwqe:     "true", // enable `qe` latched signal of software write pulse
      hwre:     "true",
      fields: [
        { bits: "5-1:0",
          name: "CL_TAG",
          desc: "Tag Address"
        }
      ]
    },
    {
      name:     "STATUS_1490",
      desc:     "Status register of cache line 1490",
      swaccess: "rw",
      hwaccess: "hrw",
      hwext:    "true",
      hwqe:     "true", // enable `qe` latched signal of software write pulse
      hwre:     "true",
      fields: [
        {
          bits: "5+3:5", // 2 bits for status
          name: "CL_STATUS",
          desc: "Contain the current status of the corresponding cache line                [0]: valid, [1]: dirty, [2]: cmpt",
        }
      ]
    },
    { name:     "TAG_1490",
      desc:     "Tag Address stored in cache line 1490",
      swaccess: "rw",
      hwaccess: "hrw",
      hwext:    "true",
      hwqe:     "true", // enable `qe` latched signal of software write pulse
      hwre:     "true",
      fields: [
        { bits: "5-1:0",
          name: "CL_TAG",
          desc: "Tag Address"
        }
      ]
    },
    {
      name:     "STATUS_1491",
      desc:     "Status register of cache line 1491",
      swaccess: "rw",
      hwaccess: "hrw",
      hwext:    "true",
      hwqe:     "true", // enable `qe` latched signal of software write pulse
      hwre:     "true",
      fields: [
        {
          bits: "5+3:5", // 2 bits for status
          name: "CL_STATUS",
          desc: "Contain the current status of the corresponding cache line                [0]: valid, [1]: dirty, [2]: cmpt",
        }
      ]
    },
    { name:     "TAG_1491",
      desc:     "Tag Address stored in cache line 1491",
      swaccess: "rw",
      hwaccess: "hrw",
      hwext:    "true",
      hwqe:     "true", // enable `qe` latched signal of software write pulse
      hwre:     "true",
      fields: [
        { bits: "5-1:0",
          name: "CL_TAG",
          desc: "Tag Address"
        }
      ]
    },
    {
      name:     "STATUS_1492",
      desc:     "Status register of cache line 1492",
      swaccess: "rw",
      hwaccess: "hrw",
      hwext:    "true",
      hwqe:     "true", // enable `qe` latched signal of software write pulse
      hwre:     "true",
      fields: [
        {
          bits: "5+3:5", // 2 bits for status
          name: "CL_STATUS",
          desc: "Contain the current status of the corresponding cache line                [0]: valid, [1]: dirty, [2]: cmpt",
        }
      ]
    },
    { name:     "TAG_1492",
      desc:     "Tag Address stored in cache line 1492",
      swaccess: "rw",
      hwaccess: "hrw",
      hwext:    "true",
      hwqe:     "true", // enable `qe` latched signal of software write pulse
      hwre:     "true",
      fields: [
        { bits: "5-1:0",
          name: "CL_TAG",
          desc: "Tag Address"
        }
      ]
    },
    {
      name:     "STATUS_1493",
      desc:     "Status register of cache line 1493",
      swaccess: "rw",
      hwaccess: "hrw",
      hwext:    "true",
      hwqe:     "true", // enable `qe` latched signal of software write pulse
      hwre:     "true",
      fields: [
        {
          bits: "5+3:5", // 2 bits for status
          name: "CL_STATUS",
          desc: "Contain the current status of the corresponding cache line                [0]: valid, [1]: dirty, [2]: cmpt",
        }
      ]
    },
    { name:     "TAG_1493",
      desc:     "Tag Address stored in cache line 1493",
      swaccess: "rw",
      hwaccess: "hrw",
      hwext:    "true",
      hwqe:     "true", // enable `qe` latched signal of software write pulse
      hwre:     "true",
      fields: [
        { bits: "5-1:0",
          name: "CL_TAG",
          desc: "Tag Address"
        }
      ]
    },
    {
      name:     "STATUS_1494",
      desc:     "Status register of cache line 1494",
      swaccess: "rw",
      hwaccess: "hrw",
      hwext:    "true",
      hwqe:     "true", // enable `qe` latched signal of software write pulse
      hwre:     "true",
      fields: [
        {
          bits: "5+3:5", // 2 bits for status
          name: "CL_STATUS",
          desc: "Contain the current status of the corresponding cache line                [0]: valid, [1]: dirty, [2]: cmpt",
        }
      ]
    },
    { name:     "TAG_1494",
      desc:     "Tag Address stored in cache line 1494",
      swaccess: "rw",
      hwaccess: "hrw",
      hwext:    "true",
      hwqe:     "true", // enable `qe` latched signal of software write pulse
      hwre:     "true",
      fields: [
        { bits: "5-1:0",
          name: "CL_TAG",
          desc: "Tag Address"
        }
      ]
    },
    {
      name:     "STATUS_1495",
      desc:     "Status register of cache line 1495",
      swaccess: "rw",
      hwaccess: "hrw",
      hwext:    "true",
      hwqe:     "true", // enable `qe` latched signal of software write pulse
      hwre:     "true",
      fields: [
        {
          bits: "5+3:5", // 2 bits for status
          name: "CL_STATUS",
          desc: "Contain the current status of the corresponding cache line                [0]: valid, [1]: dirty, [2]: cmpt",
        }
      ]
    },
    { name:     "TAG_1495",
      desc:     "Tag Address stored in cache line 1495",
      swaccess: "rw",
      hwaccess: "hrw",
      hwext:    "true",
      hwqe:     "true", // enable `qe` latched signal of software write pulse
      hwre:     "true",
      fields: [
        { bits: "5-1:0",
          name: "CL_TAG",
          desc: "Tag Address"
        }
      ]
    },
    {
      name:     "STATUS_1496",
      desc:     "Status register of cache line 1496",
      swaccess: "rw",
      hwaccess: "hrw",
      hwext:    "true",
      hwqe:     "true", // enable `qe` latched signal of software write pulse
      hwre:     "true",
      fields: [
        {
          bits: "5+3:5", // 2 bits for status
          name: "CL_STATUS",
          desc: "Contain the current status of the corresponding cache line                [0]: valid, [1]: dirty, [2]: cmpt",
        }
      ]
    },
    { name:     "TAG_1496",
      desc:     "Tag Address stored in cache line 1496",
      swaccess: "rw",
      hwaccess: "hrw",
      hwext:    "true",
      hwqe:     "true", // enable `qe` latched signal of software write pulse
      hwre:     "true",
      fields: [
        { bits: "5-1:0",
          name: "CL_TAG",
          desc: "Tag Address"
        }
      ]
    },
    {
      name:     "STATUS_1497",
      desc:     "Status register of cache line 1497",
      swaccess: "rw",
      hwaccess: "hrw",
      hwext:    "true",
      hwqe:     "true", // enable `qe` latched signal of software write pulse
      hwre:     "true",
      fields: [
        {
          bits: "5+3:5", // 2 bits for status
          name: "CL_STATUS",
          desc: "Contain the current status of the corresponding cache line                [0]: valid, [1]: dirty, [2]: cmpt",
        }
      ]
    },
    { name:     "TAG_1497",
      desc:     "Tag Address stored in cache line 1497",
      swaccess: "rw",
      hwaccess: "hrw",
      hwext:    "true",
      hwqe:     "true", // enable `qe` latched signal of software write pulse
      hwre:     "true",
      fields: [
        { bits: "5-1:0",
          name: "CL_TAG",
          desc: "Tag Address"
        }
      ]
    },
    {
      name:     "STATUS_1498",
      desc:     "Status register of cache line 1498",
      swaccess: "rw",
      hwaccess: "hrw",
      hwext:    "true",
      hwqe:     "true", // enable `qe` latched signal of software write pulse
      hwre:     "true",
      fields: [
        {
          bits: "5+3:5", // 2 bits for status
          name: "CL_STATUS",
          desc: "Contain the current status of the corresponding cache line                [0]: valid, [1]: dirty, [2]: cmpt",
        }
      ]
    },
    { name:     "TAG_1498",
      desc:     "Tag Address stored in cache line 1498",
      swaccess: "rw",
      hwaccess: "hrw",
      hwext:    "true",
      hwqe:     "true", // enable `qe` latched signal of software write pulse
      hwre:     "true",
      fields: [
        { bits: "5-1:0",
          name: "CL_TAG",
          desc: "Tag Address"
        }
      ]
    },
    {
      name:     "STATUS_1499",
      desc:     "Status register of cache line 1499",
      swaccess: "rw",
      hwaccess: "hrw",
      hwext:    "true",
      hwqe:     "true", // enable `qe` latched signal of software write pulse
      hwre:     "true",
      fields: [
        {
          bits: "5+3:5", // 2 bits for status
          name: "CL_STATUS",
          desc: "Contain the current status of the corresponding cache line                [0]: valid, [1]: dirty, [2]: cmpt",
        }
      ]
    },
    { name:     "TAG_1499",
      desc:     "Tag Address stored in cache line 1499",
      swaccess: "rw",
      hwaccess: "hrw",
      hwext:    "true",
      hwqe:     "true", // enable `qe` latched signal of software write pulse
      hwre:     "true",
      fields: [
        { bits: "5-1:0",
          name: "CL_TAG",
          desc: "Tag Address"
        }
      ]
    },
    {
      name:     "STATUS_1500",
      desc:     "Status register of cache line 1500",
      swaccess: "rw",
      hwaccess: "hrw",
      hwext:    "true",
      hwqe:     "true", // enable `qe` latched signal of software write pulse
      hwre:     "true",
      fields: [
        {
          bits: "5+3:5", // 2 bits for status
          name: "CL_STATUS",
          desc: "Contain the current status of the corresponding cache line                [0]: valid, [1]: dirty, [2]: cmpt",
        }
      ]
    },
    { name:     "TAG_1500",
      desc:     "Tag Address stored in cache line 1500",
      swaccess: "rw",
      hwaccess: "hrw",
      hwext:    "true",
      hwqe:     "true", // enable `qe` latched signal of software write pulse
      hwre:     "true",
      fields: [
        { bits: "5-1:0",
          name: "CL_TAG",
          desc: "Tag Address"
        }
      ]
    },
    {
      name:     "STATUS_1501",
      desc:     "Status register of cache line 1501",
      swaccess: "rw",
      hwaccess: "hrw",
      hwext:    "true",
      hwqe:     "true", // enable `qe` latched signal of software write pulse
      hwre:     "true",
      fields: [
        {
          bits: "5+3:5", // 2 bits for status
          name: "CL_STATUS",
          desc: "Contain the current status of the corresponding cache line                [0]: valid, [1]: dirty, [2]: cmpt",
        }
      ]
    },
    { name:     "TAG_1501",
      desc:     "Tag Address stored in cache line 1501",
      swaccess: "rw",
      hwaccess: "hrw",
      hwext:    "true",
      hwqe:     "true", // enable `qe` latched signal of software write pulse
      hwre:     "true",
      fields: [
        { bits: "5-1:0",
          name: "CL_TAG",
          desc: "Tag Address"
        }
      ]
    },
    {
      name:     "STATUS_1502",
      desc:     "Status register of cache line 1502",
      swaccess: "rw",
      hwaccess: "hrw",
      hwext:    "true",
      hwqe:     "true", // enable `qe` latched signal of software write pulse
      hwre:     "true",
      fields: [
        {
          bits: "5+3:5", // 2 bits for status
          name: "CL_STATUS",
          desc: "Contain the current status of the corresponding cache line                [0]: valid, [1]: dirty, [2]: cmpt",
        }
      ]
    },
    { name:     "TAG_1502",
      desc:     "Tag Address stored in cache line 1502",
      swaccess: "rw",
      hwaccess: "hrw",
      hwext:    "true",
      hwqe:     "true", // enable `qe` latched signal of software write pulse
      hwre:     "true",
      fields: [
        { bits: "5-1:0",
          name: "CL_TAG",
          desc: "Tag Address"
        }
      ]
    },
    {
      name:     "STATUS_1503",
      desc:     "Status register of cache line 1503",
      swaccess: "rw",
      hwaccess: "hrw",
      hwext:    "true",
      hwqe:     "true", // enable `qe` latched signal of software write pulse
      hwre:     "true",
      fields: [
        {
          bits: "5+3:5", // 2 bits for status
          name: "CL_STATUS",
          desc: "Contain the current status of the corresponding cache line                [0]: valid, [1]: dirty, [2]: cmpt",
        }
      ]
    },
    { name:     "TAG_1503",
      desc:     "Tag Address stored in cache line 1503",
      swaccess: "rw",
      hwaccess: "hrw",
      hwext:    "true",
      hwqe:     "true", // enable `qe` latched signal of software write pulse
      hwre:     "true",
      fields: [
        { bits: "5-1:0",
          name: "CL_TAG",
          desc: "Tag Address"
        }
      ]
    },
    {
      name:     "STATUS_1504",
      desc:     "Status register of cache line 1504",
      swaccess: "rw",
      hwaccess: "hrw",
      hwext:    "true",
      hwqe:     "true", // enable `qe` latched signal of software write pulse
      hwre:     "true",
      fields: [
        {
          bits: "5+3:5", // 2 bits for status
          name: "CL_STATUS",
          desc: "Contain the current status of the corresponding cache line                [0]: valid, [1]: dirty, [2]: cmpt",
        }
      ]
    },
    { name:     "TAG_1504",
      desc:     "Tag Address stored in cache line 1504",
      swaccess: "rw",
      hwaccess: "hrw",
      hwext:    "true",
      hwqe:     "true", // enable `qe` latched signal of software write pulse
      hwre:     "true",
      fields: [
        { bits: "5-1:0",
          name: "CL_TAG",
          desc: "Tag Address"
        }
      ]
    },
    {
      name:     "STATUS_1505",
      desc:     "Status register of cache line 1505",
      swaccess: "rw",
      hwaccess: "hrw",
      hwext:    "true",
      hwqe:     "true", // enable `qe` latched signal of software write pulse
      hwre:     "true",
      fields: [
        {
          bits: "5+3:5", // 2 bits for status
          name: "CL_STATUS",
          desc: "Contain the current status of the corresponding cache line                [0]: valid, [1]: dirty, [2]: cmpt",
        }
      ]
    },
    { name:     "TAG_1505",
      desc:     "Tag Address stored in cache line 1505",
      swaccess: "rw",
      hwaccess: "hrw",
      hwext:    "true",
      hwqe:     "true", // enable `qe` latched signal of software write pulse
      hwre:     "true",
      fields: [
        { bits: "5-1:0",
          name: "CL_TAG",
          desc: "Tag Address"
        }
      ]
    },
    {
      name:     "STATUS_1506",
      desc:     "Status register of cache line 1506",
      swaccess: "rw",
      hwaccess: "hrw",
      hwext:    "true",
      hwqe:     "true", // enable `qe` latched signal of software write pulse
      hwre:     "true",
      fields: [
        {
          bits: "5+3:5", // 2 bits for status
          name: "CL_STATUS",
          desc: "Contain the current status of the corresponding cache line                [0]: valid, [1]: dirty, [2]: cmpt",
        }
      ]
    },
    { name:     "TAG_1506",
      desc:     "Tag Address stored in cache line 1506",
      swaccess: "rw",
      hwaccess: "hrw",
      hwext:    "true",
      hwqe:     "true", // enable `qe` latched signal of software write pulse
      hwre:     "true",
      fields: [
        { bits: "5-1:0",
          name: "CL_TAG",
          desc: "Tag Address"
        }
      ]
    },
    {
      name:     "STATUS_1507",
      desc:     "Status register of cache line 1507",
      swaccess: "rw",
      hwaccess: "hrw",
      hwext:    "true",
      hwqe:     "true", // enable `qe` latched signal of software write pulse
      hwre:     "true",
      fields: [
        {
          bits: "5+3:5", // 2 bits for status
          name: "CL_STATUS",
          desc: "Contain the current status of the corresponding cache line                [0]: valid, [1]: dirty, [2]: cmpt",
        }
      ]
    },
    { name:     "TAG_1507",
      desc:     "Tag Address stored in cache line 1507",
      swaccess: "rw",
      hwaccess: "hrw",
      hwext:    "true",
      hwqe:     "true", // enable `qe` latched signal of software write pulse
      hwre:     "true",
      fields: [
        { bits: "5-1:0",
          name: "CL_TAG",
          desc: "Tag Address"
        }
      ]
    },
    {
      name:     "STATUS_1508",
      desc:     "Status register of cache line 1508",
      swaccess: "rw",
      hwaccess: "hrw",
      hwext:    "true",
      hwqe:     "true", // enable `qe` latched signal of software write pulse
      hwre:     "true",
      fields: [
        {
          bits: "5+3:5", // 2 bits for status
          name: "CL_STATUS",
          desc: "Contain the current status of the corresponding cache line                [0]: valid, [1]: dirty, [2]: cmpt",
        }
      ]
    },
    { name:     "TAG_1508",
      desc:     "Tag Address stored in cache line 1508",
      swaccess: "rw",
      hwaccess: "hrw",
      hwext:    "true",
      hwqe:     "true", // enable `qe` latched signal of software write pulse
      hwre:     "true",
      fields: [
        { bits: "5-1:0",
          name: "CL_TAG",
          desc: "Tag Address"
        }
      ]
    },
    {
      name:     "STATUS_1509",
      desc:     "Status register of cache line 1509",
      swaccess: "rw",
      hwaccess: "hrw",
      hwext:    "true",
      hwqe:     "true", // enable `qe` latched signal of software write pulse
      hwre:     "true",
      fields: [
        {
          bits: "5+3:5", // 2 bits for status
          name: "CL_STATUS",
          desc: "Contain the current status of the corresponding cache line                [0]: valid, [1]: dirty, [2]: cmpt",
        }
      ]
    },
    { name:     "TAG_1509",
      desc:     "Tag Address stored in cache line 1509",
      swaccess: "rw",
      hwaccess: "hrw",
      hwext:    "true",
      hwqe:     "true", // enable `qe` latched signal of software write pulse
      hwre:     "true",
      fields: [
        { bits: "5-1:0",
          name: "CL_TAG",
          desc: "Tag Address"
        }
      ]
    },
    {
      name:     "STATUS_1510",
      desc:     "Status register of cache line 1510",
      swaccess: "rw",
      hwaccess: "hrw",
      hwext:    "true",
      hwqe:     "true", // enable `qe` latched signal of software write pulse
      hwre:     "true",
      fields: [
        {
          bits: "5+3:5", // 2 bits for status
          name: "CL_STATUS",
          desc: "Contain the current status of the corresponding cache line                [0]: valid, [1]: dirty, [2]: cmpt",
        }
      ]
    },
    { name:     "TAG_1510",
      desc:     "Tag Address stored in cache line 1510",
      swaccess: "rw",
      hwaccess: "hrw",
      hwext:    "true",
      hwqe:     "true", // enable `qe` latched signal of software write pulse
      hwre:     "true",
      fields: [
        { bits: "5-1:0",
          name: "CL_TAG",
          desc: "Tag Address"
        }
      ]
    },
    {
      name:     "STATUS_1511",
      desc:     "Status register of cache line 1511",
      swaccess: "rw",
      hwaccess: "hrw",
      hwext:    "true",
      hwqe:     "true", // enable `qe` latched signal of software write pulse
      hwre:     "true",
      fields: [
        {
          bits: "5+3:5", // 2 bits for status
          name: "CL_STATUS",
          desc: "Contain the current status of the corresponding cache line                [0]: valid, [1]: dirty, [2]: cmpt",
        }
      ]
    },
    { name:     "TAG_1511",
      desc:     "Tag Address stored in cache line 1511",
      swaccess: "rw",
      hwaccess: "hrw",
      hwext:    "true",
      hwqe:     "true", // enable `qe` latched signal of software write pulse
      hwre:     "true",
      fields: [
        { bits: "5-1:0",
          name: "CL_TAG",
          desc: "Tag Address"
        }
      ]
    },
    {
      name:     "STATUS_1512",
      desc:     "Status register of cache line 1512",
      swaccess: "rw",
      hwaccess: "hrw",
      hwext:    "true",
      hwqe:     "true", // enable `qe` latched signal of software write pulse
      hwre:     "true",
      fields: [
        {
          bits: "5+3:5", // 2 bits for status
          name: "CL_STATUS",
          desc: "Contain the current status of the corresponding cache line                [0]: valid, [1]: dirty, [2]: cmpt",
        }
      ]
    },
    { name:     "TAG_1512",
      desc:     "Tag Address stored in cache line 1512",
      swaccess: "rw",
      hwaccess: "hrw",
      hwext:    "true",
      hwqe:     "true", // enable `qe` latched signal of software write pulse
      hwre:     "true",
      fields: [
        { bits: "5-1:0",
          name: "CL_TAG",
          desc: "Tag Address"
        }
      ]
    },
    {
      name:     "STATUS_1513",
      desc:     "Status register of cache line 1513",
      swaccess: "rw",
      hwaccess: "hrw",
      hwext:    "true",
      hwqe:     "true", // enable `qe` latched signal of software write pulse
      hwre:     "true",
      fields: [
        {
          bits: "5+3:5", // 2 bits for status
          name: "CL_STATUS",
          desc: "Contain the current status of the corresponding cache line                [0]: valid, [1]: dirty, [2]: cmpt",
        }
      ]
    },
    { name:     "TAG_1513",
      desc:     "Tag Address stored in cache line 1513",
      swaccess: "rw",
      hwaccess: "hrw",
      hwext:    "true",
      hwqe:     "true", // enable `qe` latched signal of software write pulse
      hwre:     "true",
      fields: [
        { bits: "5-1:0",
          name: "CL_TAG",
          desc: "Tag Address"
        }
      ]
    },
    {
      name:     "STATUS_1514",
      desc:     "Status register of cache line 1514",
      swaccess: "rw",
      hwaccess: "hrw",
      hwext:    "true",
      hwqe:     "true", // enable `qe` latched signal of software write pulse
      hwre:     "true",
      fields: [
        {
          bits: "5+3:5", // 2 bits for status
          name: "CL_STATUS",
          desc: "Contain the current status of the corresponding cache line                [0]: valid, [1]: dirty, [2]: cmpt",
        }
      ]
    },
    { name:     "TAG_1514",
      desc:     "Tag Address stored in cache line 1514",
      swaccess: "rw",
      hwaccess: "hrw",
      hwext:    "true",
      hwqe:     "true", // enable `qe` latched signal of software write pulse
      hwre:     "true",
      fields: [
        { bits: "5-1:0",
          name: "CL_TAG",
          desc: "Tag Address"
        }
      ]
    },
    {
      name:     "STATUS_1515",
      desc:     "Status register of cache line 1515",
      swaccess: "rw",
      hwaccess: "hrw",
      hwext:    "true",
      hwqe:     "true", // enable `qe` latched signal of software write pulse
      hwre:     "true",
      fields: [
        {
          bits: "5+3:5", // 2 bits for status
          name: "CL_STATUS",
          desc: "Contain the current status of the corresponding cache line                [0]: valid, [1]: dirty, [2]: cmpt",
        }
      ]
    },
    { name:     "TAG_1515",
      desc:     "Tag Address stored in cache line 1515",
      swaccess: "rw",
      hwaccess: "hrw",
      hwext:    "true",
      hwqe:     "true", // enable `qe` latched signal of software write pulse
      hwre:     "true",
      fields: [
        { bits: "5-1:0",
          name: "CL_TAG",
          desc: "Tag Address"
        }
      ]
    },
    {
      name:     "STATUS_1516",
      desc:     "Status register of cache line 1516",
      swaccess: "rw",
      hwaccess: "hrw",
      hwext:    "true",
      hwqe:     "true", // enable `qe` latched signal of software write pulse
      hwre:     "true",
      fields: [
        {
          bits: "5+3:5", // 2 bits for status
          name: "CL_STATUS",
          desc: "Contain the current status of the corresponding cache line                [0]: valid, [1]: dirty, [2]: cmpt",
        }
      ]
    },
    { name:     "TAG_1516",
      desc:     "Tag Address stored in cache line 1516",
      swaccess: "rw",
      hwaccess: "hrw",
      hwext:    "true",
      hwqe:     "true", // enable `qe` latched signal of software write pulse
      hwre:     "true",
      fields: [
        { bits: "5-1:0",
          name: "CL_TAG",
          desc: "Tag Address"
        }
      ]
    },
    {
      name:     "STATUS_1517",
      desc:     "Status register of cache line 1517",
      swaccess: "rw",
      hwaccess: "hrw",
      hwext:    "true",
      hwqe:     "true", // enable `qe` latched signal of software write pulse
      hwre:     "true",
      fields: [
        {
          bits: "5+3:5", // 2 bits for status
          name: "CL_STATUS",
          desc: "Contain the current status of the corresponding cache line                [0]: valid, [1]: dirty, [2]: cmpt",
        }
      ]
    },
    { name:     "TAG_1517",
      desc:     "Tag Address stored in cache line 1517",
      swaccess: "rw",
      hwaccess: "hrw",
      hwext:    "true",
      hwqe:     "true", // enable `qe` latched signal of software write pulse
      hwre:     "true",
      fields: [
        { bits: "5-1:0",
          name: "CL_TAG",
          desc: "Tag Address"
        }
      ]
    },
    {
      name:     "STATUS_1518",
      desc:     "Status register of cache line 1518",
      swaccess: "rw",
      hwaccess: "hrw",
      hwext:    "true",
      hwqe:     "true", // enable `qe` latched signal of software write pulse
      hwre:     "true",
      fields: [
        {
          bits: "5+3:5", // 2 bits for status
          name: "CL_STATUS",
          desc: "Contain the current status of the corresponding cache line                [0]: valid, [1]: dirty, [2]: cmpt",
        }
      ]
    },
    { name:     "TAG_1518",
      desc:     "Tag Address stored in cache line 1518",
      swaccess: "rw",
      hwaccess: "hrw",
      hwext:    "true",
      hwqe:     "true", // enable `qe` latched signal of software write pulse
      hwre:     "true",
      fields: [
        { bits: "5-1:0",
          name: "CL_TAG",
          desc: "Tag Address"
        }
      ]
    },
    {
      name:     "STATUS_1519",
      desc:     "Status register of cache line 1519",
      swaccess: "rw",
      hwaccess: "hrw",
      hwext:    "true",
      hwqe:     "true", // enable `qe` latched signal of software write pulse
      hwre:     "true",
      fields: [
        {
          bits: "5+3:5", // 2 bits for status
          name: "CL_STATUS",
          desc: "Contain the current status of the corresponding cache line                [0]: valid, [1]: dirty, [2]: cmpt",
        }
      ]
    },
    { name:     "TAG_1519",
      desc:     "Tag Address stored in cache line 1519",
      swaccess: "rw",
      hwaccess: "hrw",
      hwext:    "true",
      hwqe:     "true", // enable `qe` latched signal of software write pulse
      hwre:     "true",
      fields: [
        { bits: "5-1:0",
          name: "CL_TAG",
          desc: "Tag Address"
        }
      ]
    },
    {
      name:     "STATUS_1520",
      desc:     "Status register of cache line 1520",
      swaccess: "rw",
      hwaccess: "hrw",
      hwext:    "true",
      hwqe:     "true", // enable `qe` latched signal of software write pulse
      hwre:     "true",
      fields: [
        {
          bits: "5+3:5", // 2 bits for status
          name: "CL_STATUS",
          desc: "Contain the current status of the corresponding cache line                [0]: valid, [1]: dirty, [2]: cmpt",
        }
      ]
    },
    { name:     "TAG_1520",
      desc:     "Tag Address stored in cache line 1520",
      swaccess: "rw",
      hwaccess: "hrw",
      hwext:    "true",
      hwqe:     "true", // enable `qe` latched signal of software write pulse
      hwre:     "true",
      fields: [
        { bits: "5-1:0",
          name: "CL_TAG",
          desc: "Tag Address"
        }
      ]
    },
    {
      name:     "STATUS_1521",
      desc:     "Status register of cache line 1521",
      swaccess: "rw",
      hwaccess: "hrw",
      hwext:    "true",
      hwqe:     "true", // enable `qe` latched signal of software write pulse
      hwre:     "true",
      fields: [
        {
          bits: "5+3:5", // 2 bits for status
          name: "CL_STATUS",
          desc: "Contain the current status of the corresponding cache line                [0]: valid, [1]: dirty, [2]: cmpt",
        }
      ]
    },
    { name:     "TAG_1521",
      desc:     "Tag Address stored in cache line 1521",
      swaccess: "rw",
      hwaccess: "hrw",
      hwext:    "true",
      hwqe:     "true", // enable `qe` latched signal of software write pulse
      hwre:     "true",
      fields: [
        { bits: "5-1:0",
          name: "CL_TAG",
          desc: "Tag Address"
        }
      ]
    },
    {
      name:     "STATUS_1522",
      desc:     "Status register of cache line 1522",
      swaccess: "rw",
      hwaccess: "hrw",
      hwext:    "true",
      hwqe:     "true", // enable `qe` latched signal of software write pulse
      hwre:     "true",
      fields: [
        {
          bits: "5+3:5", // 2 bits for status
          name: "CL_STATUS",
          desc: "Contain the current status of the corresponding cache line                [0]: valid, [1]: dirty, [2]: cmpt",
        }
      ]
    },
    { name:     "TAG_1522",
      desc:     "Tag Address stored in cache line 1522",
      swaccess: "rw",
      hwaccess: "hrw",
      hwext:    "true",
      hwqe:     "true", // enable `qe` latched signal of software write pulse
      hwre:     "true",
      fields: [
        { bits: "5-1:0",
          name: "CL_TAG",
          desc: "Tag Address"
        }
      ]
    },
    {
      name:     "STATUS_1523",
      desc:     "Status register of cache line 1523",
      swaccess: "rw",
      hwaccess: "hrw",
      hwext:    "true",
      hwqe:     "true", // enable `qe` latched signal of software write pulse
      hwre:     "true",
      fields: [
        {
          bits: "5+3:5", // 2 bits for status
          name: "CL_STATUS",
          desc: "Contain the current status of the corresponding cache line                [0]: valid, [1]: dirty, [2]: cmpt",
        }
      ]
    },
    { name:     "TAG_1523",
      desc:     "Tag Address stored in cache line 1523",
      swaccess: "rw",
      hwaccess: "hrw",
      hwext:    "true",
      hwqe:     "true", // enable `qe` latched signal of software write pulse
      hwre:     "true",
      fields: [
        { bits: "5-1:0",
          name: "CL_TAG",
          desc: "Tag Address"
        }
      ]
    },
    {
      name:     "STATUS_1524",
      desc:     "Status register of cache line 1524",
      swaccess: "rw",
      hwaccess: "hrw",
      hwext:    "true",
      hwqe:     "true", // enable `qe` latched signal of software write pulse
      hwre:     "true",
      fields: [
        {
          bits: "5+3:5", // 2 bits for status
          name: "CL_STATUS",
          desc: "Contain the current status of the corresponding cache line                [0]: valid, [1]: dirty, [2]: cmpt",
        }
      ]
    },
    { name:     "TAG_1524",
      desc:     "Tag Address stored in cache line 1524",
      swaccess: "rw",
      hwaccess: "hrw",
      hwext:    "true",
      hwqe:     "true", // enable `qe` latched signal of software write pulse
      hwre:     "true",
      fields: [
        { bits: "5-1:0",
          name: "CL_TAG",
          desc: "Tag Address"
        }
      ]
    },
    {
      name:     "STATUS_1525",
      desc:     "Status register of cache line 1525",
      swaccess: "rw",
      hwaccess: "hrw",
      hwext:    "true",
      hwqe:     "true", // enable `qe` latched signal of software write pulse
      hwre:     "true",
      fields: [
        {
          bits: "5+3:5", // 2 bits for status
          name: "CL_STATUS",
          desc: "Contain the current status of the corresponding cache line                [0]: valid, [1]: dirty, [2]: cmpt",
        }
      ]
    },
    { name:     "TAG_1525",
      desc:     "Tag Address stored in cache line 1525",
      swaccess: "rw",
      hwaccess: "hrw",
      hwext:    "true",
      hwqe:     "true", // enable `qe` latched signal of software write pulse
      hwre:     "true",
      fields: [
        { bits: "5-1:0",
          name: "CL_TAG",
          desc: "Tag Address"
        }
      ]
    },
    {
      name:     "STATUS_1526",
      desc:     "Status register of cache line 1526",
      swaccess: "rw",
      hwaccess: "hrw",
      hwext:    "true",
      hwqe:     "true", // enable `qe` latched signal of software write pulse
      hwre:     "true",
      fields: [
        {
          bits: "5+3:5", // 2 bits for status
          name: "CL_STATUS",
          desc: "Contain the current status of the corresponding cache line                [0]: valid, [1]: dirty, [2]: cmpt",
        }
      ]
    },
    { name:     "TAG_1526",
      desc:     "Tag Address stored in cache line 1526",
      swaccess: "rw",
      hwaccess: "hrw",
      hwext:    "true",
      hwqe:     "true", // enable `qe` latched signal of software write pulse
      hwre:     "true",
      fields: [
        { bits: "5-1:0",
          name: "CL_TAG",
          desc: "Tag Address"
        }
      ]
    },
    {
      name:     "STATUS_1527",
      desc:     "Status register of cache line 1527",
      swaccess: "rw",
      hwaccess: "hrw",
      hwext:    "true",
      hwqe:     "true", // enable `qe` latched signal of software write pulse
      hwre:     "true",
      fields: [
        {
          bits: "5+3:5", // 2 bits for status
          name: "CL_STATUS",
          desc: "Contain the current status of the corresponding cache line                [0]: valid, [1]: dirty, [2]: cmpt",
        }
      ]
    },
    { name:     "TAG_1527",
      desc:     "Tag Address stored in cache line 1527",
      swaccess: "rw",
      hwaccess: "hrw",
      hwext:    "true",
      hwqe:     "true", // enable `qe` latched signal of software write pulse
      hwre:     "true",
      fields: [
        { bits: "5-1:0",
          name: "CL_TAG",
          desc: "Tag Address"
        }
      ]
    },
    {
      name:     "STATUS_1528",
      desc:     "Status register of cache line 1528",
      swaccess: "rw",
      hwaccess: "hrw",
      hwext:    "true",
      hwqe:     "true", // enable `qe` latched signal of software write pulse
      hwre:     "true",
      fields: [
        {
          bits: "5+3:5", // 2 bits for status
          name: "CL_STATUS",
          desc: "Contain the current status of the corresponding cache line                [0]: valid, [1]: dirty, [2]: cmpt",
        }
      ]
    },
    { name:     "TAG_1528",
      desc:     "Tag Address stored in cache line 1528",
      swaccess: "rw",
      hwaccess: "hrw",
      hwext:    "true",
      hwqe:     "true", // enable `qe` latched signal of software write pulse
      hwre:     "true",
      fields: [
        { bits: "5-1:0",
          name: "CL_TAG",
          desc: "Tag Address"
        }
      ]
    },
    {
      name:     "STATUS_1529",
      desc:     "Status register of cache line 1529",
      swaccess: "rw",
      hwaccess: "hrw",
      hwext:    "true",
      hwqe:     "true", // enable `qe` latched signal of software write pulse
      hwre:     "true",
      fields: [
        {
          bits: "5+3:5", // 2 bits for status
          name: "CL_STATUS",
          desc: "Contain the current status of the corresponding cache line                [0]: valid, [1]: dirty, [2]: cmpt",
        }
      ]
    },
    { name:     "TAG_1529",
      desc:     "Tag Address stored in cache line 1529",
      swaccess: "rw",
      hwaccess: "hrw",
      hwext:    "true",
      hwqe:     "true", // enable `qe` latched signal of software write pulse
      hwre:     "true",
      fields: [
        { bits: "5-1:0",
          name: "CL_TAG",
          desc: "Tag Address"
        }
      ]
    },
    {
      name:     "STATUS_1530",
      desc:     "Status register of cache line 1530",
      swaccess: "rw",
      hwaccess: "hrw",
      hwext:    "true",
      hwqe:     "true", // enable `qe` latched signal of software write pulse
      hwre:     "true",
      fields: [
        {
          bits: "5+3:5", // 2 bits for status
          name: "CL_STATUS",
          desc: "Contain the current status of the corresponding cache line                [0]: valid, [1]: dirty, [2]: cmpt",
        }
      ]
    },
    { name:     "TAG_1530",
      desc:     "Tag Address stored in cache line 1530",
      swaccess: "rw",
      hwaccess: "hrw",
      hwext:    "true",
      hwqe:     "true", // enable `qe` latched signal of software write pulse
      hwre:     "true",
      fields: [
        { bits: "5-1:0",
          name: "CL_TAG",
          desc: "Tag Address"
        }
      ]
    },
    {
      name:     "STATUS_1531",
      desc:     "Status register of cache line 1531",
      swaccess: "rw",
      hwaccess: "hrw",
      hwext:    "true",
      hwqe:     "true", // enable `qe` latched signal of software write pulse
      hwre:     "true",
      fields: [
        {
          bits: "5+3:5", // 2 bits for status
          name: "CL_STATUS",
          desc: "Contain the current status of the corresponding cache line                [0]: valid, [1]: dirty, [2]: cmpt",
        }
      ]
    },
    { name:     "TAG_1531",
      desc:     "Tag Address stored in cache line 1531",
      swaccess: "rw",
      hwaccess: "hrw",
      hwext:    "true",
      hwqe:     "true", // enable `qe` latched signal of software write pulse
      hwre:     "true",
      fields: [
        { bits: "5-1:0",
          name: "CL_TAG",
          desc: "Tag Address"
        }
      ]
    },
    {
      name:     "STATUS_1532",
      desc:     "Status register of cache line 1532",
      swaccess: "rw",
      hwaccess: "hrw",
      hwext:    "true",
      hwqe:     "true", // enable `qe` latched signal of software write pulse
      hwre:     "true",
      fields: [
        {
          bits: "5+3:5", // 2 bits for status
          name: "CL_STATUS",
          desc: "Contain the current status of the corresponding cache line                [0]: valid, [1]: dirty, [2]: cmpt",
        }
      ]
    },
    { name:     "TAG_1532",
      desc:     "Tag Address stored in cache line 1532",
      swaccess: "rw",
      hwaccess: "hrw",
      hwext:    "true",
      hwqe:     "true", // enable `qe` latched signal of software write pulse
      hwre:     "true",
      fields: [
        { bits: "5-1:0",
          name: "CL_TAG",
          desc: "Tag Address"
        }
      ]
    },
    {
      name:     "STATUS_1533",
      desc:     "Status register of cache line 1533",
      swaccess: "rw",
      hwaccess: "hrw",
      hwext:    "true",
      hwqe:     "true", // enable `qe` latched signal of software write pulse
      hwre:     "true",
      fields: [
        {
          bits: "5+3:5", // 2 bits for status
          name: "CL_STATUS",
          desc: "Contain the current status of the corresponding cache line                [0]: valid, [1]: dirty, [2]: cmpt",
        }
      ]
    },
    { name:     "TAG_1533",
      desc:     "Tag Address stored in cache line 1533",
      swaccess: "rw",
      hwaccess: "hrw",
      hwext:    "true",
      hwqe:     "true", // enable `qe` latched signal of software write pulse
      hwre:     "true",
      fields: [
        { bits: "5-1:0",
          name: "CL_TAG",
          desc: "Tag Address"
        }
      ]
    },
    {
      name:     "STATUS_1534",
      desc:     "Status register of cache line 1534",
      swaccess: "rw",
      hwaccess: "hrw",
      hwext:    "true",
      hwqe:     "true", // enable `qe` latched signal of software write pulse
      hwre:     "true",
      fields: [
        {
          bits: "5+3:5", // 2 bits for status
          name: "CL_STATUS",
          desc: "Contain the current status of the corresponding cache line                [0]: valid, [1]: dirty, [2]: cmpt",
        }
      ]
    },
    { name:     "TAG_1534",
      desc:     "Tag Address stored in cache line 1534",
      swaccess: "rw",
      hwaccess: "hrw",
      hwext:    "true",
      hwqe:     "true", // enable `qe` latched signal of software write pulse
      hwre:     "true",
      fields: [
        { bits: "5-1:0",
          name: "CL_TAG",
          desc: "Tag Address"
        }
      ]
    },
    {
      name:     "STATUS_1535",
      desc:     "Status register of cache line 1535",
      swaccess: "rw",
      hwaccess: "hrw",
      hwext:    "true",
      hwqe:     "true", // enable `qe` latched signal of software write pulse
      hwre:     "true",
      fields: [
        {
          bits: "5+3:5", // 2 bits for status
          name: "CL_STATUS",
          desc: "Contain the current status of the corresponding cache line                [0]: valid, [1]: dirty, [2]: cmpt",
        }
      ]
    },
    { name:     "TAG_1535",
      desc:     "Tag Address stored in cache line 1535",
      swaccess: "rw",
      hwaccess: "hrw",
      hwext:    "true",
      hwqe:     "true", // enable `qe` latched signal of software write pulse
      hwre:     "true",
      fields: [
        { bits: "5-1:0",
          name: "CL_TAG",
          desc: "Tag Address"
        }
      ]
    },
    {
      name:     "STATUS_1536",
      desc:     "Status register of cache line 1536",
      swaccess: "rw",
      hwaccess: "hrw",
      hwext:    "true",
      hwqe:     "true", // enable `qe` latched signal of software write pulse
      hwre:     "true",
      fields: [
        {
          bits: "5+3:5", // 2 bits for status
          name: "CL_STATUS",
          desc: "Contain the current status of the corresponding cache line                [0]: valid, [1]: dirty, [2]: cmpt",
        }
      ]
    },
    { name:     "TAG_1536",
      desc:     "Tag Address stored in cache line 1536",
      swaccess: "rw",
      hwaccess: "hrw",
      hwext:    "true",
      hwqe:     "true", // enable `qe` latched signal of software write pulse
      hwre:     "true",
      fields: [
        { bits: "5-1:0",
          name: "CL_TAG",
          desc: "Tag Address"
        }
      ]
    },
    {
      name:     "STATUS_1537",
      desc:     "Status register of cache line 1537",
      swaccess: "rw",
      hwaccess: "hrw",
      hwext:    "true",
      hwqe:     "true", // enable `qe` latched signal of software write pulse
      hwre:     "true",
      fields: [
        {
          bits: "5+3:5", // 2 bits for status
          name: "CL_STATUS",
          desc: "Contain the current status of the corresponding cache line                [0]: valid, [1]: dirty, [2]: cmpt",
        }
      ]
    },
    { name:     "TAG_1537",
      desc:     "Tag Address stored in cache line 1537",
      swaccess: "rw",
      hwaccess: "hrw",
      hwext:    "true",
      hwqe:     "true", // enable `qe` latched signal of software write pulse
      hwre:     "true",
      fields: [
        { bits: "5-1:0",
          name: "CL_TAG",
          desc: "Tag Address"
        }
      ]
    },
    {
      name:     "STATUS_1538",
      desc:     "Status register of cache line 1538",
      swaccess: "rw",
      hwaccess: "hrw",
      hwext:    "true",
      hwqe:     "true", // enable `qe` latched signal of software write pulse
      hwre:     "true",
      fields: [
        {
          bits: "5+3:5", // 2 bits for status
          name: "CL_STATUS",
          desc: "Contain the current status of the corresponding cache line                [0]: valid, [1]: dirty, [2]: cmpt",
        }
      ]
    },
    { name:     "TAG_1538",
      desc:     "Tag Address stored in cache line 1538",
      swaccess: "rw",
      hwaccess: "hrw",
      hwext:    "true",
      hwqe:     "true", // enable `qe` latched signal of software write pulse
      hwre:     "true",
      fields: [
        { bits: "5-1:0",
          name: "CL_TAG",
          desc: "Tag Address"
        }
      ]
    },
    {
      name:     "STATUS_1539",
      desc:     "Status register of cache line 1539",
      swaccess: "rw",
      hwaccess: "hrw",
      hwext:    "true",
      hwqe:     "true", // enable `qe` latched signal of software write pulse
      hwre:     "true",
      fields: [
        {
          bits: "5+3:5", // 2 bits for status
          name: "CL_STATUS",
          desc: "Contain the current status of the corresponding cache line                [0]: valid, [1]: dirty, [2]: cmpt",
        }
      ]
    },
    { name:     "TAG_1539",
      desc:     "Tag Address stored in cache line 1539",
      swaccess: "rw",
      hwaccess: "hrw",
      hwext:    "true",
      hwqe:     "true", // enable `qe` latched signal of software write pulse
      hwre:     "true",
      fields: [
        { bits: "5-1:0",
          name: "CL_TAG",
          desc: "Tag Address"
        }
      ]
    },
    {
      name:     "STATUS_1540",
      desc:     "Status register of cache line 1540",
      swaccess: "rw",
      hwaccess: "hrw",
      hwext:    "true",
      hwqe:     "true", // enable `qe` latched signal of software write pulse
      hwre:     "true",
      fields: [
        {
          bits: "5+3:5", // 2 bits for status
          name: "CL_STATUS",
          desc: "Contain the current status of the corresponding cache line                [0]: valid, [1]: dirty, [2]: cmpt",
        }
      ]
    },
    { name:     "TAG_1540",
      desc:     "Tag Address stored in cache line 1540",
      swaccess: "rw",
      hwaccess: "hrw",
      hwext:    "true",
      hwqe:     "true", // enable `qe` latched signal of software write pulse
      hwre:     "true",
      fields: [
        { bits: "5-1:0",
          name: "CL_TAG",
          desc: "Tag Address"
        }
      ]
    },
    {
      name:     "STATUS_1541",
      desc:     "Status register of cache line 1541",
      swaccess: "rw",
      hwaccess: "hrw",
      hwext:    "true",
      hwqe:     "true", // enable `qe` latched signal of software write pulse
      hwre:     "true",
      fields: [
        {
          bits: "5+3:5", // 2 bits for status
          name: "CL_STATUS",
          desc: "Contain the current status of the corresponding cache line                [0]: valid, [1]: dirty, [2]: cmpt",
        }
      ]
    },
    { name:     "TAG_1541",
      desc:     "Tag Address stored in cache line 1541",
      swaccess: "rw",
      hwaccess: "hrw",
      hwext:    "true",
      hwqe:     "true", // enable `qe` latched signal of software write pulse
      hwre:     "true",
      fields: [
        { bits: "5-1:0",
          name: "CL_TAG",
          desc: "Tag Address"
        }
      ]
    },
    {
      name:     "STATUS_1542",
      desc:     "Status register of cache line 1542",
      swaccess: "rw",
      hwaccess: "hrw",
      hwext:    "true",
      hwqe:     "true", // enable `qe` latched signal of software write pulse
      hwre:     "true",
      fields: [
        {
          bits: "5+3:5", // 2 bits for status
          name: "CL_STATUS",
          desc: "Contain the current status of the corresponding cache line                [0]: valid, [1]: dirty, [2]: cmpt",
        }
      ]
    },
    { name:     "TAG_1542",
      desc:     "Tag Address stored in cache line 1542",
      swaccess: "rw",
      hwaccess: "hrw",
      hwext:    "true",
      hwqe:     "true", // enable `qe` latched signal of software write pulse
      hwre:     "true",
      fields: [
        { bits: "5-1:0",
          name: "CL_TAG",
          desc: "Tag Address"
        }
      ]
    },
    {
      name:     "STATUS_1543",
      desc:     "Status register of cache line 1543",
      swaccess: "rw",
      hwaccess: "hrw",
      hwext:    "true",
      hwqe:     "true", // enable `qe` latched signal of software write pulse
      hwre:     "true",
      fields: [
        {
          bits: "5+3:5", // 2 bits for status
          name: "CL_STATUS",
          desc: "Contain the current status of the corresponding cache line                [0]: valid, [1]: dirty, [2]: cmpt",
        }
      ]
    },
    { name:     "TAG_1543",
      desc:     "Tag Address stored in cache line 1543",
      swaccess: "rw",
      hwaccess: "hrw",
      hwext:    "true",
      hwqe:     "true", // enable `qe` latched signal of software write pulse
      hwre:     "true",
      fields: [
        { bits: "5-1:0",
          name: "CL_TAG",
          desc: "Tag Address"
        }
      ]
    },
    {
      name:     "STATUS_1544",
      desc:     "Status register of cache line 1544",
      swaccess: "rw",
      hwaccess: "hrw",
      hwext:    "true",
      hwqe:     "true", // enable `qe` latched signal of software write pulse
      hwre:     "true",
      fields: [
        {
          bits: "5+3:5", // 2 bits for status
          name: "CL_STATUS",
          desc: "Contain the current status of the corresponding cache line                [0]: valid, [1]: dirty, [2]: cmpt",
        }
      ]
    },
    { name:     "TAG_1544",
      desc:     "Tag Address stored in cache line 1544",
      swaccess: "rw",
      hwaccess: "hrw",
      hwext:    "true",
      hwqe:     "true", // enable `qe` latched signal of software write pulse
      hwre:     "true",
      fields: [
        { bits: "5-1:0",
          name: "CL_TAG",
          desc: "Tag Address"
        }
      ]
    },
    {
      name:     "STATUS_1545",
      desc:     "Status register of cache line 1545",
      swaccess: "rw",
      hwaccess: "hrw",
      hwext:    "true",
      hwqe:     "true", // enable `qe` latched signal of software write pulse
      hwre:     "true",
      fields: [
        {
          bits: "5+3:5", // 2 bits for status
          name: "CL_STATUS",
          desc: "Contain the current status of the corresponding cache line                [0]: valid, [1]: dirty, [2]: cmpt",
        }
      ]
    },
    { name:     "TAG_1545",
      desc:     "Tag Address stored in cache line 1545",
      swaccess: "rw",
      hwaccess: "hrw",
      hwext:    "true",
      hwqe:     "true", // enable `qe` latched signal of software write pulse
      hwre:     "true",
      fields: [
        { bits: "5-1:0",
          name: "CL_TAG",
          desc: "Tag Address"
        }
      ]
    },
    {
      name:     "STATUS_1546",
      desc:     "Status register of cache line 1546",
      swaccess: "rw",
      hwaccess: "hrw",
      hwext:    "true",
      hwqe:     "true", // enable `qe` latched signal of software write pulse
      hwre:     "true",
      fields: [
        {
          bits: "5+3:5", // 2 bits for status
          name: "CL_STATUS",
          desc: "Contain the current status of the corresponding cache line                [0]: valid, [1]: dirty, [2]: cmpt",
        }
      ]
    },
    { name:     "TAG_1546",
      desc:     "Tag Address stored in cache line 1546",
      swaccess: "rw",
      hwaccess: "hrw",
      hwext:    "true",
      hwqe:     "true", // enable `qe` latched signal of software write pulse
      hwre:     "true",
      fields: [
        { bits: "5-1:0",
          name: "CL_TAG",
          desc: "Tag Address"
        }
      ]
    },
    {
      name:     "STATUS_1547",
      desc:     "Status register of cache line 1547",
      swaccess: "rw",
      hwaccess: "hrw",
      hwext:    "true",
      hwqe:     "true", // enable `qe` latched signal of software write pulse
      hwre:     "true",
      fields: [
        {
          bits: "5+3:5", // 2 bits for status
          name: "CL_STATUS",
          desc: "Contain the current status of the corresponding cache line                [0]: valid, [1]: dirty, [2]: cmpt",
        }
      ]
    },
    { name:     "TAG_1547",
      desc:     "Tag Address stored in cache line 1547",
      swaccess: "rw",
      hwaccess: "hrw",
      hwext:    "true",
      hwqe:     "true", // enable `qe` latched signal of software write pulse
      hwre:     "true",
      fields: [
        { bits: "5-1:0",
          name: "CL_TAG",
          desc: "Tag Address"
        }
      ]
    },
    {
      name:     "STATUS_1548",
      desc:     "Status register of cache line 1548",
      swaccess: "rw",
      hwaccess: "hrw",
      hwext:    "true",
      hwqe:     "true", // enable `qe` latched signal of software write pulse
      hwre:     "true",
      fields: [
        {
          bits: "5+3:5", // 2 bits for status
          name: "CL_STATUS",
          desc: "Contain the current status of the corresponding cache line                [0]: valid, [1]: dirty, [2]: cmpt",
        }
      ]
    },
    { name:     "TAG_1548",
      desc:     "Tag Address stored in cache line 1548",
      swaccess: "rw",
      hwaccess: "hrw",
      hwext:    "true",
      hwqe:     "true", // enable `qe` latched signal of software write pulse
      hwre:     "true",
      fields: [
        { bits: "5-1:0",
          name: "CL_TAG",
          desc: "Tag Address"
        }
      ]
    },
    {
      name:     "STATUS_1549",
      desc:     "Status register of cache line 1549",
      swaccess: "rw",
      hwaccess: "hrw",
      hwext:    "true",
      hwqe:     "true", // enable `qe` latched signal of software write pulse
      hwre:     "true",
      fields: [
        {
          bits: "5+3:5", // 2 bits for status
          name: "CL_STATUS",
          desc: "Contain the current status of the corresponding cache line                [0]: valid, [1]: dirty, [2]: cmpt",
        }
      ]
    },
    { name:     "TAG_1549",
      desc:     "Tag Address stored in cache line 1549",
      swaccess: "rw",
      hwaccess: "hrw",
      hwext:    "true",
      hwqe:     "true", // enable `qe` latched signal of software write pulse
      hwre:     "true",
      fields: [
        { bits: "5-1:0",
          name: "CL_TAG",
          desc: "Tag Address"
        }
      ]
    },
    {
      name:     "STATUS_1550",
      desc:     "Status register of cache line 1550",
      swaccess: "rw",
      hwaccess: "hrw",
      hwext:    "true",
      hwqe:     "true", // enable `qe` latched signal of software write pulse
      hwre:     "true",
      fields: [
        {
          bits: "5+3:5", // 2 bits for status
          name: "CL_STATUS",
          desc: "Contain the current status of the corresponding cache line                [0]: valid, [1]: dirty, [2]: cmpt",
        }
      ]
    },
    { name:     "TAG_1550",
      desc:     "Tag Address stored in cache line 1550",
      swaccess: "rw",
      hwaccess: "hrw",
      hwext:    "true",
      hwqe:     "true", // enable `qe` latched signal of software write pulse
      hwre:     "true",
      fields: [
        { bits: "5-1:0",
          name: "CL_TAG",
          desc: "Tag Address"
        }
      ]
    },
    {
      name:     "STATUS_1551",
      desc:     "Status register of cache line 1551",
      swaccess: "rw",
      hwaccess: "hrw",
      hwext:    "true",
      hwqe:     "true", // enable `qe` latched signal of software write pulse
      hwre:     "true",
      fields: [
        {
          bits: "5+3:5", // 2 bits for status
          name: "CL_STATUS",
          desc: "Contain the current status of the corresponding cache line                [0]: valid, [1]: dirty, [2]: cmpt",
        }
      ]
    },
    { name:     "TAG_1551",
      desc:     "Tag Address stored in cache line 1551",
      swaccess: "rw",
      hwaccess: "hrw",
      hwext:    "true",
      hwqe:     "true", // enable `qe` latched signal of software write pulse
      hwre:     "true",
      fields: [
        { bits: "5-1:0",
          name: "CL_TAG",
          desc: "Tag Address"
        }
      ]
    },
    {
      name:     "STATUS_1552",
      desc:     "Status register of cache line 1552",
      swaccess: "rw",
      hwaccess: "hrw",
      hwext:    "true",
      hwqe:     "true", // enable `qe` latched signal of software write pulse
      hwre:     "true",
      fields: [
        {
          bits: "5+3:5", // 2 bits for status
          name: "CL_STATUS",
          desc: "Contain the current status of the corresponding cache line                [0]: valid, [1]: dirty, [2]: cmpt",
        }
      ]
    },
    { name:     "TAG_1552",
      desc:     "Tag Address stored in cache line 1552",
      swaccess: "rw",
      hwaccess: "hrw",
      hwext:    "true",
      hwqe:     "true", // enable `qe` latched signal of software write pulse
      hwre:     "true",
      fields: [
        { bits: "5-1:0",
          name: "CL_TAG",
          desc: "Tag Address"
        }
      ]
    },
    {
      name:     "STATUS_1553",
      desc:     "Status register of cache line 1553",
      swaccess: "rw",
      hwaccess: "hrw",
      hwext:    "true",
      hwqe:     "true", // enable `qe` latched signal of software write pulse
      hwre:     "true",
      fields: [
        {
          bits: "5+3:5", // 2 bits for status
          name: "CL_STATUS",
          desc: "Contain the current status of the corresponding cache line                [0]: valid, [1]: dirty, [2]: cmpt",
        }
      ]
    },
    { name:     "TAG_1553",
      desc:     "Tag Address stored in cache line 1553",
      swaccess: "rw",
      hwaccess: "hrw",
      hwext:    "true",
      hwqe:     "true", // enable `qe` latched signal of software write pulse
      hwre:     "true",
      fields: [
        { bits: "5-1:0",
          name: "CL_TAG",
          desc: "Tag Address"
        }
      ]
    },
    {
      name:     "STATUS_1554",
      desc:     "Status register of cache line 1554",
      swaccess: "rw",
      hwaccess: "hrw",
      hwext:    "true",
      hwqe:     "true", // enable `qe` latched signal of software write pulse
      hwre:     "true",
      fields: [
        {
          bits: "5+3:5", // 2 bits for status
          name: "CL_STATUS",
          desc: "Contain the current status of the corresponding cache line                [0]: valid, [1]: dirty, [2]: cmpt",
        }
      ]
    },
    { name:     "TAG_1554",
      desc:     "Tag Address stored in cache line 1554",
      swaccess: "rw",
      hwaccess: "hrw",
      hwext:    "true",
      hwqe:     "true", // enable `qe` latched signal of software write pulse
      hwre:     "true",
      fields: [
        { bits: "5-1:0",
          name: "CL_TAG",
          desc: "Tag Address"
        }
      ]
    },
    {
      name:     "STATUS_1555",
      desc:     "Status register of cache line 1555",
      swaccess: "rw",
      hwaccess: "hrw",
      hwext:    "true",
      hwqe:     "true", // enable `qe` latched signal of software write pulse
      hwre:     "true",
      fields: [
        {
          bits: "5+3:5", // 2 bits for status
          name: "CL_STATUS",
          desc: "Contain the current status of the corresponding cache line                [0]: valid, [1]: dirty, [2]: cmpt",
        }
      ]
    },
    { name:     "TAG_1555",
      desc:     "Tag Address stored in cache line 1555",
      swaccess: "rw",
      hwaccess: "hrw",
      hwext:    "true",
      hwqe:     "true", // enable `qe` latched signal of software write pulse
      hwre:     "true",
      fields: [
        { bits: "5-1:0",
          name: "CL_TAG",
          desc: "Tag Address"
        }
      ]
    },
    {
      name:     "STATUS_1556",
      desc:     "Status register of cache line 1556",
      swaccess: "rw",
      hwaccess: "hrw",
      hwext:    "true",
      hwqe:     "true", // enable `qe` latched signal of software write pulse
      hwre:     "true",
      fields: [
        {
          bits: "5+3:5", // 2 bits for status
          name: "CL_STATUS",
          desc: "Contain the current status of the corresponding cache line                [0]: valid, [1]: dirty, [2]: cmpt",
        }
      ]
    },
    { name:     "TAG_1556",
      desc:     "Tag Address stored in cache line 1556",
      swaccess: "rw",
      hwaccess: "hrw",
      hwext:    "true",
      hwqe:     "true", // enable `qe` latched signal of software write pulse
      hwre:     "true",
      fields: [
        { bits: "5-1:0",
          name: "CL_TAG",
          desc: "Tag Address"
        }
      ]
    },
    {
      name:     "STATUS_1557",
      desc:     "Status register of cache line 1557",
      swaccess: "rw",
      hwaccess: "hrw",
      hwext:    "true",
      hwqe:     "true", // enable `qe` latched signal of software write pulse
      hwre:     "true",
      fields: [
        {
          bits: "5+3:5", // 2 bits for status
          name: "CL_STATUS",
          desc: "Contain the current status of the corresponding cache line                [0]: valid, [1]: dirty, [2]: cmpt",
        }
      ]
    },
    { name:     "TAG_1557",
      desc:     "Tag Address stored in cache line 1557",
      swaccess: "rw",
      hwaccess: "hrw",
      hwext:    "true",
      hwqe:     "true", // enable `qe` latched signal of software write pulse
      hwre:     "true",
      fields: [
        { bits: "5-1:0",
          name: "CL_TAG",
          desc: "Tag Address"
        }
      ]
    },
    {
      name:     "STATUS_1558",
      desc:     "Status register of cache line 1558",
      swaccess: "rw",
      hwaccess: "hrw",
      hwext:    "true",
      hwqe:     "true", // enable `qe` latched signal of software write pulse
      hwre:     "true",
      fields: [
        {
          bits: "5+3:5", // 2 bits for status
          name: "CL_STATUS",
          desc: "Contain the current status of the corresponding cache line                [0]: valid, [1]: dirty, [2]: cmpt",
        }
      ]
    },
    { name:     "TAG_1558",
      desc:     "Tag Address stored in cache line 1558",
      swaccess: "rw",
      hwaccess: "hrw",
      hwext:    "true",
      hwqe:     "true", // enable `qe` latched signal of software write pulse
      hwre:     "true",
      fields: [
        { bits: "5-1:0",
          name: "CL_TAG",
          desc: "Tag Address"
        }
      ]
    },
    {
      name:     "STATUS_1559",
      desc:     "Status register of cache line 1559",
      swaccess: "rw",
      hwaccess: "hrw",
      hwext:    "true",
      hwqe:     "true", // enable `qe` latched signal of software write pulse
      hwre:     "true",
      fields: [
        {
          bits: "5+3:5", // 2 bits for status
          name: "CL_STATUS",
          desc: "Contain the current status of the corresponding cache line                [0]: valid, [1]: dirty, [2]: cmpt",
        }
      ]
    },
    { name:     "TAG_1559",
      desc:     "Tag Address stored in cache line 1559",
      swaccess: "rw",
      hwaccess: "hrw",
      hwext:    "true",
      hwqe:     "true", // enable `qe` latched signal of software write pulse
      hwre:     "true",
      fields: [
        { bits: "5-1:0",
          name: "CL_TAG",
          desc: "Tag Address"
        }
      ]
    },
    {
      name:     "STATUS_1560",
      desc:     "Status register of cache line 1560",
      swaccess: "rw",
      hwaccess: "hrw",
      hwext:    "true",
      hwqe:     "true", // enable `qe` latched signal of software write pulse
      hwre:     "true",
      fields: [
        {
          bits: "5+3:5", // 2 bits for status
          name: "CL_STATUS",
          desc: "Contain the current status of the corresponding cache line                [0]: valid, [1]: dirty, [2]: cmpt",
        }
      ]
    },
    { name:     "TAG_1560",
      desc:     "Tag Address stored in cache line 1560",
      swaccess: "rw",
      hwaccess: "hrw",
      hwext:    "true",
      hwqe:     "true", // enable `qe` latched signal of software write pulse
      hwre:     "true",
      fields: [
        { bits: "5-1:0",
          name: "CL_TAG",
          desc: "Tag Address"
        }
      ]
    },
    {
      name:     "STATUS_1561",
      desc:     "Status register of cache line 1561",
      swaccess: "rw",
      hwaccess: "hrw",
      hwext:    "true",
      hwqe:     "true", // enable `qe` latched signal of software write pulse
      hwre:     "true",
      fields: [
        {
          bits: "5+3:5", // 2 bits for status
          name: "CL_STATUS",
          desc: "Contain the current status of the corresponding cache line                [0]: valid, [1]: dirty, [2]: cmpt",
        }
      ]
    },
    { name:     "TAG_1561",
      desc:     "Tag Address stored in cache line 1561",
      swaccess: "rw",
      hwaccess: "hrw",
      hwext:    "true",
      hwqe:     "true", // enable `qe` latched signal of software write pulse
      hwre:     "true",
      fields: [
        { bits: "5-1:0",
          name: "CL_TAG",
          desc: "Tag Address"
        }
      ]
    },
    {
      name:     "STATUS_1562",
      desc:     "Status register of cache line 1562",
      swaccess: "rw",
      hwaccess: "hrw",
      hwext:    "true",
      hwqe:     "true", // enable `qe` latched signal of software write pulse
      hwre:     "true",
      fields: [
        {
          bits: "5+3:5", // 2 bits for status
          name: "CL_STATUS",
          desc: "Contain the current status of the corresponding cache line                [0]: valid, [1]: dirty, [2]: cmpt",
        }
      ]
    },
    { name:     "TAG_1562",
      desc:     "Tag Address stored in cache line 1562",
      swaccess: "rw",
      hwaccess: "hrw",
      hwext:    "true",
      hwqe:     "true", // enable `qe` latched signal of software write pulse
      hwre:     "true",
      fields: [
        { bits: "5-1:0",
          name: "CL_TAG",
          desc: "Tag Address"
        }
      ]
    },
    {
      name:     "STATUS_1563",
      desc:     "Status register of cache line 1563",
      swaccess: "rw",
      hwaccess: "hrw",
      hwext:    "true",
      hwqe:     "true", // enable `qe` latched signal of software write pulse
      hwre:     "true",
      fields: [
        {
          bits: "5+3:5", // 2 bits for status
          name: "CL_STATUS",
          desc: "Contain the current status of the corresponding cache line                [0]: valid, [1]: dirty, [2]: cmpt",
        }
      ]
    },
    { name:     "TAG_1563",
      desc:     "Tag Address stored in cache line 1563",
      swaccess: "rw",
      hwaccess: "hrw",
      hwext:    "true",
      hwqe:     "true", // enable `qe` latched signal of software write pulse
      hwre:     "true",
      fields: [
        { bits: "5-1:0",
          name: "CL_TAG",
          desc: "Tag Address"
        }
      ]
    },
    {
      name:     "STATUS_1564",
      desc:     "Status register of cache line 1564",
      swaccess: "rw",
      hwaccess: "hrw",
      hwext:    "true",
      hwqe:     "true", // enable `qe` latched signal of software write pulse
      hwre:     "true",
      fields: [
        {
          bits: "5+3:5", // 2 bits for status
          name: "CL_STATUS",
          desc: "Contain the current status of the corresponding cache line                [0]: valid, [1]: dirty, [2]: cmpt",
        }
      ]
    },
    { name:     "TAG_1564",
      desc:     "Tag Address stored in cache line 1564",
      swaccess: "rw",
      hwaccess: "hrw",
      hwext:    "true",
      hwqe:     "true", // enable `qe` latched signal of software write pulse
      hwre:     "true",
      fields: [
        { bits: "5-1:0",
          name: "CL_TAG",
          desc: "Tag Address"
        }
      ]
    },
    {
      name:     "STATUS_1565",
      desc:     "Status register of cache line 1565",
      swaccess: "rw",
      hwaccess: "hrw",
      hwext:    "true",
      hwqe:     "true", // enable `qe` latched signal of software write pulse
      hwre:     "true",
      fields: [
        {
          bits: "5+3:5", // 2 bits for status
          name: "CL_STATUS",
          desc: "Contain the current status of the corresponding cache line                [0]: valid, [1]: dirty, [2]: cmpt",
        }
      ]
    },
    { name:     "TAG_1565",
      desc:     "Tag Address stored in cache line 1565",
      swaccess: "rw",
      hwaccess: "hrw",
      hwext:    "true",
      hwqe:     "true", // enable `qe` latched signal of software write pulse
      hwre:     "true",
      fields: [
        { bits: "5-1:0",
          name: "CL_TAG",
          desc: "Tag Address"
        }
      ]
    },
    {
      name:     "STATUS_1566",
      desc:     "Status register of cache line 1566",
      swaccess: "rw",
      hwaccess: "hrw",
      hwext:    "true",
      hwqe:     "true", // enable `qe` latched signal of software write pulse
      hwre:     "true",
      fields: [
        {
          bits: "5+3:5", // 2 bits for status
          name: "CL_STATUS",
          desc: "Contain the current status of the corresponding cache line                [0]: valid, [1]: dirty, [2]: cmpt",
        }
      ]
    },
    { name:     "TAG_1566",
      desc:     "Tag Address stored in cache line 1566",
      swaccess: "rw",
      hwaccess: "hrw",
      hwext:    "true",
      hwqe:     "true", // enable `qe` latched signal of software write pulse
      hwre:     "true",
      fields: [
        { bits: "5-1:0",
          name: "CL_TAG",
          desc: "Tag Address"
        }
      ]
    },
    {
      name:     "STATUS_1567",
      desc:     "Status register of cache line 1567",
      swaccess: "rw",
      hwaccess: "hrw",
      hwext:    "true",
      hwqe:     "true", // enable `qe` latched signal of software write pulse
      hwre:     "true",
      fields: [
        {
          bits: "5+3:5", // 2 bits for status
          name: "CL_STATUS",
          desc: "Contain the current status of the corresponding cache line                [0]: valid, [1]: dirty, [2]: cmpt",
        }
      ]
    },
    { name:     "TAG_1567",
      desc:     "Tag Address stored in cache line 1567",
      swaccess: "rw",
      hwaccess: "hrw",
      hwext:    "true",
      hwqe:     "true", // enable `qe` latched signal of software write pulse
      hwre:     "true",
      fields: [
        { bits: "5-1:0",
          name: "CL_TAG",
          desc: "Tag Address"
        }
      ]
    },
    {
      name:     "STATUS_1568",
      desc:     "Status register of cache line 1568",
      swaccess: "rw",
      hwaccess: "hrw",
      hwext:    "true",
      hwqe:     "true", // enable `qe` latched signal of software write pulse
      hwre:     "true",
      fields: [
        {
          bits: "5+3:5", // 2 bits for status
          name: "CL_STATUS",
          desc: "Contain the current status of the corresponding cache line                [0]: valid, [1]: dirty, [2]: cmpt",
        }
      ]
    },
    { name:     "TAG_1568",
      desc:     "Tag Address stored in cache line 1568",
      swaccess: "rw",
      hwaccess: "hrw",
      hwext:    "true",
      hwqe:     "true", // enable `qe` latched signal of software write pulse
      hwre:     "true",
      fields: [
        { bits: "5-1:0",
          name: "CL_TAG",
          desc: "Tag Address"
        }
      ]
    },
    {
      name:     "STATUS_1569",
      desc:     "Status register of cache line 1569",
      swaccess: "rw",
      hwaccess: "hrw",
      hwext:    "true",
      hwqe:     "true", // enable `qe` latched signal of software write pulse
      hwre:     "true",
      fields: [
        {
          bits: "5+3:5", // 2 bits for status
          name: "CL_STATUS",
          desc: "Contain the current status of the corresponding cache line                [0]: valid, [1]: dirty, [2]: cmpt",
        }
      ]
    },
    { name:     "TAG_1569",
      desc:     "Tag Address stored in cache line 1569",
      swaccess: "rw",
      hwaccess: "hrw",
      hwext:    "true",
      hwqe:     "true", // enable `qe` latched signal of software write pulse
      hwre:     "true",
      fields: [
        { bits: "5-1:0",
          name: "CL_TAG",
          desc: "Tag Address"
        }
      ]
    },
    {
      name:     "STATUS_1570",
      desc:     "Status register of cache line 1570",
      swaccess: "rw",
      hwaccess: "hrw",
      hwext:    "true",
      hwqe:     "true", // enable `qe` latched signal of software write pulse
      hwre:     "true",
      fields: [
        {
          bits: "5+3:5", // 2 bits for status
          name: "CL_STATUS",
          desc: "Contain the current status of the corresponding cache line                [0]: valid, [1]: dirty, [2]: cmpt",
        }
      ]
    },
    { name:     "TAG_1570",
      desc:     "Tag Address stored in cache line 1570",
      swaccess: "rw",
      hwaccess: "hrw",
      hwext:    "true",
      hwqe:     "true", // enable `qe` latched signal of software write pulse
      hwre:     "true",
      fields: [
        { bits: "5-1:0",
          name: "CL_TAG",
          desc: "Tag Address"
        }
      ]
    },
    {
      name:     "STATUS_1571",
      desc:     "Status register of cache line 1571",
      swaccess: "rw",
      hwaccess: "hrw",
      hwext:    "true",
      hwqe:     "true", // enable `qe` latched signal of software write pulse
      hwre:     "true",
      fields: [
        {
          bits: "5+3:5", // 2 bits for status
          name: "CL_STATUS",
          desc: "Contain the current status of the corresponding cache line                [0]: valid, [1]: dirty, [2]: cmpt",
        }
      ]
    },
    { name:     "TAG_1571",
      desc:     "Tag Address stored in cache line 1571",
      swaccess: "rw",
      hwaccess: "hrw",
      hwext:    "true",
      hwqe:     "true", // enable `qe` latched signal of software write pulse
      hwre:     "true",
      fields: [
        { bits: "5-1:0",
          name: "CL_TAG",
          desc: "Tag Address"
        }
      ]
    },
    {
      name:     "STATUS_1572",
      desc:     "Status register of cache line 1572",
      swaccess: "rw",
      hwaccess: "hrw",
      hwext:    "true",
      hwqe:     "true", // enable `qe` latched signal of software write pulse
      hwre:     "true",
      fields: [
        {
          bits: "5+3:5", // 2 bits for status
          name: "CL_STATUS",
          desc: "Contain the current status of the corresponding cache line                [0]: valid, [1]: dirty, [2]: cmpt",
        }
      ]
    },
    { name:     "TAG_1572",
      desc:     "Tag Address stored in cache line 1572",
      swaccess: "rw",
      hwaccess: "hrw",
      hwext:    "true",
      hwqe:     "true", // enable `qe` latched signal of software write pulse
      hwre:     "true",
      fields: [
        { bits: "5-1:0",
          name: "CL_TAG",
          desc: "Tag Address"
        }
      ]
    },
    {
      name:     "STATUS_1573",
      desc:     "Status register of cache line 1573",
      swaccess: "rw",
      hwaccess: "hrw",
      hwext:    "true",
      hwqe:     "true", // enable `qe` latched signal of software write pulse
      hwre:     "true",
      fields: [
        {
          bits: "5+3:5", // 2 bits for status
          name: "CL_STATUS",
          desc: "Contain the current status of the corresponding cache line                [0]: valid, [1]: dirty, [2]: cmpt",
        }
      ]
    },
    { name:     "TAG_1573",
      desc:     "Tag Address stored in cache line 1573",
      swaccess: "rw",
      hwaccess: "hrw",
      hwext:    "true",
      hwqe:     "true", // enable `qe` latched signal of software write pulse
      hwre:     "true",
      fields: [
        { bits: "5-1:0",
          name: "CL_TAG",
          desc: "Tag Address"
        }
      ]
    },
    {
      name:     "STATUS_1574",
      desc:     "Status register of cache line 1574",
      swaccess: "rw",
      hwaccess: "hrw",
      hwext:    "true",
      hwqe:     "true", // enable `qe` latched signal of software write pulse
      hwre:     "true",
      fields: [
        {
          bits: "5+3:5", // 2 bits for status
          name: "CL_STATUS",
          desc: "Contain the current status of the corresponding cache line                [0]: valid, [1]: dirty, [2]: cmpt",
        }
      ]
    },
    { name:     "TAG_1574",
      desc:     "Tag Address stored in cache line 1574",
      swaccess: "rw",
      hwaccess: "hrw",
      hwext:    "true",
      hwqe:     "true", // enable `qe` latched signal of software write pulse
      hwre:     "true",
      fields: [
        { bits: "5-1:0",
          name: "CL_TAG",
          desc: "Tag Address"
        }
      ]
    },
    {
      name:     "STATUS_1575",
      desc:     "Status register of cache line 1575",
      swaccess: "rw",
      hwaccess: "hrw",
      hwext:    "true",
      hwqe:     "true", // enable `qe` latched signal of software write pulse
      hwre:     "true",
      fields: [
        {
          bits: "5+3:5", // 2 bits for status
          name: "CL_STATUS",
          desc: "Contain the current status of the corresponding cache line                [0]: valid, [1]: dirty, [2]: cmpt",
        }
      ]
    },
    { name:     "TAG_1575",
      desc:     "Tag Address stored in cache line 1575",
      swaccess: "rw",
      hwaccess: "hrw",
      hwext:    "true",
      hwqe:     "true", // enable `qe` latched signal of software write pulse
      hwre:     "true",
      fields: [
        { bits: "5-1:0",
          name: "CL_TAG",
          desc: "Tag Address"
        }
      ]
    },
    {
      name:     "STATUS_1576",
      desc:     "Status register of cache line 1576",
      swaccess: "rw",
      hwaccess: "hrw",
      hwext:    "true",
      hwqe:     "true", // enable `qe` latched signal of software write pulse
      hwre:     "true",
      fields: [
        {
          bits: "5+3:5", // 2 bits for status
          name: "CL_STATUS",
          desc: "Contain the current status of the corresponding cache line                [0]: valid, [1]: dirty, [2]: cmpt",
        }
      ]
    },
    { name:     "TAG_1576",
      desc:     "Tag Address stored in cache line 1576",
      swaccess: "rw",
      hwaccess: "hrw",
      hwext:    "true",
      hwqe:     "true", // enable `qe` latched signal of software write pulse
      hwre:     "true",
      fields: [
        { bits: "5-1:0",
          name: "CL_TAG",
          desc: "Tag Address"
        }
      ]
    },
    {
      name:     "STATUS_1577",
      desc:     "Status register of cache line 1577",
      swaccess: "rw",
      hwaccess: "hrw",
      hwext:    "true",
      hwqe:     "true", // enable `qe` latched signal of software write pulse
      hwre:     "true",
      fields: [
        {
          bits: "5+3:5", // 2 bits for status
          name: "CL_STATUS",
          desc: "Contain the current status of the corresponding cache line                [0]: valid, [1]: dirty, [2]: cmpt",
        }
      ]
    },
    { name:     "TAG_1577",
      desc:     "Tag Address stored in cache line 1577",
      swaccess: "rw",
      hwaccess: "hrw",
      hwext:    "true",
      hwqe:     "true", // enable `qe` latched signal of software write pulse
      hwre:     "true",
      fields: [
        { bits: "5-1:0",
          name: "CL_TAG",
          desc: "Tag Address"
        }
      ]
    },
    {
      name:     "STATUS_1578",
      desc:     "Status register of cache line 1578",
      swaccess: "rw",
      hwaccess: "hrw",
      hwext:    "true",
      hwqe:     "true", // enable `qe` latched signal of software write pulse
      hwre:     "true",
      fields: [
        {
          bits: "5+3:5", // 2 bits for status
          name: "CL_STATUS",
          desc: "Contain the current status of the corresponding cache line                [0]: valid, [1]: dirty, [2]: cmpt",
        }
      ]
    },
    { name:     "TAG_1578",
      desc:     "Tag Address stored in cache line 1578",
      swaccess: "rw",
      hwaccess: "hrw",
      hwext:    "true",
      hwqe:     "true", // enable `qe` latched signal of software write pulse
      hwre:     "true",
      fields: [
        { bits: "5-1:0",
          name: "CL_TAG",
          desc: "Tag Address"
        }
      ]
    },
    {
      name:     "STATUS_1579",
      desc:     "Status register of cache line 1579",
      swaccess: "rw",
      hwaccess: "hrw",
      hwext:    "true",
      hwqe:     "true", // enable `qe` latched signal of software write pulse
      hwre:     "true",
      fields: [
        {
          bits: "5+3:5", // 2 bits for status
          name: "CL_STATUS",
          desc: "Contain the current status of the corresponding cache line                [0]: valid, [1]: dirty, [2]: cmpt",
        }
      ]
    },
    { name:     "TAG_1579",
      desc:     "Tag Address stored in cache line 1579",
      swaccess: "rw",
      hwaccess: "hrw",
      hwext:    "true",
      hwqe:     "true", // enable `qe` latched signal of software write pulse
      hwre:     "true",
      fields: [
        { bits: "5-1:0",
          name: "CL_TAG",
          desc: "Tag Address"
        }
      ]
    },
    {
      name:     "STATUS_1580",
      desc:     "Status register of cache line 1580",
      swaccess: "rw",
      hwaccess: "hrw",
      hwext:    "true",
      hwqe:     "true", // enable `qe` latched signal of software write pulse
      hwre:     "true",
      fields: [
        {
          bits: "5+3:5", // 2 bits for status
          name: "CL_STATUS",
          desc: "Contain the current status of the corresponding cache line                [0]: valid, [1]: dirty, [2]: cmpt",
        }
      ]
    },
    { name:     "TAG_1580",
      desc:     "Tag Address stored in cache line 1580",
      swaccess: "rw",
      hwaccess: "hrw",
      hwext:    "true",
      hwqe:     "true", // enable `qe` latched signal of software write pulse
      hwre:     "true",
      fields: [
        { bits: "5-1:0",
          name: "CL_TAG",
          desc: "Tag Address"
        }
      ]
    },
    {
      name:     "STATUS_1581",
      desc:     "Status register of cache line 1581",
      swaccess: "rw",
      hwaccess: "hrw",
      hwext:    "true",
      hwqe:     "true", // enable `qe` latched signal of software write pulse
      hwre:     "true",
      fields: [
        {
          bits: "5+3:5", // 2 bits for status
          name: "CL_STATUS",
          desc: "Contain the current status of the corresponding cache line                [0]: valid, [1]: dirty, [2]: cmpt",
        }
      ]
    },
    { name:     "TAG_1581",
      desc:     "Tag Address stored in cache line 1581",
      swaccess: "rw",
      hwaccess: "hrw",
      hwext:    "true",
      hwqe:     "true", // enable `qe` latched signal of software write pulse
      hwre:     "true",
      fields: [
        { bits: "5-1:0",
          name: "CL_TAG",
          desc: "Tag Address"
        }
      ]
    },
    {
      name:     "STATUS_1582",
      desc:     "Status register of cache line 1582",
      swaccess: "rw",
      hwaccess: "hrw",
      hwext:    "true",
      hwqe:     "true", // enable `qe` latched signal of software write pulse
      hwre:     "true",
      fields: [
        {
          bits: "5+3:5", // 2 bits for status
          name: "CL_STATUS",
          desc: "Contain the current status of the corresponding cache line                [0]: valid, [1]: dirty, [2]: cmpt",
        }
      ]
    },
    { name:     "TAG_1582",
      desc:     "Tag Address stored in cache line 1582",
      swaccess: "rw",
      hwaccess: "hrw",
      hwext:    "true",
      hwqe:     "true", // enable `qe` latched signal of software write pulse
      hwre:     "true",
      fields: [
        { bits: "5-1:0",
          name: "CL_TAG",
          desc: "Tag Address"
        }
      ]
    },
    {
      name:     "STATUS_1583",
      desc:     "Status register of cache line 1583",
      swaccess: "rw",
      hwaccess: "hrw",
      hwext:    "true",
      hwqe:     "true", // enable `qe` latched signal of software write pulse
      hwre:     "true",
      fields: [
        {
          bits: "5+3:5", // 2 bits for status
          name: "CL_STATUS",
          desc: "Contain the current status of the corresponding cache line                [0]: valid, [1]: dirty, [2]: cmpt",
        }
      ]
    },
    { name:     "TAG_1583",
      desc:     "Tag Address stored in cache line 1583",
      swaccess: "rw",
      hwaccess: "hrw",
      hwext:    "true",
      hwqe:     "true", // enable `qe` latched signal of software write pulse
      hwre:     "true",
      fields: [
        { bits: "5-1:0",
          name: "CL_TAG",
          desc: "Tag Address"
        }
      ]
    },
    {
      name:     "STATUS_1584",
      desc:     "Status register of cache line 1584",
      swaccess: "rw",
      hwaccess: "hrw",
      hwext:    "true",
      hwqe:     "true", // enable `qe` latched signal of software write pulse
      hwre:     "true",
      fields: [
        {
          bits: "5+3:5", // 2 bits for status
          name: "CL_STATUS",
          desc: "Contain the current status of the corresponding cache line                [0]: valid, [1]: dirty, [2]: cmpt",
        }
      ]
    },
    { name:     "TAG_1584",
      desc:     "Tag Address stored in cache line 1584",
      swaccess: "rw",
      hwaccess: "hrw",
      hwext:    "true",
      hwqe:     "true", // enable `qe` latched signal of software write pulse
      hwre:     "true",
      fields: [
        { bits: "5-1:0",
          name: "CL_TAG",
          desc: "Tag Address"
        }
      ]
    },
    {
      name:     "STATUS_1585",
      desc:     "Status register of cache line 1585",
      swaccess: "rw",
      hwaccess: "hrw",
      hwext:    "true",
      hwqe:     "true", // enable `qe` latched signal of software write pulse
      hwre:     "true",
      fields: [
        {
          bits: "5+3:5", // 2 bits for status
          name: "CL_STATUS",
          desc: "Contain the current status of the corresponding cache line                [0]: valid, [1]: dirty, [2]: cmpt",
        }
      ]
    },
    { name:     "TAG_1585",
      desc:     "Tag Address stored in cache line 1585",
      swaccess: "rw",
      hwaccess: "hrw",
      hwext:    "true",
      hwqe:     "true", // enable `qe` latched signal of software write pulse
      hwre:     "true",
      fields: [
        { bits: "5-1:0",
          name: "CL_TAG",
          desc: "Tag Address"
        }
      ]
    },
    {
      name:     "STATUS_1586",
      desc:     "Status register of cache line 1586",
      swaccess: "rw",
      hwaccess: "hrw",
      hwext:    "true",
      hwqe:     "true", // enable `qe` latched signal of software write pulse
      hwre:     "true",
      fields: [
        {
          bits: "5+3:5", // 2 bits for status
          name: "CL_STATUS",
          desc: "Contain the current status of the corresponding cache line                [0]: valid, [1]: dirty, [2]: cmpt",
        }
      ]
    },
    { name:     "TAG_1586",
      desc:     "Tag Address stored in cache line 1586",
      swaccess: "rw",
      hwaccess: "hrw",
      hwext:    "true",
      hwqe:     "true", // enable `qe` latched signal of software write pulse
      hwre:     "true",
      fields: [
        { bits: "5-1:0",
          name: "CL_TAG",
          desc: "Tag Address"
        }
      ]
    },
    {
      name:     "STATUS_1587",
      desc:     "Status register of cache line 1587",
      swaccess: "rw",
      hwaccess: "hrw",
      hwext:    "true",
      hwqe:     "true", // enable `qe` latched signal of software write pulse
      hwre:     "true",
      fields: [
        {
          bits: "5+3:5", // 2 bits for status
          name: "CL_STATUS",
          desc: "Contain the current status of the corresponding cache line                [0]: valid, [1]: dirty, [2]: cmpt",
        }
      ]
    },
    { name:     "TAG_1587",
      desc:     "Tag Address stored in cache line 1587",
      swaccess: "rw",
      hwaccess: "hrw",
      hwext:    "true",
      hwqe:     "true", // enable `qe` latched signal of software write pulse
      hwre:     "true",
      fields: [
        { bits: "5-1:0",
          name: "CL_TAG",
          desc: "Tag Address"
        }
      ]
    },
    {
      name:     "STATUS_1588",
      desc:     "Status register of cache line 1588",
      swaccess: "rw",
      hwaccess: "hrw",
      hwext:    "true",
      hwqe:     "true", // enable `qe` latched signal of software write pulse
      hwre:     "true",
      fields: [
        {
          bits: "5+3:5", // 2 bits for status
          name: "CL_STATUS",
          desc: "Contain the current status of the corresponding cache line                [0]: valid, [1]: dirty, [2]: cmpt",
        }
      ]
    },
    { name:     "TAG_1588",
      desc:     "Tag Address stored in cache line 1588",
      swaccess: "rw",
      hwaccess: "hrw",
      hwext:    "true",
      hwqe:     "true", // enable `qe` latched signal of software write pulse
      hwre:     "true",
      fields: [
        { bits: "5-1:0",
          name: "CL_TAG",
          desc: "Tag Address"
        }
      ]
    },
    {
      name:     "STATUS_1589",
      desc:     "Status register of cache line 1589",
      swaccess: "rw",
      hwaccess: "hrw",
      hwext:    "true",
      hwqe:     "true", // enable `qe` latched signal of software write pulse
      hwre:     "true",
      fields: [
        {
          bits: "5+3:5", // 2 bits for status
          name: "CL_STATUS",
          desc: "Contain the current status of the corresponding cache line                [0]: valid, [1]: dirty, [2]: cmpt",
        }
      ]
    },
    { name:     "TAG_1589",
      desc:     "Tag Address stored in cache line 1589",
      swaccess: "rw",
      hwaccess: "hrw",
      hwext:    "true",
      hwqe:     "true", // enable `qe` latched signal of software write pulse
      hwre:     "true",
      fields: [
        { bits: "5-1:0",
          name: "CL_TAG",
          desc: "Tag Address"
        }
      ]
    },
    {
      name:     "STATUS_1590",
      desc:     "Status register of cache line 1590",
      swaccess: "rw",
      hwaccess: "hrw",
      hwext:    "true",
      hwqe:     "true", // enable `qe` latched signal of software write pulse
      hwre:     "true",
      fields: [
        {
          bits: "5+3:5", // 2 bits for status
          name: "CL_STATUS",
          desc: "Contain the current status of the corresponding cache line                [0]: valid, [1]: dirty, [2]: cmpt",
        }
      ]
    },
    { name:     "TAG_1590",
      desc:     "Tag Address stored in cache line 1590",
      swaccess: "rw",
      hwaccess: "hrw",
      hwext:    "true",
      hwqe:     "true", // enable `qe` latched signal of software write pulse
      hwre:     "true",
      fields: [
        { bits: "5-1:0",
          name: "CL_TAG",
          desc: "Tag Address"
        }
      ]
    },
    {
      name:     "STATUS_1591",
      desc:     "Status register of cache line 1591",
      swaccess: "rw",
      hwaccess: "hrw",
      hwext:    "true",
      hwqe:     "true", // enable `qe` latched signal of software write pulse
      hwre:     "true",
      fields: [
        {
          bits: "5+3:5", // 2 bits for status
          name: "CL_STATUS",
          desc: "Contain the current status of the corresponding cache line                [0]: valid, [1]: dirty, [2]: cmpt",
        }
      ]
    },
    { name:     "TAG_1591",
      desc:     "Tag Address stored in cache line 1591",
      swaccess: "rw",
      hwaccess: "hrw",
      hwext:    "true",
      hwqe:     "true", // enable `qe` latched signal of software write pulse
      hwre:     "true",
      fields: [
        { bits: "5-1:0",
          name: "CL_TAG",
          desc: "Tag Address"
        }
      ]
    },
    {
      name:     "STATUS_1592",
      desc:     "Status register of cache line 1592",
      swaccess: "rw",
      hwaccess: "hrw",
      hwext:    "true",
      hwqe:     "true", // enable `qe` latched signal of software write pulse
      hwre:     "true",
      fields: [
        {
          bits: "5+3:5", // 2 bits for status
          name: "CL_STATUS",
          desc: "Contain the current status of the corresponding cache line                [0]: valid, [1]: dirty, [2]: cmpt",
        }
      ]
    },
    { name:     "TAG_1592",
      desc:     "Tag Address stored in cache line 1592",
      swaccess: "rw",
      hwaccess: "hrw",
      hwext:    "true",
      hwqe:     "true", // enable `qe` latched signal of software write pulse
      hwre:     "true",
      fields: [
        { bits: "5-1:0",
          name: "CL_TAG",
          desc: "Tag Address"
        }
      ]
    },
    {
      name:     "STATUS_1593",
      desc:     "Status register of cache line 1593",
      swaccess: "rw",
      hwaccess: "hrw",
      hwext:    "true",
      hwqe:     "true", // enable `qe` latched signal of software write pulse
      hwre:     "true",
      fields: [
        {
          bits: "5+3:5", // 2 bits for status
          name: "CL_STATUS",
          desc: "Contain the current status of the corresponding cache line                [0]: valid, [1]: dirty, [2]: cmpt",
        }
      ]
    },
    { name:     "TAG_1593",
      desc:     "Tag Address stored in cache line 1593",
      swaccess: "rw",
      hwaccess: "hrw",
      hwext:    "true",
      hwqe:     "true", // enable `qe` latched signal of software write pulse
      hwre:     "true",
      fields: [
        { bits: "5-1:0",
          name: "CL_TAG",
          desc: "Tag Address"
        }
      ]
    },
    {
      name:     "STATUS_1594",
      desc:     "Status register of cache line 1594",
      swaccess: "rw",
      hwaccess: "hrw",
      hwext:    "true",
      hwqe:     "true", // enable `qe` latched signal of software write pulse
      hwre:     "true",
      fields: [
        {
          bits: "5+3:5", // 2 bits for status
          name: "CL_STATUS",
          desc: "Contain the current status of the corresponding cache line                [0]: valid, [1]: dirty, [2]: cmpt",
        }
      ]
    },
    { name:     "TAG_1594",
      desc:     "Tag Address stored in cache line 1594",
      swaccess: "rw",
      hwaccess: "hrw",
      hwext:    "true",
      hwqe:     "true", // enable `qe` latched signal of software write pulse
      hwre:     "true",
      fields: [
        { bits: "5-1:0",
          name: "CL_TAG",
          desc: "Tag Address"
        }
      ]
    },
    {
      name:     "STATUS_1595",
      desc:     "Status register of cache line 1595",
      swaccess: "rw",
      hwaccess: "hrw",
      hwext:    "true",
      hwqe:     "true", // enable `qe` latched signal of software write pulse
      hwre:     "true",
      fields: [
        {
          bits: "5+3:5", // 2 bits for status
          name: "CL_STATUS",
          desc: "Contain the current status of the corresponding cache line                [0]: valid, [1]: dirty, [2]: cmpt",
        }
      ]
    },
    { name:     "TAG_1595",
      desc:     "Tag Address stored in cache line 1595",
      swaccess: "rw",
      hwaccess: "hrw",
      hwext:    "true",
      hwqe:     "true", // enable `qe` latched signal of software write pulse
      hwre:     "true",
      fields: [
        { bits: "5-1:0",
          name: "CL_TAG",
          desc: "Tag Address"
        }
      ]
    },
    {
      name:     "STATUS_1596",
      desc:     "Status register of cache line 1596",
      swaccess: "rw",
      hwaccess: "hrw",
      hwext:    "true",
      hwqe:     "true", // enable `qe` latched signal of software write pulse
      hwre:     "true",
      fields: [
        {
          bits: "5+3:5", // 2 bits for status
          name: "CL_STATUS",
          desc: "Contain the current status of the corresponding cache line                [0]: valid, [1]: dirty, [2]: cmpt",
        }
      ]
    },
    { name:     "TAG_1596",
      desc:     "Tag Address stored in cache line 1596",
      swaccess: "rw",
      hwaccess: "hrw",
      hwext:    "true",
      hwqe:     "true", // enable `qe` latched signal of software write pulse
      hwre:     "true",
      fields: [
        { bits: "5-1:0",
          name: "CL_TAG",
          desc: "Tag Address"
        }
      ]
    },
    {
      name:     "STATUS_1597",
      desc:     "Status register of cache line 1597",
      swaccess: "rw",
      hwaccess: "hrw",
      hwext:    "true",
      hwqe:     "true", // enable `qe` latched signal of software write pulse
      hwre:     "true",
      fields: [
        {
          bits: "5+3:5", // 2 bits for status
          name: "CL_STATUS",
          desc: "Contain the current status of the corresponding cache line                [0]: valid, [1]: dirty, [2]: cmpt",
        }
      ]
    },
    { name:     "TAG_1597",
      desc:     "Tag Address stored in cache line 1597",
      swaccess: "rw",
      hwaccess: "hrw",
      hwext:    "true",
      hwqe:     "true", // enable `qe` latched signal of software write pulse
      hwre:     "true",
      fields: [
        { bits: "5-1:0",
          name: "CL_TAG",
          desc: "Tag Address"
        }
      ]
    },
    {
      name:     "STATUS_1598",
      desc:     "Status register of cache line 1598",
      swaccess: "rw",
      hwaccess: "hrw",
      hwext:    "true",
      hwqe:     "true", // enable `qe` latched signal of software write pulse
      hwre:     "true",
      fields: [
        {
          bits: "5+3:5", // 2 bits for status
          name: "CL_STATUS",
          desc: "Contain the current status of the corresponding cache line                [0]: valid, [1]: dirty, [2]: cmpt",
        }
      ]
    },
    { name:     "TAG_1598",
      desc:     "Tag Address stored in cache line 1598",
      swaccess: "rw",
      hwaccess: "hrw",
      hwext:    "true",
      hwqe:     "true", // enable `qe` latched signal of software write pulse
      hwre:     "true",
      fields: [
        { bits: "5-1:0",
          name: "CL_TAG",
          desc: "Tag Address"
        }
      ]
    },
    {
      name:     "STATUS_1599",
      desc:     "Status register of cache line 1599",
      swaccess: "rw",
      hwaccess: "hrw",
      hwext:    "true",
      hwqe:     "true", // enable `qe` latched signal of software write pulse
      hwre:     "true",
      fields: [
        {
          bits: "5+3:5", // 2 bits for status
          name: "CL_STATUS",
          desc: "Contain the current status of the corresponding cache line                [0]: valid, [1]: dirty, [2]: cmpt",
        }
      ]
    },
    { name:     "TAG_1599",
      desc:     "Tag Address stored in cache line 1599",
      swaccess: "rw",
      hwaccess: "hrw",
      hwext:    "true",
      hwqe:     "true", // enable `qe` latched signal of software write pulse
      hwre:     "true",
      fields: [
        { bits: "5-1:0",
          name: "CL_TAG",
          desc: "Tag Address"
        }
      ]
    },
    {
      name:     "STATUS_1600",
      desc:     "Status register of cache line 1600",
      swaccess: "rw",
      hwaccess: "hrw",
      hwext:    "true",
      hwqe:     "true", // enable `qe` latched signal of software write pulse
      hwre:     "true",
      fields: [
        {
          bits: "5+3:5", // 2 bits for status
          name: "CL_STATUS",
          desc: "Contain the current status of the corresponding cache line                [0]: valid, [1]: dirty, [2]: cmpt",
        }
      ]
    },
    { name:     "TAG_1600",
      desc:     "Tag Address stored in cache line 1600",
      swaccess: "rw",
      hwaccess: "hrw",
      hwext:    "true",
      hwqe:     "true", // enable `qe` latched signal of software write pulse
      hwre:     "true",
      fields: [
        { bits: "5-1:0",
          name: "CL_TAG",
          desc: "Tag Address"
        }
      ]
    },
    {
      name:     "STATUS_1601",
      desc:     "Status register of cache line 1601",
      swaccess: "rw",
      hwaccess: "hrw",
      hwext:    "true",
      hwqe:     "true", // enable `qe` latched signal of software write pulse
      hwre:     "true",
      fields: [
        {
          bits: "5+3:5", // 2 bits for status
          name: "CL_STATUS",
          desc: "Contain the current status of the corresponding cache line                [0]: valid, [1]: dirty, [2]: cmpt",
        }
      ]
    },
    { name:     "TAG_1601",
      desc:     "Tag Address stored in cache line 1601",
      swaccess: "rw",
      hwaccess: "hrw",
      hwext:    "true",
      hwqe:     "true", // enable `qe` latched signal of software write pulse
      hwre:     "true",
      fields: [
        { bits: "5-1:0",
          name: "CL_TAG",
          desc: "Tag Address"
        }
      ]
    },
    {
      name:     "STATUS_1602",
      desc:     "Status register of cache line 1602",
      swaccess: "rw",
      hwaccess: "hrw",
      hwext:    "true",
      hwqe:     "true", // enable `qe` latched signal of software write pulse
      hwre:     "true",
      fields: [
        {
          bits: "5+3:5", // 2 bits for status
          name: "CL_STATUS",
          desc: "Contain the current status of the corresponding cache line                [0]: valid, [1]: dirty, [2]: cmpt",
        }
      ]
    },
    { name:     "TAG_1602",
      desc:     "Tag Address stored in cache line 1602",
      swaccess: "rw",
      hwaccess: "hrw",
      hwext:    "true",
      hwqe:     "true", // enable `qe` latched signal of software write pulse
      hwre:     "true",
      fields: [
        { bits: "5-1:0",
          name: "CL_TAG",
          desc: "Tag Address"
        }
      ]
    },
    {
      name:     "STATUS_1603",
      desc:     "Status register of cache line 1603",
      swaccess: "rw",
      hwaccess: "hrw",
      hwext:    "true",
      hwqe:     "true", // enable `qe` latched signal of software write pulse
      hwre:     "true",
      fields: [
        {
          bits: "5+3:5", // 2 bits for status
          name: "CL_STATUS",
          desc: "Contain the current status of the corresponding cache line                [0]: valid, [1]: dirty, [2]: cmpt",
        }
      ]
    },
    { name:     "TAG_1603",
      desc:     "Tag Address stored in cache line 1603",
      swaccess: "rw",
      hwaccess: "hrw",
      hwext:    "true",
      hwqe:     "true", // enable `qe` latched signal of software write pulse
      hwre:     "true",
      fields: [
        { bits: "5-1:0",
          name: "CL_TAG",
          desc: "Tag Address"
        }
      ]
    },
    {
      name:     "STATUS_1604",
      desc:     "Status register of cache line 1604",
      swaccess: "rw",
      hwaccess: "hrw",
      hwext:    "true",
      hwqe:     "true", // enable `qe` latched signal of software write pulse
      hwre:     "true",
      fields: [
        {
          bits: "5+3:5", // 2 bits for status
          name: "CL_STATUS",
          desc: "Contain the current status of the corresponding cache line                [0]: valid, [1]: dirty, [2]: cmpt",
        }
      ]
    },
    { name:     "TAG_1604",
      desc:     "Tag Address stored in cache line 1604",
      swaccess: "rw",
      hwaccess: "hrw",
      hwext:    "true",
      hwqe:     "true", // enable `qe` latched signal of software write pulse
      hwre:     "true",
      fields: [
        { bits: "5-1:0",
          name: "CL_TAG",
          desc: "Tag Address"
        }
      ]
    },
    {
      name:     "STATUS_1605",
      desc:     "Status register of cache line 1605",
      swaccess: "rw",
      hwaccess: "hrw",
      hwext:    "true",
      hwqe:     "true", // enable `qe` latched signal of software write pulse
      hwre:     "true",
      fields: [
        {
          bits: "5+3:5", // 2 bits for status
          name: "CL_STATUS",
          desc: "Contain the current status of the corresponding cache line                [0]: valid, [1]: dirty, [2]: cmpt",
        }
      ]
    },
    { name:     "TAG_1605",
      desc:     "Tag Address stored in cache line 1605",
      swaccess: "rw",
      hwaccess: "hrw",
      hwext:    "true",
      hwqe:     "true", // enable `qe` latched signal of software write pulse
      hwre:     "true",
      fields: [
        { bits: "5-1:0",
          name: "CL_TAG",
          desc: "Tag Address"
        }
      ]
    },
    {
      name:     "STATUS_1606",
      desc:     "Status register of cache line 1606",
      swaccess: "rw",
      hwaccess: "hrw",
      hwext:    "true",
      hwqe:     "true", // enable `qe` latched signal of software write pulse
      hwre:     "true",
      fields: [
        {
          bits: "5+3:5", // 2 bits for status
          name: "CL_STATUS",
          desc: "Contain the current status of the corresponding cache line                [0]: valid, [1]: dirty, [2]: cmpt",
        }
      ]
    },
    { name:     "TAG_1606",
      desc:     "Tag Address stored in cache line 1606",
      swaccess: "rw",
      hwaccess: "hrw",
      hwext:    "true",
      hwqe:     "true", // enable `qe` latched signal of software write pulse
      hwre:     "true",
      fields: [
        { bits: "5-1:0",
          name: "CL_TAG",
          desc: "Tag Address"
        }
      ]
    },
    {
      name:     "STATUS_1607",
      desc:     "Status register of cache line 1607",
      swaccess: "rw",
      hwaccess: "hrw",
      hwext:    "true",
      hwqe:     "true", // enable `qe` latched signal of software write pulse
      hwre:     "true",
      fields: [
        {
          bits: "5+3:5", // 2 bits for status
          name: "CL_STATUS",
          desc: "Contain the current status of the corresponding cache line                [0]: valid, [1]: dirty, [2]: cmpt",
        }
      ]
    },
    { name:     "TAG_1607",
      desc:     "Tag Address stored in cache line 1607",
      swaccess: "rw",
      hwaccess: "hrw",
      hwext:    "true",
      hwqe:     "true", // enable `qe` latched signal of software write pulse
      hwre:     "true",
      fields: [
        { bits: "5-1:0",
          name: "CL_TAG",
          desc: "Tag Address"
        }
      ]
    },
    {
      name:     "STATUS_1608",
      desc:     "Status register of cache line 1608",
      swaccess: "rw",
      hwaccess: "hrw",
      hwext:    "true",
      hwqe:     "true", // enable `qe` latched signal of software write pulse
      hwre:     "true",
      fields: [
        {
          bits: "5+3:5", // 2 bits for status
          name: "CL_STATUS",
          desc: "Contain the current status of the corresponding cache line                [0]: valid, [1]: dirty, [2]: cmpt",
        }
      ]
    },
    { name:     "TAG_1608",
      desc:     "Tag Address stored in cache line 1608",
      swaccess: "rw",
      hwaccess: "hrw",
      hwext:    "true",
      hwqe:     "true", // enable `qe` latched signal of software write pulse
      hwre:     "true",
      fields: [
        { bits: "5-1:0",
          name: "CL_TAG",
          desc: "Tag Address"
        }
      ]
    },
    {
      name:     "STATUS_1609",
      desc:     "Status register of cache line 1609",
      swaccess: "rw",
      hwaccess: "hrw",
      hwext:    "true",
      hwqe:     "true", // enable `qe` latched signal of software write pulse
      hwre:     "true",
      fields: [
        {
          bits: "5+3:5", // 2 bits for status
          name: "CL_STATUS",
          desc: "Contain the current status of the corresponding cache line                [0]: valid, [1]: dirty, [2]: cmpt",
        }
      ]
    },
    { name:     "TAG_1609",
      desc:     "Tag Address stored in cache line 1609",
      swaccess: "rw",
      hwaccess: "hrw",
      hwext:    "true",
      hwqe:     "true", // enable `qe` latched signal of software write pulse
      hwre:     "true",
      fields: [
        { bits: "5-1:0",
          name: "CL_TAG",
          desc: "Tag Address"
        }
      ]
    },
    {
      name:     "STATUS_1610",
      desc:     "Status register of cache line 1610",
      swaccess: "rw",
      hwaccess: "hrw",
      hwext:    "true",
      hwqe:     "true", // enable `qe` latched signal of software write pulse
      hwre:     "true",
      fields: [
        {
          bits: "5+3:5", // 2 bits for status
          name: "CL_STATUS",
          desc: "Contain the current status of the corresponding cache line                [0]: valid, [1]: dirty, [2]: cmpt",
        }
      ]
    },
    { name:     "TAG_1610",
      desc:     "Tag Address stored in cache line 1610",
      swaccess: "rw",
      hwaccess: "hrw",
      hwext:    "true",
      hwqe:     "true", // enable `qe` latched signal of software write pulse
      hwre:     "true",
      fields: [
        { bits: "5-1:0",
          name: "CL_TAG",
          desc: "Tag Address"
        }
      ]
    },
    {
      name:     "STATUS_1611",
      desc:     "Status register of cache line 1611",
      swaccess: "rw",
      hwaccess: "hrw",
      hwext:    "true",
      hwqe:     "true", // enable `qe` latched signal of software write pulse
      hwre:     "true",
      fields: [
        {
          bits: "5+3:5", // 2 bits for status
          name: "CL_STATUS",
          desc: "Contain the current status of the corresponding cache line                [0]: valid, [1]: dirty, [2]: cmpt",
        }
      ]
    },
    { name:     "TAG_1611",
      desc:     "Tag Address stored in cache line 1611",
      swaccess: "rw",
      hwaccess: "hrw",
      hwext:    "true",
      hwqe:     "true", // enable `qe` latched signal of software write pulse
      hwre:     "true",
      fields: [
        { bits: "5-1:0",
          name: "CL_TAG",
          desc: "Tag Address"
        }
      ]
    },
    {
      name:     "STATUS_1612",
      desc:     "Status register of cache line 1612",
      swaccess: "rw",
      hwaccess: "hrw",
      hwext:    "true",
      hwqe:     "true", // enable `qe` latched signal of software write pulse
      hwre:     "true",
      fields: [
        {
          bits: "5+3:5", // 2 bits for status
          name: "CL_STATUS",
          desc: "Contain the current status of the corresponding cache line                [0]: valid, [1]: dirty, [2]: cmpt",
        }
      ]
    },
    { name:     "TAG_1612",
      desc:     "Tag Address stored in cache line 1612",
      swaccess: "rw",
      hwaccess: "hrw",
      hwext:    "true",
      hwqe:     "true", // enable `qe` latched signal of software write pulse
      hwre:     "true",
      fields: [
        { bits: "5-1:0",
          name: "CL_TAG",
          desc: "Tag Address"
        }
      ]
    },
    {
      name:     "STATUS_1613",
      desc:     "Status register of cache line 1613",
      swaccess: "rw",
      hwaccess: "hrw",
      hwext:    "true",
      hwqe:     "true", // enable `qe` latched signal of software write pulse
      hwre:     "true",
      fields: [
        {
          bits: "5+3:5", // 2 bits for status
          name: "CL_STATUS",
          desc: "Contain the current status of the corresponding cache line                [0]: valid, [1]: dirty, [2]: cmpt",
        }
      ]
    },
    { name:     "TAG_1613",
      desc:     "Tag Address stored in cache line 1613",
      swaccess: "rw",
      hwaccess: "hrw",
      hwext:    "true",
      hwqe:     "true", // enable `qe` latched signal of software write pulse
      hwre:     "true",
      fields: [
        { bits: "5-1:0",
          name: "CL_TAG",
          desc: "Tag Address"
        }
      ]
    },
    {
      name:     "STATUS_1614",
      desc:     "Status register of cache line 1614",
      swaccess: "rw",
      hwaccess: "hrw",
      hwext:    "true",
      hwqe:     "true", // enable `qe` latched signal of software write pulse
      hwre:     "true",
      fields: [
        {
          bits: "5+3:5", // 2 bits for status
          name: "CL_STATUS",
          desc: "Contain the current status of the corresponding cache line                [0]: valid, [1]: dirty, [2]: cmpt",
        }
      ]
    },
    { name:     "TAG_1614",
      desc:     "Tag Address stored in cache line 1614",
      swaccess: "rw",
      hwaccess: "hrw",
      hwext:    "true",
      hwqe:     "true", // enable `qe` latched signal of software write pulse
      hwre:     "true",
      fields: [
        { bits: "5-1:0",
          name: "CL_TAG",
          desc: "Tag Address"
        }
      ]
    },
    {
      name:     "STATUS_1615",
      desc:     "Status register of cache line 1615",
      swaccess: "rw",
      hwaccess: "hrw",
      hwext:    "true",
      hwqe:     "true", // enable `qe` latched signal of software write pulse
      hwre:     "true",
      fields: [
        {
          bits: "5+3:5", // 2 bits for status
          name: "CL_STATUS",
          desc: "Contain the current status of the corresponding cache line                [0]: valid, [1]: dirty, [2]: cmpt",
        }
      ]
    },
    { name:     "TAG_1615",
      desc:     "Tag Address stored in cache line 1615",
      swaccess: "rw",
      hwaccess: "hrw",
      hwext:    "true",
      hwqe:     "true", // enable `qe` latched signal of software write pulse
      hwre:     "true",
      fields: [
        { bits: "5-1:0",
          name: "CL_TAG",
          desc: "Tag Address"
        }
      ]
    },
    {
      name:     "STATUS_1616",
      desc:     "Status register of cache line 1616",
      swaccess: "rw",
      hwaccess: "hrw",
      hwext:    "true",
      hwqe:     "true", // enable `qe` latched signal of software write pulse
      hwre:     "true",
      fields: [
        {
          bits: "5+3:5", // 2 bits for status
          name: "CL_STATUS",
          desc: "Contain the current status of the corresponding cache line                [0]: valid, [1]: dirty, [2]: cmpt",
        }
      ]
    },
    { name:     "TAG_1616",
      desc:     "Tag Address stored in cache line 1616",
      swaccess: "rw",
      hwaccess: "hrw",
      hwext:    "true",
      hwqe:     "true", // enable `qe` latched signal of software write pulse
      hwre:     "true",
      fields: [
        { bits: "5-1:0",
          name: "CL_TAG",
          desc: "Tag Address"
        }
      ]
    },
    {
      name:     "STATUS_1617",
      desc:     "Status register of cache line 1617",
      swaccess: "rw",
      hwaccess: "hrw",
      hwext:    "true",
      hwqe:     "true", // enable `qe` latched signal of software write pulse
      hwre:     "true",
      fields: [
        {
          bits: "5+3:5", // 2 bits for status
          name: "CL_STATUS",
          desc: "Contain the current status of the corresponding cache line                [0]: valid, [1]: dirty, [2]: cmpt",
        }
      ]
    },
    { name:     "TAG_1617",
      desc:     "Tag Address stored in cache line 1617",
      swaccess: "rw",
      hwaccess: "hrw",
      hwext:    "true",
      hwqe:     "true", // enable `qe` latched signal of software write pulse
      hwre:     "true",
      fields: [
        { bits: "5-1:0",
          name: "CL_TAG",
          desc: "Tag Address"
        }
      ]
    },
    {
      name:     "STATUS_1618",
      desc:     "Status register of cache line 1618",
      swaccess: "rw",
      hwaccess: "hrw",
      hwext:    "true",
      hwqe:     "true", // enable `qe` latched signal of software write pulse
      hwre:     "true",
      fields: [
        {
          bits: "5+3:5", // 2 bits for status
          name: "CL_STATUS",
          desc: "Contain the current status of the corresponding cache line                [0]: valid, [1]: dirty, [2]: cmpt",
        }
      ]
    },
    { name:     "TAG_1618",
      desc:     "Tag Address stored in cache line 1618",
      swaccess: "rw",
      hwaccess: "hrw",
      hwext:    "true",
      hwqe:     "true", // enable `qe` latched signal of software write pulse
      hwre:     "true",
      fields: [
        { bits: "5-1:0",
          name: "CL_TAG",
          desc: "Tag Address"
        }
      ]
    },
    {
      name:     "STATUS_1619",
      desc:     "Status register of cache line 1619",
      swaccess: "rw",
      hwaccess: "hrw",
      hwext:    "true",
      hwqe:     "true", // enable `qe` latched signal of software write pulse
      hwre:     "true",
      fields: [
        {
          bits: "5+3:5", // 2 bits for status
          name: "CL_STATUS",
          desc: "Contain the current status of the corresponding cache line                [0]: valid, [1]: dirty, [2]: cmpt",
        }
      ]
    },
    { name:     "TAG_1619",
      desc:     "Tag Address stored in cache line 1619",
      swaccess: "rw",
      hwaccess: "hrw",
      hwext:    "true",
      hwqe:     "true", // enable `qe` latched signal of software write pulse
      hwre:     "true",
      fields: [
        { bits: "5-1:0",
          name: "CL_TAG",
          desc: "Tag Address"
        }
      ]
    },
    {
      name:     "STATUS_1620",
      desc:     "Status register of cache line 1620",
      swaccess: "rw",
      hwaccess: "hrw",
      hwext:    "true",
      hwqe:     "true", // enable `qe` latched signal of software write pulse
      hwre:     "true",
      fields: [
        {
          bits: "5+3:5", // 2 bits for status
          name: "CL_STATUS",
          desc: "Contain the current status of the corresponding cache line                [0]: valid, [1]: dirty, [2]: cmpt",
        }
      ]
    },
    { name:     "TAG_1620",
      desc:     "Tag Address stored in cache line 1620",
      swaccess: "rw",
      hwaccess: "hrw",
      hwext:    "true",
      hwqe:     "true", // enable `qe` latched signal of software write pulse
      hwre:     "true",
      fields: [
        { bits: "5-1:0",
          name: "CL_TAG",
          desc: "Tag Address"
        }
      ]
    },
    {
      name:     "STATUS_1621",
      desc:     "Status register of cache line 1621",
      swaccess: "rw",
      hwaccess: "hrw",
      hwext:    "true",
      hwqe:     "true", // enable `qe` latched signal of software write pulse
      hwre:     "true",
      fields: [
        {
          bits: "5+3:5", // 2 bits for status
          name: "CL_STATUS",
          desc: "Contain the current status of the corresponding cache line                [0]: valid, [1]: dirty, [2]: cmpt",
        }
      ]
    },
    { name:     "TAG_1621",
      desc:     "Tag Address stored in cache line 1621",
      swaccess: "rw",
      hwaccess: "hrw",
      hwext:    "true",
      hwqe:     "true", // enable `qe` latched signal of software write pulse
      hwre:     "true",
      fields: [
        { bits: "5-1:0",
          name: "CL_TAG",
          desc: "Tag Address"
        }
      ]
    },
    {
      name:     "STATUS_1622",
      desc:     "Status register of cache line 1622",
      swaccess: "rw",
      hwaccess: "hrw",
      hwext:    "true",
      hwqe:     "true", // enable `qe` latched signal of software write pulse
      hwre:     "true",
      fields: [
        {
          bits: "5+3:5", // 2 bits for status
          name: "CL_STATUS",
          desc: "Contain the current status of the corresponding cache line                [0]: valid, [1]: dirty, [2]: cmpt",
        }
      ]
    },
    { name:     "TAG_1622",
      desc:     "Tag Address stored in cache line 1622",
      swaccess: "rw",
      hwaccess: "hrw",
      hwext:    "true",
      hwqe:     "true", // enable `qe` latched signal of software write pulse
      hwre:     "true",
      fields: [
        { bits: "5-1:0",
          name: "CL_TAG",
          desc: "Tag Address"
        }
      ]
    },
    {
      name:     "STATUS_1623",
      desc:     "Status register of cache line 1623",
      swaccess: "rw",
      hwaccess: "hrw",
      hwext:    "true",
      hwqe:     "true", // enable `qe` latched signal of software write pulse
      hwre:     "true",
      fields: [
        {
          bits: "5+3:5", // 2 bits for status
          name: "CL_STATUS",
          desc: "Contain the current status of the corresponding cache line                [0]: valid, [1]: dirty, [2]: cmpt",
        }
      ]
    },
    { name:     "TAG_1623",
      desc:     "Tag Address stored in cache line 1623",
      swaccess: "rw",
      hwaccess: "hrw",
      hwext:    "true",
      hwqe:     "true", // enable `qe` latched signal of software write pulse
      hwre:     "true",
      fields: [
        { bits: "5-1:0",
          name: "CL_TAG",
          desc: "Tag Address"
        }
      ]
    },
    {
      name:     "STATUS_1624",
      desc:     "Status register of cache line 1624",
      swaccess: "rw",
      hwaccess: "hrw",
      hwext:    "true",
      hwqe:     "true", // enable `qe` latched signal of software write pulse
      hwre:     "true",
      fields: [
        {
          bits: "5+3:5", // 2 bits for status
          name: "CL_STATUS",
          desc: "Contain the current status of the corresponding cache line                [0]: valid, [1]: dirty, [2]: cmpt",
        }
      ]
    },
    { name:     "TAG_1624",
      desc:     "Tag Address stored in cache line 1624",
      swaccess: "rw",
      hwaccess: "hrw",
      hwext:    "true",
      hwqe:     "true", // enable `qe` latched signal of software write pulse
      hwre:     "true",
      fields: [
        { bits: "5-1:0",
          name: "CL_TAG",
          desc: "Tag Address"
        }
      ]
    },
    {
      name:     "STATUS_1625",
      desc:     "Status register of cache line 1625",
      swaccess: "rw",
      hwaccess: "hrw",
      hwext:    "true",
      hwqe:     "true", // enable `qe` latched signal of software write pulse
      hwre:     "true",
      fields: [
        {
          bits: "5+3:5", // 2 bits for status
          name: "CL_STATUS",
          desc: "Contain the current status of the corresponding cache line                [0]: valid, [1]: dirty, [2]: cmpt",
        }
      ]
    },
    { name:     "TAG_1625",
      desc:     "Tag Address stored in cache line 1625",
      swaccess: "rw",
      hwaccess: "hrw",
      hwext:    "true",
      hwqe:     "true", // enable `qe` latched signal of software write pulse
      hwre:     "true",
      fields: [
        { bits: "5-1:0",
          name: "CL_TAG",
          desc: "Tag Address"
        }
      ]
    },
    {
      name:     "STATUS_1626",
      desc:     "Status register of cache line 1626",
      swaccess: "rw",
      hwaccess: "hrw",
      hwext:    "true",
      hwqe:     "true", // enable `qe` latched signal of software write pulse
      hwre:     "true",
      fields: [
        {
          bits: "5+3:5", // 2 bits for status
          name: "CL_STATUS",
          desc: "Contain the current status of the corresponding cache line                [0]: valid, [1]: dirty, [2]: cmpt",
        }
      ]
    },
    { name:     "TAG_1626",
      desc:     "Tag Address stored in cache line 1626",
      swaccess: "rw",
      hwaccess: "hrw",
      hwext:    "true",
      hwqe:     "true", // enable `qe` latched signal of software write pulse
      hwre:     "true",
      fields: [
        { bits: "5-1:0",
          name: "CL_TAG",
          desc: "Tag Address"
        }
      ]
    },
    {
      name:     "STATUS_1627",
      desc:     "Status register of cache line 1627",
      swaccess: "rw",
      hwaccess: "hrw",
      hwext:    "true",
      hwqe:     "true", // enable `qe` latched signal of software write pulse
      hwre:     "true",
      fields: [
        {
          bits: "5+3:5", // 2 bits for status
          name: "CL_STATUS",
          desc: "Contain the current status of the corresponding cache line                [0]: valid, [1]: dirty, [2]: cmpt",
        }
      ]
    },
    { name:     "TAG_1627",
      desc:     "Tag Address stored in cache line 1627",
      swaccess: "rw",
      hwaccess: "hrw",
      hwext:    "true",
      hwqe:     "true", // enable `qe` latched signal of software write pulse
      hwre:     "true",
      fields: [
        { bits: "5-1:0",
          name: "CL_TAG",
          desc: "Tag Address"
        }
      ]
    },
    {
      name:     "STATUS_1628",
      desc:     "Status register of cache line 1628",
      swaccess: "rw",
      hwaccess: "hrw",
      hwext:    "true",
      hwqe:     "true", // enable `qe` latched signal of software write pulse
      hwre:     "true",
      fields: [
        {
          bits: "5+3:5", // 2 bits for status
          name: "CL_STATUS",
          desc: "Contain the current status of the corresponding cache line                [0]: valid, [1]: dirty, [2]: cmpt",
        }
      ]
    },
    { name:     "TAG_1628",
      desc:     "Tag Address stored in cache line 1628",
      swaccess: "rw",
      hwaccess: "hrw",
      hwext:    "true",
      hwqe:     "true", // enable `qe` latched signal of software write pulse
      hwre:     "true",
      fields: [
        { bits: "5-1:0",
          name: "CL_TAG",
          desc: "Tag Address"
        }
      ]
    },
    {
      name:     "STATUS_1629",
      desc:     "Status register of cache line 1629",
      swaccess: "rw",
      hwaccess: "hrw",
      hwext:    "true",
      hwqe:     "true", // enable `qe` latched signal of software write pulse
      hwre:     "true",
      fields: [
        {
          bits: "5+3:5", // 2 bits for status
          name: "CL_STATUS",
          desc: "Contain the current status of the corresponding cache line                [0]: valid, [1]: dirty, [2]: cmpt",
        }
      ]
    },
    { name:     "TAG_1629",
      desc:     "Tag Address stored in cache line 1629",
      swaccess: "rw",
      hwaccess: "hrw",
      hwext:    "true",
      hwqe:     "true", // enable `qe` latched signal of software write pulse
      hwre:     "true",
      fields: [
        { bits: "5-1:0",
          name: "CL_TAG",
          desc: "Tag Address"
        }
      ]
    },
    {
      name:     "STATUS_1630",
      desc:     "Status register of cache line 1630",
      swaccess: "rw",
      hwaccess: "hrw",
      hwext:    "true",
      hwqe:     "true", // enable `qe` latched signal of software write pulse
      hwre:     "true",
      fields: [
        {
          bits: "5+3:5", // 2 bits for status
          name: "CL_STATUS",
          desc: "Contain the current status of the corresponding cache line                [0]: valid, [1]: dirty, [2]: cmpt",
        }
      ]
    },
    { name:     "TAG_1630",
      desc:     "Tag Address stored in cache line 1630",
      swaccess: "rw",
      hwaccess: "hrw",
      hwext:    "true",
      hwqe:     "true", // enable `qe` latched signal of software write pulse
      hwre:     "true",
      fields: [
        { bits: "5-1:0",
          name: "CL_TAG",
          desc: "Tag Address"
        }
      ]
    },
    {
      name:     "STATUS_1631",
      desc:     "Status register of cache line 1631",
      swaccess: "rw",
      hwaccess: "hrw",
      hwext:    "true",
      hwqe:     "true", // enable `qe` latched signal of software write pulse
      hwre:     "true",
      fields: [
        {
          bits: "5+3:5", // 2 bits for status
          name: "CL_STATUS",
          desc: "Contain the current status of the corresponding cache line                [0]: valid, [1]: dirty, [2]: cmpt",
        }
      ]
    },
    { name:     "TAG_1631",
      desc:     "Tag Address stored in cache line 1631",
      swaccess: "rw",
      hwaccess: "hrw",
      hwext:    "true",
      hwqe:     "true", // enable `qe` latched signal of software write pulse
      hwre:     "true",
      fields: [
        { bits: "5-1:0",
          name: "CL_TAG",
          desc: "Tag Address"
        }
      ]
    },
    {
      name:     "STATUS_1632",
      desc:     "Status register of cache line 1632",
      swaccess: "rw",
      hwaccess: "hrw",
      hwext:    "true",
      hwqe:     "true", // enable `qe` latched signal of software write pulse
      hwre:     "true",
      fields: [
        {
          bits: "5+3:5", // 2 bits for status
          name: "CL_STATUS",
          desc: "Contain the current status of the corresponding cache line                [0]: valid, [1]: dirty, [2]: cmpt",
        }
      ]
    },
    { name:     "TAG_1632",
      desc:     "Tag Address stored in cache line 1632",
      swaccess: "rw",
      hwaccess: "hrw",
      hwext:    "true",
      hwqe:     "true", // enable `qe` latched signal of software write pulse
      hwre:     "true",
      fields: [
        { bits: "5-1:0",
          name: "CL_TAG",
          desc: "Tag Address"
        }
      ]
    },
    {
      name:     "STATUS_1633",
      desc:     "Status register of cache line 1633",
      swaccess: "rw",
      hwaccess: "hrw",
      hwext:    "true",
      hwqe:     "true", // enable `qe` latched signal of software write pulse
      hwre:     "true",
      fields: [
        {
          bits: "5+3:5", // 2 bits for status
          name: "CL_STATUS",
          desc: "Contain the current status of the corresponding cache line                [0]: valid, [1]: dirty, [2]: cmpt",
        }
      ]
    },
    { name:     "TAG_1633",
      desc:     "Tag Address stored in cache line 1633",
      swaccess: "rw",
      hwaccess: "hrw",
      hwext:    "true",
      hwqe:     "true", // enable `qe` latched signal of software write pulse
      hwre:     "true",
      fields: [
        { bits: "5-1:0",
          name: "CL_TAG",
          desc: "Tag Address"
        }
      ]
    },
    {
      name:     "STATUS_1634",
      desc:     "Status register of cache line 1634",
      swaccess: "rw",
      hwaccess: "hrw",
      hwext:    "true",
      hwqe:     "true", // enable `qe` latched signal of software write pulse
      hwre:     "true",
      fields: [
        {
          bits: "5+3:5", // 2 bits for status
          name: "CL_STATUS",
          desc: "Contain the current status of the corresponding cache line                [0]: valid, [1]: dirty, [2]: cmpt",
        }
      ]
    },
    { name:     "TAG_1634",
      desc:     "Tag Address stored in cache line 1634",
      swaccess: "rw",
      hwaccess: "hrw",
      hwext:    "true",
      hwqe:     "true", // enable `qe` latched signal of software write pulse
      hwre:     "true",
      fields: [
        { bits: "5-1:0",
          name: "CL_TAG",
          desc: "Tag Address"
        }
      ]
    },
    {
      name:     "STATUS_1635",
      desc:     "Status register of cache line 1635",
      swaccess: "rw",
      hwaccess: "hrw",
      hwext:    "true",
      hwqe:     "true", // enable `qe` latched signal of software write pulse
      hwre:     "true",
      fields: [
        {
          bits: "5+3:5", // 2 bits for status
          name: "CL_STATUS",
          desc: "Contain the current status of the corresponding cache line                [0]: valid, [1]: dirty, [2]: cmpt",
        }
      ]
    },
    { name:     "TAG_1635",
      desc:     "Tag Address stored in cache line 1635",
      swaccess: "rw",
      hwaccess: "hrw",
      hwext:    "true",
      hwqe:     "true", // enable `qe` latched signal of software write pulse
      hwre:     "true",
      fields: [
        { bits: "5-1:0",
          name: "CL_TAG",
          desc: "Tag Address"
        }
      ]
    },
    {
      name:     "STATUS_1636",
      desc:     "Status register of cache line 1636",
      swaccess: "rw",
      hwaccess: "hrw",
      hwext:    "true",
      hwqe:     "true", // enable `qe` latched signal of software write pulse
      hwre:     "true",
      fields: [
        {
          bits: "5+3:5", // 2 bits for status
          name: "CL_STATUS",
          desc: "Contain the current status of the corresponding cache line                [0]: valid, [1]: dirty, [2]: cmpt",
        }
      ]
    },
    { name:     "TAG_1636",
      desc:     "Tag Address stored in cache line 1636",
      swaccess: "rw",
      hwaccess: "hrw",
      hwext:    "true",
      hwqe:     "true", // enable `qe` latched signal of software write pulse
      hwre:     "true",
      fields: [
        { bits: "5-1:0",
          name: "CL_TAG",
          desc: "Tag Address"
        }
      ]
    },
    {
      name:     "STATUS_1637",
      desc:     "Status register of cache line 1637",
      swaccess: "rw",
      hwaccess: "hrw",
      hwext:    "true",
      hwqe:     "true", // enable `qe` latched signal of software write pulse
      hwre:     "true",
      fields: [
        {
          bits: "5+3:5", // 2 bits for status
          name: "CL_STATUS",
          desc: "Contain the current status of the corresponding cache line                [0]: valid, [1]: dirty, [2]: cmpt",
        }
      ]
    },
    { name:     "TAG_1637",
      desc:     "Tag Address stored in cache line 1637",
      swaccess: "rw",
      hwaccess: "hrw",
      hwext:    "true",
      hwqe:     "true", // enable `qe` latched signal of software write pulse
      hwre:     "true",
      fields: [
        { bits: "5-1:0",
          name: "CL_TAG",
          desc: "Tag Address"
        }
      ]
    },
    {
      name:     "STATUS_1638",
      desc:     "Status register of cache line 1638",
      swaccess: "rw",
      hwaccess: "hrw",
      hwext:    "true",
      hwqe:     "true", // enable `qe` latched signal of software write pulse
      hwre:     "true",
      fields: [
        {
          bits: "5+3:5", // 2 bits for status
          name: "CL_STATUS",
          desc: "Contain the current status of the corresponding cache line                [0]: valid, [1]: dirty, [2]: cmpt",
        }
      ]
    },
    { name:     "TAG_1638",
      desc:     "Tag Address stored in cache line 1638",
      swaccess: "rw",
      hwaccess: "hrw",
      hwext:    "true",
      hwqe:     "true", // enable `qe` latched signal of software write pulse
      hwre:     "true",
      fields: [
        { bits: "5-1:0",
          name: "CL_TAG",
          desc: "Tag Address"
        }
      ]
    },
    {
      name:     "STATUS_1639",
      desc:     "Status register of cache line 1639",
      swaccess: "rw",
      hwaccess: "hrw",
      hwext:    "true",
      hwqe:     "true", // enable `qe` latched signal of software write pulse
      hwre:     "true",
      fields: [
        {
          bits: "5+3:5", // 2 bits for status
          name: "CL_STATUS",
          desc: "Contain the current status of the corresponding cache line                [0]: valid, [1]: dirty, [2]: cmpt",
        }
      ]
    },
    { name:     "TAG_1639",
      desc:     "Tag Address stored in cache line 1639",
      swaccess: "rw",
      hwaccess: "hrw",
      hwext:    "true",
      hwqe:     "true", // enable `qe` latched signal of software write pulse
      hwre:     "true",
      fields: [
        { bits: "5-1:0",
          name: "CL_TAG",
          desc: "Tag Address"
        }
      ]
    },
    {
      name:     "STATUS_1640",
      desc:     "Status register of cache line 1640",
      swaccess: "rw",
      hwaccess: "hrw",
      hwext:    "true",
      hwqe:     "true", // enable `qe` latched signal of software write pulse
      hwre:     "true",
      fields: [
        {
          bits: "5+3:5", // 2 bits for status
          name: "CL_STATUS",
          desc: "Contain the current status of the corresponding cache line                [0]: valid, [1]: dirty, [2]: cmpt",
        }
      ]
    },
    { name:     "TAG_1640",
      desc:     "Tag Address stored in cache line 1640",
      swaccess: "rw",
      hwaccess: "hrw",
      hwext:    "true",
      hwqe:     "true", // enable `qe` latched signal of software write pulse
      hwre:     "true",
      fields: [
        { bits: "5-1:0",
          name: "CL_TAG",
          desc: "Tag Address"
        }
      ]
    },
    {
      name:     "STATUS_1641",
      desc:     "Status register of cache line 1641",
      swaccess: "rw",
      hwaccess: "hrw",
      hwext:    "true",
      hwqe:     "true", // enable `qe` latched signal of software write pulse
      hwre:     "true",
      fields: [
        {
          bits: "5+3:5", // 2 bits for status
          name: "CL_STATUS",
          desc: "Contain the current status of the corresponding cache line                [0]: valid, [1]: dirty, [2]: cmpt",
        }
      ]
    },
    { name:     "TAG_1641",
      desc:     "Tag Address stored in cache line 1641",
      swaccess: "rw",
      hwaccess: "hrw",
      hwext:    "true",
      hwqe:     "true", // enable `qe` latched signal of software write pulse
      hwre:     "true",
      fields: [
        { bits: "5-1:0",
          name: "CL_TAG",
          desc: "Tag Address"
        }
      ]
    },
    {
      name:     "STATUS_1642",
      desc:     "Status register of cache line 1642",
      swaccess: "rw",
      hwaccess: "hrw",
      hwext:    "true",
      hwqe:     "true", // enable `qe` latched signal of software write pulse
      hwre:     "true",
      fields: [
        {
          bits: "5+3:5", // 2 bits for status
          name: "CL_STATUS",
          desc: "Contain the current status of the corresponding cache line                [0]: valid, [1]: dirty, [2]: cmpt",
        }
      ]
    },
    { name:     "TAG_1642",
      desc:     "Tag Address stored in cache line 1642",
      swaccess: "rw",
      hwaccess: "hrw",
      hwext:    "true",
      hwqe:     "true", // enable `qe` latched signal of software write pulse
      hwre:     "true",
      fields: [
        { bits: "5-1:0",
          name: "CL_TAG",
          desc: "Tag Address"
        }
      ]
    },
    {
      name:     "STATUS_1643",
      desc:     "Status register of cache line 1643",
      swaccess: "rw",
      hwaccess: "hrw",
      hwext:    "true",
      hwqe:     "true", // enable `qe` latched signal of software write pulse
      hwre:     "true",
      fields: [
        {
          bits: "5+3:5", // 2 bits for status
          name: "CL_STATUS",
          desc: "Contain the current status of the corresponding cache line                [0]: valid, [1]: dirty, [2]: cmpt",
        }
      ]
    },
    { name:     "TAG_1643",
      desc:     "Tag Address stored in cache line 1643",
      swaccess: "rw",
      hwaccess: "hrw",
      hwext:    "true",
      hwqe:     "true", // enable `qe` latched signal of software write pulse
      hwre:     "true",
      fields: [
        { bits: "5-1:0",
          name: "CL_TAG",
          desc: "Tag Address"
        }
      ]
    },
    {
      name:     "STATUS_1644",
      desc:     "Status register of cache line 1644",
      swaccess: "rw",
      hwaccess: "hrw",
      hwext:    "true",
      hwqe:     "true", // enable `qe` latched signal of software write pulse
      hwre:     "true",
      fields: [
        {
          bits: "5+3:5", // 2 bits for status
          name: "CL_STATUS",
          desc: "Contain the current status of the corresponding cache line                [0]: valid, [1]: dirty, [2]: cmpt",
        }
      ]
    },
    { name:     "TAG_1644",
      desc:     "Tag Address stored in cache line 1644",
      swaccess: "rw",
      hwaccess: "hrw",
      hwext:    "true",
      hwqe:     "true", // enable `qe` latched signal of software write pulse
      hwre:     "true",
      fields: [
        { bits: "5-1:0",
          name: "CL_TAG",
          desc: "Tag Address"
        }
      ]
    },
    {
      name:     "STATUS_1645",
      desc:     "Status register of cache line 1645",
      swaccess: "rw",
      hwaccess: "hrw",
      hwext:    "true",
      hwqe:     "true", // enable `qe` latched signal of software write pulse
      hwre:     "true",
      fields: [
        {
          bits: "5+3:5", // 2 bits for status
          name: "CL_STATUS",
          desc: "Contain the current status of the corresponding cache line                [0]: valid, [1]: dirty, [2]: cmpt",
        }
      ]
    },
    { name:     "TAG_1645",
      desc:     "Tag Address stored in cache line 1645",
      swaccess: "rw",
      hwaccess: "hrw",
      hwext:    "true",
      hwqe:     "true", // enable `qe` latched signal of software write pulse
      hwre:     "true",
      fields: [
        { bits: "5-1:0",
          name: "CL_TAG",
          desc: "Tag Address"
        }
      ]
    },
    {
      name:     "STATUS_1646",
      desc:     "Status register of cache line 1646",
      swaccess: "rw",
      hwaccess: "hrw",
      hwext:    "true",
      hwqe:     "true", // enable `qe` latched signal of software write pulse
      hwre:     "true",
      fields: [
        {
          bits: "5+3:5", // 2 bits for status
          name: "CL_STATUS",
          desc: "Contain the current status of the corresponding cache line                [0]: valid, [1]: dirty, [2]: cmpt",
        }
      ]
    },
    { name:     "TAG_1646",
      desc:     "Tag Address stored in cache line 1646",
      swaccess: "rw",
      hwaccess: "hrw",
      hwext:    "true",
      hwqe:     "true", // enable `qe` latched signal of software write pulse
      hwre:     "true",
      fields: [
        { bits: "5-1:0",
          name: "CL_TAG",
          desc: "Tag Address"
        }
      ]
    },
    {
      name:     "STATUS_1647",
      desc:     "Status register of cache line 1647",
      swaccess: "rw",
      hwaccess: "hrw",
      hwext:    "true",
      hwqe:     "true", // enable `qe` latched signal of software write pulse
      hwre:     "true",
      fields: [
        {
          bits: "5+3:5", // 2 bits for status
          name: "CL_STATUS",
          desc: "Contain the current status of the corresponding cache line                [0]: valid, [1]: dirty, [2]: cmpt",
        }
      ]
    },
    { name:     "TAG_1647",
      desc:     "Tag Address stored in cache line 1647",
      swaccess: "rw",
      hwaccess: "hrw",
      hwext:    "true",
      hwqe:     "true", // enable `qe` latched signal of software write pulse
      hwre:     "true",
      fields: [
        { bits: "5-1:0",
          name: "CL_TAG",
          desc: "Tag Address"
        }
      ]
    },
    {
      name:     "STATUS_1648",
      desc:     "Status register of cache line 1648",
      swaccess: "rw",
      hwaccess: "hrw",
      hwext:    "true",
      hwqe:     "true", // enable `qe` latched signal of software write pulse
      hwre:     "true",
      fields: [
        {
          bits: "5+3:5", // 2 bits for status
          name: "CL_STATUS",
          desc: "Contain the current status of the corresponding cache line                [0]: valid, [1]: dirty, [2]: cmpt",
        }
      ]
    },
    { name:     "TAG_1648",
      desc:     "Tag Address stored in cache line 1648",
      swaccess: "rw",
      hwaccess: "hrw",
      hwext:    "true",
      hwqe:     "true", // enable `qe` latched signal of software write pulse
      hwre:     "true",
      fields: [
        { bits: "5-1:0",
          name: "CL_TAG",
          desc: "Tag Address"
        }
      ]
    },
    {
      name:     "STATUS_1649",
      desc:     "Status register of cache line 1649",
      swaccess: "rw",
      hwaccess: "hrw",
      hwext:    "true",
      hwqe:     "true", // enable `qe` latched signal of software write pulse
      hwre:     "true",
      fields: [
        {
          bits: "5+3:5", // 2 bits for status
          name: "CL_STATUS",
          desc: "Contain the current status of the corresponding cache line                [0]: valid, [1]: dirty, [2]: cmpt",
        }
      ]
    },
    { name:     "TAG_1649",
      desc:     "Tag Address stored in cache line 1649",
      swaccess: "rw",
      hwaccess: "hrw",
      hwext:    "true",
      hwqe:     "true", // enable `qe` latched signal of software write pulse
      hwre:     "true",
      fields: [
        { bits: "5-1:0",
          name: "CL_TAG",
          desc: "Tag Address"
        }
      ]
    },
    {
      name:     "STATUS_1650",
      desc:     "Status register of cache line 1650",
      swaccess: "rw",
      hwaccess: "hrw",
      hwext:    "true",
      hwqe:     "true", // enable `qe` latched signal of software write pulse
      hwre:     "true",
      fields: [
        {
          bits: "5+3:5", // 2 bits for status
          name: "CL_STATUS",
          desc: "Contain the current status of the corresponding cache line                [0]: valid, [1]: dirty, [2]: cmpt",
        }
      ]
    },
    { name:     "TAG_1650",
      desc:     "Tag Address stored in cache line 1650",
      swaccess: "rw",
      hwaccess: "hrw",
      hwext:    "true",
      hwqe:     "true", // enable `qe` latched signal of software write pulse
      hwre:     "true",
      fields: [
        { bits: "5-1:0",
          name: "CL_TAG",
          desc: "Tag Address"
        }
      ]
    },
    {
      name:     "STATUS_1651",
      desc:     "Status register of cache line 1651",
      swaccess: "rw",
      hwaccess: "hrw",
      hwext:    "true",
      hwqe:     "true", // enable `qe` latched signal of software write pulse
      hwre:     "true",
      fields: [
        {
          bits: "5+3:5", // 2 bits for status
          name: "CL_STATUS",
          desc: "Contain the current status of the corresponding cache line                [0]: valid, [1]: dirty, [2]: cmpt",
        }
      ]
    },
    { name:     "TAG_1651",
      desc:     "Tag Address stored in cache line 1651",
      swaccess: "rw",
      hwaccess: "hrw",
      hwext:    "true",
      hwqe:     "true", // enable `qe` latched signal of software write pulse
      hwre:     "true",
      fields: [
        { bits: "5-1:0",
          name: "CL_TAG",
          desc: "Tag Address"
        }
      ]
    },
    {
      name:     "STATUS_1652",
      desc:     "Status register of cache line 1652",
      swaccess: "rw",
      hwaccess: "hrw",
      hwext:    "true",
      hwqe:     "true", // enable `qe` latched signal of software write pulse
      hwre:     "true",
      fields: [
        {
          bits: "5+3:5", // 2 bits for status
          name: "CL_STATUS",
          desc: "Contain the current status of the corresponding cache line                [0]: valid, [1]: dirty, [2]: cmpt",
        }
      ]
    },
    { name:     "TAG_1652",
      desc:     "Tag Address stored in cache line 1652",
      swaccess: "rw",
      hwaccess: "hrw",
      hwext:    "true",
      hwqe:     "true", // enable `qe` latched signal of software write pulse
      hwre:     "true",
      fields: [
        { bits: "5-1:0",
          name: "CL_TAG",
          desc: "Tag Address"
        }
      ]
    },
    {
      name:     "STATUS_1653",
      desc:     "Status register of cache line 1653",
      swaccess: "rw",
      hwaccess: "hrw",
      hwext:    "true",
      hwqe:     "true", // enable `qe` latched signal of software write pulse
      hwre:     "true",
      fields: [
        {
          bits: "5+3:5", // 2 bits for status
          name: "CL_STATUS",
          desc: "Contain the current status of the corresponding cache line                [0]: valid, [1]: dirty, [2]: cmpt",
        }
      ]
    },
    { name:     "TAG_1653",
      desc:     "Tag Address stored in cache line 1653",
      swaccess: "rw",
      hwaccess: "hrw",
      hwext:    "true",
      hwqe:     "true", // enable `qe` latched signal of software write pulse
      hwre:     "true",
      fields: [
        { bits: "5-1:0",
          name: "CL_TAG",
          desc: "Tag Address"
        }
      ]
    },
    {
      name:     "STATUS_1654",
      desc:     "Status register of cache line 1654",
      swaccess: "rw",
      hwaccess: "hrw",
      hwext:    "true",
      hwqe:     "true", // enable `qe` latched signal of software write pulse
      hwre:     "true",
      fields: [
        {
          bits: "5+3:5", // 2 bits for status
          name: "CL_STATUS",
          desc: "Contain the current status of the corresponding cache line                [0]: valid, [1]: dirty, [2]: cmpt",
        }
      ]
    },
    { name:     "TAG_1654",
      desc:     "Tag Address stored in cache line 1654",
      swaccess: "rw",
      hwaccess: "hrw",
      hwext:    "true",
      hwqe:     "true", // enable `qe` latched signal of software write pulse
      hwre:     "true",
      fields: [
        { bits: "5-1:0",
          name: "CL_TAG",
          desc: "Tag Address"
        }
      ]
    },
    {
      name:     "STATUS_1655",
      desc:     "Status register of cache line 1655",
      swaccess: "rw",
      hwaccess: "hrw",
      hwext:    "true",
      hwqe:     "true", // enable `qe` latched signal of software write pulse
      hwre:     "true",
      fields: [
        {
          bits: "5+3:5", // 2 bits for status
          name: "CL_STATUS",
          desc: "Contain the current status of the corresponding cache line                [0]: valid, [1]: dirty, [2]: cmpt",
        }
      ]
    },
    { name:     "TAG_1655",
      desc:     "Tag Address stored in cache line 1655",
      swaccess: "rw",
      hwaccess: "hrw",
      hwext:    "true",
      hwqe:     "true", // enable `qe` latched signal of software write pulse
      hwre:     "true",
      fields: [
        { bits: "5-1:0",
          name: "CL_TAG",
          desc: "Tag Address"
        }
      ]
    },
    {
      name:     "STATUS_1656",
      desc:     "Status register of cache line 1656",
      swaccess: "rw",
      hwaccess: "hrw",
      hwext:    "true",
      hwqe:     "true", // enable `qe` latched signal of software write pulse
      hwre:     "true",
      fields: [
        {
          bits: "5+3:5", // 2 bits for status
          name: "CL_STATUS",
          desc: "Contain the current status of the corresponding cache line                [0]: valid, [1]: dirty, [2]: cmpt",
        }
      ]
    },
    { name:     "TAG_1656",
      desc:     "Tag Address stored in cache line 1656",
      swaccess: "rw",
      hwaccess: "hrw",
      hwext:    "true",
      hwqe:     "true", // enable `qe` latched signal of software write pulse
      hwre:     "true",
      fields: [
        { bits: "5-1:0",
          name: "CL_TAG",
          desc: "Tag Address"
        }
      ]
    },
    {
      name:     "STATUS_1657",
      desc:     "Status register of cache line 1657",
      swaccess: "rw",
      hwaccess: "hrw",
      hwext:    "true",
      hwqe:     "true", // enable `qe` latched signal of software write pulse
      hwre:     "true",
      fields: [
        {
          bits: "5+3:5", // 2 bits for status
          name: "CL_STATUS",
          desc: "Contain the current status of the corresponding cache line                [0]: valid, [1]: dirty, [2]: cmpt",
        }
      ]
    },
    { name:     "TAG_1657",
      desc:     "Tag Address stored in cache line 1657",
      swaccess: "rw",
      hwaccess: "hrw",
      hwext:    "true",
      hwqe:     "true", // enable `qe` latched signal of software write pulse
      hwre:     "true",
      fields: [
        { bits: "5-1:0",
          name: "CL_TAG",
          desc: "Tag Address"
        }
      ]
    },
    {
      name:     "STATUS_1658",
      desc:     "Status register of cache line 1658",
      swaccess: "rw",
      hwaccess: "hrw",
      hwext:    "true",
      hwqe:     "true", // enable `qe` latched signal of software write pulse
      hwre:     "true",
      fields: [
        {
          bits: "5+3:5", // 2 bits for status
          name: "CL_STATUS",
          desc: "Contain the current status of the corresponding cache line                [0]: valid, [1]: dirty, [2]: cmpt",
        }
      ]
    },
    { name:     "TAG_1658",
      desc:     "Tag Address stored in cache line 1658",
      swaccess: "rw",
      hwaccess: "hrw",
      hwext:    "true",
      hwqe:     "true", // enable `qe` latched signal of software write pulse
      hwre:     "true",
      fields: [
        { bits: "5-1:0",
          name: "CL_TAG",
          desc: "Tag Address"
        }
      ]
    },
    {
      name:     "STATUS_1659",
      desc:     "Status register of cache line 1659",
      swaccess: "rw",
      hwaccess: "hrw",
      hwext:    "true",
      hwqe:     "true", // enable `qe` latched signal of software write pulse
      hwre:     "true",
      fields: [
        {
          bits: "5+3:5", // 2 bits for status
          name: "CL_STATUS",
          desc: "Contain the current status of the corresponding cache line                [0]: valid, [1]: dirty, [2]: cmpt",
        }
      ]
    },
    { name:     "TAG_1659",
      desc:     "Tag Address stored in cache line 1659",
      swaccess: "rw",
      hwaccess: "hrw",
      hwext:    "true",
      hwqe:     "true", // enable `qe` latched signal of software write pulse
      hwre:     "true",
      fields: [
        { bits: "5-1:0",
          name: "CL_TAG",
          desc: "Tag Address"
        }
      ]
    },
    {
      name:     "STATUS_1660",
      desc:     "Status register of cache line 1660",
      swaccess: "rw",
      hwaccess: "hrw",
      hwext:    "true",
      hwqe:     "true", // enable `qe` latched signal of software write pulse
      hwre:     "true",
      fields: [
        {
          bits: "5+3:5", // 2 bits for status
          name: "CL_STATUS",
          desc: "Contain the current status of the corresponding cache line                [0]: valid, [1]: dirty, [2]: cmpt",
        }
      ]
    },
    { name:     "TAG_1660",
      desc:     "Tag Address stored in cache line 1660",
      swaccess: "rw",
      hwaccess: "hrw",
      hwext:    "true",
      hwqe:     "true", // enable `qe` latched signal of software write pulse
      hwre:     "true",
      fields: [
        { bits: "5-1:0",
          name: "CL_TAG",
          desc: "Tag Address"
        }
      ]
    },
    {
      name:     "STATUS_1661",
      desc:     "Status register of cache line 1661",
      swaccess: "rw",
      hwaccess: "hrw",
      hwext:    "true",
      hwqe:     "true", // enable `qe` latched signal of software write pulse
      hwre:     "true",
      fields: [
        {
          bits: "5+3:5", // 2 bits for status
          name: "CL_STATUS",
          desc: "Contain the current status of the corresponding cache line                [0]: valid, [1]: dirty, [2]: cmpt",
        }
      ]
    },
    { name:     "TAG_1661",
      desc:     "Tag Address stored in cache line 1661",
      swaccess: "rw",
      hwaccess: "hrw",
      hwext:    "true",
      hwqe:     "true", // enable `qe` latched signal of software write pulse
      hwre:     "true",
      fields: [
        { bits: "5-1:0",
          name: "CL_TAG",
          desc: "Tag Address"
        }
      ]
    },
    {
      name:     "STATUS_1662",
      desc:     "Status register of cache line 1662",
      swaccess: "rw",
      hwaccess: "hrw",
      hwext:    "true",
      hwqe:     "true", // enable `qe` latched signal of software write pulse
      hwre:     "true",
      fields: [
        {
          bits: "5+3:5", // 2 bits for status
          name: "CL_STATUS",
          desc: "Contain the current status of the corresponding cache line                [0]: valid, [1]: dirty, [2]: cmpt",
        }
      ]
    },
    { name:     "TAG_1662",
      desc:     "Tag Address stored in cache line 1662",
      swaccess: "rw",
      hwaccess: "hrw",
      hwext:    "true",
      hwqe:     "true", // enable `qe` latched signal of software write pulse
      hwre:     "true",
      fields: [
        { bits: "5-1:0",
          name: "CL_TAG",
          desc: "Tag Address"
        }
      ]
    },
    {
      name:     "STATUS_1663",
      desc:     "Status register of cache line 1663",
      swaccess: "rw",
      hwaccess: "hrw",
      hwext:    "true",
      hwqe:     "true", // enable `qe` latched signal of software write pulse
      hwre:     "true",
      fields: [
        {
          bits: "5+3:5", // 2 bits for status
          name: "CL_STATUS",
          desc: "Contain the current status of the corresponding cache line                [0]: valid, [1]: dirty, [2]: cmpt",
        }
      ]
    },
    { name:     "TAG_1663",
      desc:     "Tag Address stored in cache line 1663",
      swaccess: "rw",
      hwaccess: "hrw",
      hwext:    "true",
      hwqe:     "true", // enable `qe` latched signal of software write pulse
      hwre:     "true",
      fields: [
        { bits: "5-1:0",
          name: "CL_TAG",
          desc: "Tag Address"
        }
      ]
    },
    {
      name:     "STATUS_1664",
      desc:     "Status register of cache line 1664",
      swaccess: "rw",
      hwaccess: "hrw",
      hwext:    "true",
      hwqe:     "true", // enable `qe` latched signal of software write pulse
      hwre:     "true",
      fields: [
        {
          bits: "5+3:5", // 2 bits for status
          name: "CL_STATUS",
          desc: "Contain the current status of the corresponding cache line                [0]: valid, [1]: dirty, [2]: cmpt",
        }
      ]
    },
    { name:     "TAG_1664",
      desc:     "Tag Address stored in cache line 1664",
      swaccess: "rw",
      hwaccess: "hrw",
      hwext:    "true",
      hwqe:     "true", // enable `qe` latched signal of software write pulse
      hwre:     "true",
      fields: [
        { bits: "5-1:0",
          name: "CL_TAG",
          desc: "Tag Address"
        }
      ]
    },
    {
      name:     "STATUS_1665",
      desc:     "Status register of cache line 1665",
      swaccess: "rw",
      hwaccess: "hrw",
      hwext:    "true",
      hwqe:     "true", // enable `qe` latched signal of software write pulse
      hwre:     "true",
      fields: [
        {
          bits: "5+3:5", // 2 bits for status
          name: "CL_STATUS",
          desc: "Contain the current status of the corresponding cache line                [0]: valid, [1]: dirty, [2]: cmpt",
        }
      ]
    },
    { name:     "TAG_1665",
      desc:     "Tag Address stored in cache line 1665",
      swaccess: "rw",
      hwaccess: "hrw",
      hwext:    "true",
      hwqe:     "true", // enable `qe` latched signal of software write pulse
      hwre:     "true",
      fields: [
        { bits: "5-1:0",
          name: "CL_TAG",
          desc: "Tag Address"
        }
      ]
    },
    {
      name:     "STATUS_1666",
      desc:     "Status register of cache line 1666",
      swaccess: "rw",
      hwaccess: "hrw",
      hwext:    "true",
      hwqe:     "true", // enable `qe` latched signal of software write pulse
      hwre:     "true",
      fields: [
        {
          bits: "5+3:5", // 2 bits for status
          name: "CL_STATUS",
          desc: "Contain the current status of the corresponding cache line                [0]: valid, [1]: dirty, [2]: cmpt",
        }
      ]
    },
    { name:     "TAG_1666",
      desc:     "Tag Address stored in cache line 1666",
      swaccess: "rw",
      hwaccess: "hrw",
      hwext:    "true",
      hwqe:     "true", // enable `qe` latched signal of software write pulse
      hwre:     "true",
      fields: [
        { bits: "5-1:0",
          name: "CL_TAG",
          desc: "Tag Address"
        }
      ]
    },
    {
      name:     "STATUS_1667",
      desc:     "Status register of cache line 1667",
      swaccess: "rw",
      hwaccess: "hrw",
      hwext:    "true",
      hwqe:     "true", // enable `qe` latched signal of software write pulse
      hwre:     "true",
      fields: [
        {
          bits: "5+3:5", // 2 bits for status
          name: "CL_STATUS",
          desc: "Contain the current status of the corresponding cache line                [0]: valid, [1]: dirty, [2]: cmpt",
        }
      ]
    },
    { name:     "TAG_1667",
      desc:     "Tag Address stored in cache line 1667",
      swaccess: "rw",
      hwaccess: "hrw",
      hwext:    "true",
      hwqe:     "true", // enable `qe` latched signal of software write pulse
      hwre:     "true",
      fields: [
        { bits: "5-1:0",
          name: "CL_TAG",
          desc: "Tag Address"
        }
      ]
    },
    {
      name:     "STATUS_1668",
      desc:     "Status register of cache line 1668",
      swaccess: "rw",
      hwaccess: "hrw",
      hwext:    "true",
      hwqe:     "true", // enable `qe` latched signal of software write pulse
      hwre:     "true",
      fields: [
        {
          bits: "5+3:5", // 2 bits for status
          name: "CL_STATUS",
          desc: "Contain the current status of the corresponding cache line                [0]: valid, [1]: dirty, [2]: cmpt",
        }
      ]
    },
    { name:     "TAG_1668",
      desc:     "Tag Address stored in cache line 1668",
      swaccess: "rw",
      hwaccess: "hrw",
      hwext:    "true",
      hwqe:     "true", // enable `qe` latched signal of software write pulse
      hwre:     "true",
      fields: [
        { bits: "5-1:0",
          name: "CL_TAG",
          desc: "Tag Address"
        }
      ]
    },
    {
      name:     "STATUS_1669",
      desc:     "Status register of cache line 1669",
      swaccess: "rw",
      hwaccess: "hrw",
      hwext:    "true",
      hwqe:     "true", // enable `qe` latched signal of software write pulse
      hwre:     "true",
      fields: [
        {
          bits: "5+3:5", // 2 bits for status
          name: "CL_STATUS",
          desc: "Contain the current status of the corresponding cache line                [0]: valid, [1]: dirty, [2]: cmpt",
        }
      ]
    },
    { name:     "TAG_1669",
      desc:     "Tag Address stored in cache line 1669",
      swaccess: "rw",
      hwaccess: "hrw",
      hwext:    "true",
      hwqe:     "true", // enable `qe` latched signal of software write pulse
      hwre:     "true",
      fields: [
        { bits: "5-1:0",
          name: "CL_TAG",
          desc: "Tag Address"
        }
      ]
    },
    {
      name:     "STATUS_1670",
      desc:     "Status register of cache line 1670",
      swaccess: "rw",
      hwaccess: "hrw",
      hwext:    "true",
      hwqe:     "true", // enable `qe` latched signal of software write pulse
      hwre:     "true",
      fields: [
        {
          bits: "5+3:5", // 2 bits for status
          name: "CL_STATUS",
          desc: "Contain the current status of the corresponding cache line                [0]: valid, [1]: dirty, [2]: cmpt",
        }
      ]
    },
    { name:     "TAG_1670",
      desc:     "Tag Address stored in cache line 1670",
      swaccess: "rw",
      hwaccess: "hrw",
      hwext:    "true",
      hwqe:     "true", // enable `qe` latched signal of software write pulse
      hwre:     "true",
      fields: [
        { bits: "5-1:0",
          name: "CL_TAG",
          desc: "Tag Address"
        }
      ]
    },
    {
      name:     "STATUS_1671",
      desc:     "Status register of cache line 1671",
      swaccess: "rw",
      hwaccess: "hrw",
      hwext:    "true",
      hwqe:     "true", // enable `qe` latched signal of software write pulse
      hwre:     "true",
      fields: [
        {
          bits: "5+3:5", // 2 bits for status
          name: "CL_STATUS",
          desc: "Contain the current status of the corresponding cache line                [0]: valid, [1]: dirty, [2]: cmpt",
        }
      ]
    },
    { name:     "TAG_1671",
      desc:     "Tag Address stored in cache line 1671",
      swaccess: "rw",
      hwaccess: "hrw",
      hwext:    "true",
      hwqe:     "true", // enable `qe` latched signal of software write pulse
      hwre:     "true",
      fields: [
        { bits: "5-1:0",
          name: "CL_TAG",
          desc: "Tag Address"
        }
      ]
    },
    {
      name:     "STATUS_1672",
      desc:     "Status register of cache line 1672",
      swaccess: "rw",
      hwaccess: "hrw",
      hwext:    "true",
      hwqe:     "true", // enable `qe` latched signal of software write pulse
      hwre:     "true",
      fields: [
        {
          bits: "5+3:5", // 2 bits for status
          name: "CL_STATUS",
          desc: "Contain the current status of the corresponding cache line                [0]: valid, [1]: dirty, [2]: cmpt",
        }
      ]
    },
    { name:     "TAG_1672",
      desc:     "Tag Address stored in cache line 1672",
      swaccess: "rw",
      hwaccess: "hrw",
      hwext:    "true",
      hwqe:     "true", // enable `qe` latched signal of software write pulse
      hwre:     "true",
      fields: [
        { bits: "5-1:0",
          name: "CL_TAG",
          desc: "Tag Address"
        }
      ]
    },
    {
      name:     "STATUS_1673",
      desc:     "Status register of cache line 1673",
      swaccess: "rw",
      hwaccess: "hrw",
      hwext:    "true",
      hwqe:     "true", // enable `qe` latched signal of software write pulse
      hwre:     "true",
      fields: [
        {
          bits: "5+3:5", // 2 bits for status
          name: "CL_STATUS",
          desc: "Contain the current status of the corresponding cache line                [0]: valid, [1]: dirty, [2]: cmpt",
        }
      ]
    },
    { name:     "TAG_1673",
      desc:     "Tag Address stored in cache line 1673",
      swaccess: "rw",
      hwaccess: "hrw",
      hwext:    "true",
      hwqe:     "true", // enable `qe` latched signal of software write pulse
      hwre:     "true",
      fields: [
        { bits: "5-1:0",
          name: "CL_TAG",
          desc: "Tag Address"
        }
      ]
    },
    {
      name:     "STATUS_1674",
      desc:     "Status register of cache line 1674",
      swaccess: "rw",
      hwaccess: "hrw",
      hwext:    "true",
      hwqe:     "true", // enable `qe` latched signal of software write pulse
      hwre:     "true",
      fields: [
        {
          bits: "5+3:5", // 2 bits for status
          name: "CL_STATUS",
          desc: "Contain the current status of the corresponding cache line                [0]: valid, [1]: dirty, [2]: cmpt",
        }
      ]
    },
    { name:     "TAG_1674",
      desc:     "Tag Address stored in cache line 1674",
      swaccess: "rw",
      hwaccess: "hrw",
      hwext:    "true",
      hwqe:     "true", // enable `qe` latched signal of software write pulse
      hwre:     "true",
      fields: [
        { bits: "5-1:0",
          name: "CL_TAG",
          desc: "Tag Address"
        }
      ]
    },
    {
      name:     "STATUS_1675",
      desc:     "Status register of cache line 1675",
      swaccess: "rw",
      hwaccess: "hrw",
      hwext:    "true",
      hwqe:     "true", // enable `qe` latched signal of software write pulse
      hwre:     "true",
      fields: [
        {
          bits: "5+3:5", // 2 bits for status
          name: "CL_STATUS",
          desc: "Contain the current status of the corresponding cache line                [0]: valid, [1]: dirty, [2]: cmpt",
        }
      ]
    },
    { name:     "TAG_1675",
      desc:     "Tag Address stored in cache line 1675",
      swaccess: "rw",
      hwaccess: "hrw",
      hwext:    "true",
      hwqe:     "true", // enable `qe` latched signal of software write pulse
      hwre:     "true",
      fields: [
        { bits: "5-1:0",
          name: "CL_TAG",
          desc: "Tag Address"
        }
      ]
    },
    {
      name:     "STATUS_1676",
      desc:     "Status register of cache line 1676",
      swaccess: "rw",
      hwaccess: "hrw",
      hwext:    "true",
      hwqe:     "true", // enable `qe` latched signal of software write pulse
      hwre:     "true",
      fields: [
        {
          bits: "5+3:5", // 2 bits for status
          name: "CL_STATUS",
          desc: "Contain the current status of the corresponding cache line                [0]: valid, [1]: dirty, [2]: cmpt",
        }
      ]
    },
    { name:     "TAG_1676",
      desc:     "Tag Address stored in cache line 1676",
      swaccess: "rw",
      hwaccess: "hrw",
      hwext:    "true",
      hwqe:     "true", // enable `qe` latched signal of software write pulse
      hwre:     "true",
      fields: [
        { bits: "5-1:0",
          name: "CL_TAG",
          desc: "Tag Address"
        }
      ]
    },
    {
      name:     "STATUS_1677",
      desc:     "Status register of cache line 1677",
      swaccess: "rw",
      hwaccess: "hrw",
      hwext:    "true",
      hwqe:     "true", // enable `qe` latched signal of software write pulse
      hwre:     "true",
      fields: [
        {
          bits: "5+3:5", // 2 bits for status
          name: "CL_STATUS",
          desc: "Contain the current status of the corresponding cache line                [0]: valid, [1]: dirty, [2]: cmpt",
        }
      ]
    },
    { name:     "TAG_1677",
      desc:     "Tag Address stored in cache line 1677",
      swaccess: "rw",
      hwaccess: "hrw",
      hwext:    "true",
      hwqe:     "true", // enable `qe` latched signal of software write pulse
      hwre:     "true",
      fields: [
        { bits: "5-1:0",
          name: "CL_TAG",
          desc: "Tag Address"
        }
      ]
    },
    {
      name:     "STATUS_1678",
      desc:     "Status register of cache line 1678",
      swaccess: "rw",
      hwaccess: "hrw",
      hwext:    "true",
      hwqe:     "true", // enable `qe` latched signal of software write pulse
      hwre:     "true",
      fields: [
        {
          bits: "5+3:5", // 2 bits for status
          name: "CL_STATUS",
          desc: "Contain the current status of the corresponding cache line                [0]: valid, [1]: dirty, [2]: cmpt",
        }
      ]
    },
    { name:     "TAG_1678",
      desc:     "Tag Address stored in cache line 1678",
      swaccess: "rw",
      hwaccess: "hrw",
      hwext:    "true",
      hwqe:     "true", // enable `qe` latched signal of software write pulse
      hwre:     "true",
      fields: [
        { bits: "5-1:0",
          name: "CL_TAG",
          desc: "Tag Address"
        }
      ]
    },
    {
      name:     "STATUS_1679",
      desc:     "Status register of cache line 1679",
      swaccess: "rw",
      hwaccess: "hrw",
      hwext:    "true",
      hwqe:     "true", // enable `qe` latched signal of software write pulse
      hwre:     "true",
      fields: [
        {
          bits: "5+3:5", // 2 bits for status
          name: "CL_STATUS",
          desc: "Contain the current status of the corresponding cache line                [0]: valid, [1]: dirty, [2]: cmpt",
        }
      ]
    },
    { name:     "TAG_1679",
      desc:     "Tag Address stored in cache line 1679",
      swaccess: "rw",
      hwaccess: "hrw",
      hwext:    "true",
      hwqe:     "true", // enable `qe` latched signal of software write pulse
      hwre:     "true",
      fields: [
        { bits: "5-1:0",
          name: "CL_TAG",
          desc: "Tag Address"
        }
      ]
    },
    {
      name:     "STATUS_1680",
      desc:     "Status register of cache line 1680",
      swaccess: "rw",
      hwaccess: "hrw",
      hwext:    "true",
      hwqe:     "true", // enable `qe` latched signal of software write pulse
      hwre:     "true",
      fields: [
        {
          bits: "5+3:5", // 2 bits for status
          name: "CL_STATUS",
          desc: "Contain the current status of the corresponding cache line                [0]: valid, [1]: dirty, [2]: cmpt",
        }
      ]
    },
    { name:     "TAG_1680",
      desc:     "Tag Address stored in cache line 1680",
      swaccess: "rw",
      hwaccess: "hrw",
      hwext:    "true",
      hwqe:     "true", // enable `qe` latched signal of software write pulse
      hwre:     "true",
      fields: [
        { bits: "5-1:0",
          name: "CL_TAG",
          desc: "Tag Address"
        }
      ]
    },
    {
      name:     "STATUS_1681",
      desc:     "Status register of cache line 1681",
      swaccess: "rw",
      hwaccess: "hrw",
      hwext:    "true",
      hwqe:     "true", // enable `qe` latched signal of software write pulse
      hwre:     "true",
      fields: [
        {
          bits: "5+3:5", // 2 bits for status
          name: "CL_STATUS",
          desc: "Contain the current status of the corresponding cache line                [0]: valid, [1]: dirty, [2]: cmpt",
        }
      ]
    },
    { name:     "TAG_1681",
      desc:     "Tag Address stored in cache line 1681",
      swaccess: "rw",
      hwaccess: "hrw",
      hwext:    "true",
      hwqe:     "true", // enable `qe` latched signal of software write pulse
      hwre:     "true",
      fields: [
        { bits: "5-1:0",
          name: "CL_TAG",
          desc: "Tag Address"
        }
      ]
    },
    {
      name:     "STATUS_1682",
      desc:     "Status register of cache line 1682",
      swaccess: "rw",
      hwaccess: "hrw",
      hwext:    "true",
      hwqe:     "true", // enable `qe` latched signal of software write pulse
      hwre:     "true",
      fields: [
        {
          bits: "5+3:5", // 2 bits for status
          name: "CL_STATUS",
          desc: "Contain the current status of the corresponding cache line                [0]: valid, [1]: dirty, [2]: cmpt",
        }
      ]
    },
    { name:     "TAG_1682",
      desc:     "Tag Address stored in cache line 1682",
      swaccess: "rw",
      hwaccess: "hrw",
      hwext:    "true",
      hwqe:     "true", // enable `qe` latched signal of software write pulse
      hwre:     "true",
      fields: [
        { bits: "5-1:0",
          name: "CL_TAG",
          desc: "Tag Address"
        }
      ]
    },
    {
      name:     "STATUS_1683",
      desc:     "Status register of cache line 1683",
      swaccess: "rw",
      hwaccess: "hrw",
      hwext:    "true",
      hwqe:     "true", // enable `qe` latched signal of software write pulse
      hwre:     "true",
      fields: [
        {
          bits: "5+3:5", // 2 bits for status
          name: "CL_STATUS",
          desc: "Contain the current status of the corresponding cache line                [0]: valid, [1]: dirty, [2]: cmpt",
        }
      ]
    },
    { name:     "TAG_1683",
      desc:     "Tag Address stored in cache line 1683",
      swaccess: "rw",
      hwaccess: "hrw",
      hwext:    "true",
      hwqe:     "true", // enable `qe` latched signal of software write pulse
      hwre:     "true",
      fields: [
        { bits: "5-1:0",
          name: "CL_TAG",
          desc: "Tag Address"
        }
      ]
    },
    {
      name:     "STATUS_1684",
      desc:     "Status register of cache line 1684",
      swaccess: "rw",
      hwaccess: "hrw",
      hwext:    "true",
      hwqe:     "true", // enable `qe` latched signal of software write pulse
      hwre:     "true",
      fields: [
        {
          bits: "5+3:5", // 2 bits for status
          name: "CL_STATUS",
          desc: "Contain the current status of the corresponding cache line                [0]: valid, [1]: dirty, [2]: cmpt",
        }
      ]
    },
    { name:     "TAG_1684",
      desc:     "Tag Address stored in cache line 1684",
      swaccess: "rw",
      hwaccess: "hrw",
      hwext:    "true",
      hwqe:     "true", // enable `qe` latched signal of software write pulse
      hwre:     "true",
      fields: [
        { bits: "5-1:0",
          name: "CL_TAG",
          desc: "Tag Address"
        }
      ]
    },
    {
      name:     "STATUS_1685",
      desc:     "Status register of cache line 1685",
      swaccess: "rw",
      hwaccess: "hrw",
      hwext:    "true",
      hwqe:     "true", // enable `qe` latched signal of software write pulse
      hwre:     "true",
      fields: [
        {
          bits: "5+3:5", // 2 bits for status
          name: "CL_STATUS",
          desc: "Contain the current status of the corresponding cache line                [0]: valid, [1]: dirty, [2]: cmpt",
        }
      ]
    },
    { name:     "TAG_1685",
      desc:     "Tag Address stored in cache line 1685",
      swaccess: "rw",
      hwaccess: "hrw",
      hwext:    "true",
      hwqe:     "true", // enable `qe` latched signal of software write pulse
      hwre:     "true",
      fields: [
        { bits: "5-1:0",
          name: "CL_TAG",
          desc: "Tag Address"
        }
      ]
    },
    {
      name:     "STATUS_1686",
      desc:     "Status register of cache line 1686",
      swaccess: "rw",
      hwaccess: "hrw",
      hwext:    "true",
      hwqe:     "true", // enable `qe` latched signal of software write pulse
      hwre:     "true",
      fields: [
        {
          bits: "5+3:5", // 2 bits for status
          name: "CL_STATUS",
          desc: "Contain the current status of the corresponding cache line                [0]: valid, [1]: dirty, [2]: cmpt",
        }
      ]
    },
    { name:     "TAG_1686",
      desc:     "Tag Address stored in cache line 1686",
      swaccess: "rw",
      hwaccess: "hrw",
      hwext:    "true",
      hwqe:     "true", // enable `qe` latched signal of software write pulse
      hwre:     "true",
      fields: [
        { bits: "5-1:0",
          name: "CL_TAG",
          desc: "Tag Address"
        }
      ]
    },
    {
      name:     "STATUS_1687",
      desc:     "Status register of cache line 1687",
      swaccess: "rw",
      hwaccess: "hrw",
      hwext:    "true",
      hwqe:     "true", // enable `qe` latched signal of software write pulse
      hwre:     "true",
      fields: [
        {
          bits: "5+3:5", // 2 bits for status
          name: "CL_STATUS",
          desc: "Contain the current status of the corresponding cache line                [0]: valid, [1]: dirty, [2]: cmpt",
        }
      ]
    },
    { name:     "TAG_1687",
      desc:     "Tag Address stored in cache line 1687",
      swaccess: "rw",
      hwaccess: "hrw",
      hwext:    "true",
      hwqe:     "true", // enable `qe` latched signal of software write pulse
      hwre:     "true",
      fields: [
        { bits: "5-1:0",
          name: "CL_TAG",
          desc: "Tag Address"
        }
      ]
    },
    {
      name:     "STATUS_1688",
      desc:     "Status register of cache line 1688",
      swaccess: "rw",
      hwaccess: "hrw",
      hwext:    "true",
      hwqe:     "true", // enable `qe` latched signal of software write pulse
      hwre:     "true",
      fields: [
        {
          bits: "5+3:5", // 2 bits for status
          name: "CL_STATUS",
          desc: "Contain the current status of the corresponding cache line                [0]: valid, [1]: dirty, [2]: cmpt",
        }
      ]
    },
    { name:     "TAG_1688",
      desc:     "Tag Address stored in cache line 1688",
      swaccess: "rw",
      hwaccess: "hrw",
      hwext:    "true",
      hwqe:     "true", // enable `qe` latched signal of software write pulse
      hwre:     "true",
      fields: [
        { bits: "5-1:0",
          name: "CL_TAG",
          desc: "Tag Address"
        }
      ]
    },
    {
      name:     "STATUS_1689",
      desc:     "Status register of cache line 1689",
      swaccess: "rw",
      hwaccess: "hrw",
      hwext:    "true",
      hwqe:     "true", // enable `qe` latched signal of software write pulse
      hwre:     "true",
      fields: [
        {
          bits: "5+3:5", // 2 bits for status
          name: "CL_STATUS",
          desc: "Contain the current status of the corresponding cache line                [0]: valid, [1]: dirty, [2]: cmpt",
        }
      ]
    },
    { name:     "TAG_1689",
      desc:     "Tag Address stored in cache line 1689",
      swaccess: "rw",
      hwaccess: "hrw",
      hwext:    "true",
      hwqe:     "true", // enable `qe` latched signal of software write pulse
      hwre:     "true",
      fields: [
        { bits: "5-1:0",
          name: "CL_TAG",
          desc: "Tag Address"
        }
      ]
    },
    {
      name:     "STATUS_1690",
      desc:     "Status register of cache line 1690",
      swaccess: "rw",
      hwaccess: "hrw",
      hwext:    "true",
      hwqe:     "true", // enable `qe` latched signal of software write pulse
      hwre:     "true",
      fields: [
        {
          bits: "5+3:5", // 2 bits for status
          name: "CL_STATUS",
          desc: "Contain the current status of the corresponding cache line                [0]: valid, [1]: dirty, [2]: cmpt",
        }
      ]
    },
    { name:     "TAG_1690",
      desc:     "Tag Address stored in cache line 1690",
      swaccess: "rw",
      hwaccess: "hrw",
      hwext:    "true",
      hwqe:     "true", // enable `qe` latched signal of software write pulse
      hwre:     "true",
      fields: [
        { bits: "5-1:0",
          name: "CL_TAG",
          desc: "Tag Address"
        }
      ]
    },
    {
      name:     "STATUS_1691",
      desc:     "Status register of cache line 1691",
      swaccess: "rw",
      hwaccess: "hrw",
      hwext:    "true",
      hwqe:     "true", // enable `qe` latched signal of software write pulse
      hwre:     "true",
      fields: [
        {
          bits: "5+3:5", // 2 bits for status
          name: "CL_STATUS",
          desc: "Contain the current status of the corresponding cache line                [0]: valid, [1]: dirty, [2]: cmpt",
        }
      ]
    },
    { name:     "TAG_1691",
      desc:     "Tag Address stored in cache line 1691",
      swaccess: "rw",
      hwaccess: "hrw",
      hwext:    "true",
      hwqe:     "true", // enable `qe` latched signal of software write pulse
      hwre:     "true",
      fields: [
        { bits: "5-1:0",
          name: "CL_TAG",
          desc: "Tag Address"
        }
      ]
    },
    {
      name:     "STATUS_1692",
      desc:     "Status register of cache line 1692",
      swaccess: "rw",
      hwaccess: "hrw",
      hwext:    "true",
      hwqe:     "true", // enable `qe` latched signal of software write pulse
      hwre:     "true",
      fields: [
        {
          bits: "5+3:5", // 2 bits for status
          name: "CL_STATUS",
          desc: "Contain the current status of the corresponding cache line                [0]: valid, [1]: dirty, [2]: cmpt",
        }
      ]
    },
    { name:     "TAG_1692",
      desc:     "Tag Address stored in cache line 1692",
      swaccess: "rw",
      hwaccess: "hrw",
      hwext:    "true",
      hwqe:     "true", // enable `qe` latched signal of software write pulse
      hwre:     "true",
      fields: [
        { bits: "5-1:0",
          name: "CL_TAG",
          desc: "Tag Address"
        }
      ]
    },
    {
      name:     "STATUS_1693",
      desc:     "Status register of cache line 1693",
      swaccess: "rw",
      hwaccess: "hrw",
      hwext:    "true",
      hwqe:     "true", // enable `qe` latched signal of software write pulse
      hwre:     "true",
      fields: [
        {
          bits: "5+3:5", // 2 bits for status
          name: "CL_STATUS",
          desc: "Contain the current status of the corresponding cache line                [0]: valid, [1]: dirty, [2]: cmpt",
        }
      ]
    },
    { name:     "TAG_1693",
      desc:     "Tag Address stored in cache line 1693",
      swaccess: "rw",
      hwaccess: "hrw",
      hwext:    "true",
      hwqe:     "true", // enable `qe` latched signal of software write pulse
      hwre:     "true",
      fields: [
        { bits: "5-1:0",
          name: "CL_TAG",
          desc: "Tag Address"
        }
      ]
    },
    {
      name:     "STATUS_1694",
      desc:     "Status register of cache line 1694",
      swaccess: "rw",
      hwaccess: "hrw",
      hwext:    "true",
      hwqe:     "true", // enable `qe` latched signal of software write pulse
      hwre:     "true",
      fields: [
        {
          bits: "5+3:5", // 2 bits for status
          name: "CL_STATUS",
          desc: "Contain the current status of the corresponding cache line                [0]: valid, [1]: dirty, [2]: cmpt",
        }
      ]
    },
    { name:     "TAG_1694",
      desc:     "Tag Address stored in cache line 1694",
      swaccess: "rw",
      hwaccess: "hrw",
      hwext:    "true",
      hwqe:     "true", // enable `qe` latched signal of software write pulse
      hwre:     "true",
      fields: [
        { bits: "5-1:0",
          name: "CL_TAG",
          desc: "Tag Address"
        }
      ]
    },
    {
      name:     "STATUS_1695",
      desc:     "Status register of cache line 1695",
      swaccess: "rw",
      hwaccess: "hrw",
      hwext:    "true",
      hwqe:     "true", // enable `qe` latched signal of software write pulse
      hwre:     "true",
      fields: [
        {
          bits: "5+3:5", // 2 bits for status
          name: "CL_STATUS",
          desc: "Contain the current status of the corresponding cache line                [0]: valid, [1]: dirty, [2]: cmpt",
        }
      ]
    },
    { name:     "TAG_1695",
      desc:     "Tag Address stored in cache line 1695",
      swaccess: "rw",
      hwaccess: "hrw",
      hwext:    "true",
      hwqe:     "true", // enable `qe` latched signal of software write pulse
      hwre:     "true",
      fields: [
        { bits: "5-1:0",
          name: "CL_TAG",
          desc: "Tag Address"
        }
      ]
    },
    {
      name:     "STATUS_1696",
      desc:     "Status register of cache line 1696",
      swaccess: "rw",
      hwaccess: "hrw",
      hwext:    "true",
      hwqe:     "true", // enable `qe` latched signal of software write pulse
      hwre:     "true",
      fields: [
        {
          bits: "5+3:5", // 2 bits for status
          name: "CL_STATUS",
          desc: "Contain the current status of the corresponding cache line                [0]: valid, [1]: dirty, [2]: cmpt",
        }
      ]
    },
    { name:     "TAG_1696",
      desc:     "Tag Address stored in cache line 1696",
      swaccess: "rw",
      hwaccess: "hrw",
      hwext:    "true",
      hwqe:     "true", // enable `qe` latched signal of software write pulse
      hwre:     "true",
      fields: [
        { bits: "5-1:0",
          name: "CL_TAG",
          desc: "Tag Address"
        }
      ]
    },
    {
      name:     "STATUS_1697",
      desc:     "Status register of cache line 1697",
      swaccess: "rw",
      hwaccess: "hrw",
      hwext:    "true",
      hwqe:     "true", // enable `qe` latched signal of software write pulse
      hwre:     "true",
      fields: [
        {
          bits: "5+3:5", // 2 bits for status
          name: "CL_STATUS",
          desc: "Contain the current status of the corresponding cache line                [0]: valid, [1]: dirty, [2]: cmpt",
        }
      ]
    },
    { name:     "TAG_1697",
      desc:     "Tag Address stored in cache line 1697",
      swaccess: "rw",
      hwaccess: "hrw",
      hwext:    "true",
      hwqe:     "true", // enable `qe` latched signal of software write pulse
      hwre:     "true",
      fields: [
        { bits: "5-1:0",
          name: "CL_TAG",
          desc: "Tag Address"
        }
      ]
    },
    {
      name:     "STATUS_1698",
      desc:     "Status register of cache line 1698",
      swaccess: "rw",
      hwaccess: "hrw",
      hwext:    "true",
      hwqe:     "true", // enable `qe` latched signal of software write pulse
      hwre:     "true",
      fields: [
        {
          bits: "5+3:5", // 2 bits for status
          name: "CL_STATUS",
          desc: "Contain the current status of the corresponding cache line                [0]: valid, [1]: dirty, [2]: cmpt",
        }
      ]
    },
    { name:     "TAG_1698",
      desc:     "Tag Address stored in cache line 1698",
      swaccess: "rw",
      hwaccess: "hrw",
      hwext:    "true",
      hwqe:     "true", // enable `qe` latched signal of software write pulse
      hwre:     "true",
      fields: [
        { bits: "5-1:0",
          name: "CL_TAG",
          desc: "Tag Address"
        }
      ]
    },
    {
      name:     "STATUS_1699",
      desc:     "Status register of cache line 1699",
      swaccess: "rw",
      hwaccess: "hrw",
      hwext:    "true",
      hwqe:     "true", // enable `qe` latched signal of software write pulse
      hwre:     "true",
      fields: [
        {
          bits: "5+3:5", // 2 bits for status
          name: "CL_STATUS",
          desc: "Contain the current status of the corresponding cache line                [0]: valid, [1]: dirty, [2]: cmpt",
        }
      ]
    },
    { name:     "TAG_1699",
      desc:     "Tag Address stored in cache line 1699",
      swaccess: "rw",
      hwaccess: "hrw",
      hwext:    "true",
      hwqe:     "true", // enable `qe` latched signal of software write pulse
      hwre:     "true",
      fields: [
        { bits: "5-1:0",
          name: "CL_TAG",
          desc: "Tag Address"
        }
      ]
    },
    {
      name:     "STATUS_1700",
      desc:     "Status register of cache line 1700",
      swaccess: "rw",
      hwaccess: "hrw",
      hwext:    "true",
      hwqe:     "true", // enable `qe` latched signal of software write pulse
      hwre:     "true",
      fields: [
        {
          bits: "5+3:5", // 2 bits for status
          name: "CL_STATUS",
          desc: "Contain the current status of the corresponding cache line                [0]: valid, [1]: dirty, [2]: cmpt",
        }
      ]
    },
    { name:     "TAG_1700",
      desc:     "Tag Address stored in cache line 1700",
      swaccess: "rw",
      hwaccess: "hrw",
      hwext:    "true",
      hwqe:     "true", // enable `qe` latched signal of software write pulse
      hwre:     "true",
      fields: [
        { bits: "5-1:0",
          name: "CL_TAG",
          desc: "Tag Address"
        }
      ]
    },
    {
      name:     "STATUS_1701",
      desc:     "Status register of cache line 1701",
      swaccess: "rw",
      hwaccess: "hrw",
      hwext:    "true",
      hwqe:     "true", // enable `qe` latched signal of software write pulse
      hwre:     "true",
      fields: [
        {
          bits: "5+3:5", // 2 bits for status
          name: "CL_STATUS",
          desc: "Contain the current status of the corresponding cache line                [0]: valid, [1]: dirty, [2]: cmpt",
        }
      ]
    },
    { name:     "TAG_1701",
      desc:     "Tag Address stored in cache line 1701",
      swaccess: "rw",
      hwaccess: "hrw",
      hwext:    "true",
      hwqe:     "true", // enable `qe` latched signal of software write pulse
      hwre:     "true",
      fields: [
        { bits: "5-1:0",
          name: "CL_TAG",
          desc: "Tag Address"
        }
      ]
    },
    {
      name:     "STATUS_1702",
      desc:     "Status register of cache line 1702",
      swaccess: "rw",
      hwaccess: "hrw",
      hwext:    "true",
      hwqe:     "true", // enable `qe` latched signal of software write pulse
      hwre:     "true",
      fields: [
        {
          bits: "5+3:5", // 2 bits for status
          name: "CL_STATUS",
          desc: "Contain the current status of the corresponding cache line                [0]: valid, [1]: dirty, [2]: cmpt",
        }
      ]
    },
    { name:     "TAG_1702",
      desc:     "Tag Address stored in cache line 1702",
      swaccess: "rw",
      hwaccess: "hrw",
      hwext:    "true",
      hwqe:     "true", // enable `qe` latched signal of software write pulse
      hwre:     "true",
      fields: [
        { bits: "5-1:0",
          name: "CL_TAG",
          desc: "Tag Address"
        }
      ]
    },
    {
      name:     "STATUS_1703",
      desc:     "Status register of cache line 1703",
      swaccess: "rw",
      hwaccess: "hrw",
      hwext:    "true",
      hwqe:     "true", // enable `qe` latched signal of software write pulse
      hwre:     "true",
      fields: [
        {
          bits: "5+3:5", // 2 bits for status
          name: "CL_STATUS",
          desc: "Contain the current status of the corresponding cache line                [0]: valid, [1]: dirty, [2]: cmpt",
        }
      ]
    },
    { name:     "TAG_1703",
      desc:     "Tag Address stored in cache line 1703",
      swaccess: "rw",
      hwaccess: "hrw",
      hwext:    "true",
      hwqe:     "true", // enable `qe` latched signal of software write pulse
      hwre:     "true",
      fields: [
        { bits: "5-1:0",
          name: "CL_TAG",
          desc: "Tag Address"
        }
      ]
    },
    {
      name:     "STATUS_1704",
      desc:     "Status register of cache line 1704",
      swaccess: "rw",
      hwaccess: "hrw",
      hwext:    "true",
      hwqe:     "true", // enable `qe` latched signal of software write pulse
      hwre:     "true",
      fields: [
        {
          bits: "5+3:5", // 2 bits for status
          name: "CL_STATUS",
          desc: "Contain the current status of the corresponding cache line                [0]: valid, [1]: dirty, [2]: cmpt",
        }
      ]
    },
    { name:     "TAG_1704",
      desc:     "Tag Address stored in cache line 1704",
      swaccess: "rw",
      hwaccess: "hrw",
      hwext:    "true",
      hwqe:     "true", // enable `qe` latched signal of software write pulse
      hwre:     "true",
      fields: [
        { bits: "5-1:0",
          name: "CL_TAG",
          desc: "Tag Address"
        }
      ]
    },
    {
      name:     "STATUS_1705",
      desc:     "Status register of cache line 1705",
      swaccess: "rw",
      hwaccess: "hrw",
      hwext:    "true",
      hwqe:     "true", // enable `qe` latched signal of software write pulse
      hwre:     "true",
      fields: [
        {
          bits: "5+3:5", // 2 bits for status
          name: "CL_STATUS",
          desc: "Contain the current status of the corresponding cache line                [0]: valid, [1]: dirty, [2]: cmpt",
        }
      ]
    },
    { name:     "TAG_1705",
      desc:     "Tag Address stored in cache line 1705",
      swaccess: "rw",
      hwaccess: "hrw",
      hwext:    "true",
      hwqe:     "true", // enable `qe` latched signal of software write pulse
      hwre:     "true",
      fields: [
        { bits: "5-1:0",
          name: "CL_TAG",
          desc: "Tag Address"
        }
      ]
    },
    {
      name:     "STATUS_1706",
      desc:     "Status register of cache line 1706",
      swaccess: "rw",
      hwaccess: "hrw",
      hwext:    "true",
      hwqe:     "true", // enable `qe` latched signal of software write pulse
      hwre:     "true",
      fields: [
        {
          bits: "5+3:5", // 2 bits for status
          name: "CL_STATUS",
          desc: "Contain the current status of the corresponding cache line                [0]: valid, [1]: dirty, [2]: cmpt",
        }
      ]
    },
    { name:     "TAG_1706",
      desc:     "Tag Address stored in cache line 1706",
      swaccess: "rw",
      hwaccess: "hrw",
      hwext:    "true",
      hwqe:     "true", // enable `qe` latched signal of software write pulse
      hwre:     "true",
      fields: [
        { bits: "5-1:0",
          name: "CL_TAG",
          desc: "Tag Address"
        }
      ]
    },
    {
      name:     "STATUS_1707",
      desc:     "Status register of cache line 1707",
      swaccess: "rw",
      hwaccess: "hrw",
      hwext:    "true",
      hwqe:     "true", // enable `qe` latched signal of software write pulse
      hwre:     "true",
      fields: [
        {
          bits: "5+3:5", // 2 bits for status
          name: "CL_STATUS",
          desc: "Contain the current status of the corresponding cache line                [0]: valid, [1]: dirty, [2]: cmpt",
        }
      ]
    },
    { name:     "TAG_1707",
      desc:     "Tag Address stored in cache line 1707",
      swaccess: "rw",
      hwaccess: "hrw",
      hwext:    "true",
      hwqe:     "true", // enable `qe` latched signal of software write pulse
      hwre:     "true",
      fields: [
        { bits: "5-1:0",
          name: "CL_TAG",
          desc: "Tag Address"
        }
      ]
    },
    {
      name:     "STATUS_1708",
      desc:     "Status register of cache line 1708",
      swaccess: "rw",
      hwaccess: "hrw",
      hwext:    "true",
      hwqe:     "true", // enable `qe` latched signal of software write pulse
      hwre:     "true",
      fields: [
        {
          bits: "5+3:5", // 2 bits for status
          name: "CL_STATUS",
          desc: "Contain the current status of the corresponding cache line                [0]: valid, [1]: dirty, [2]: cmpt",
        }
      ]
    },
    { name:     "TAG_1708",
      desc:     "Tag Address stored in cache line 1708",
      swaccess: "rw",
      hwaccess: "hrw",
      hwext:    "true",
      hwqe:     "true", // enable `qe` latched signal of software write pulse
      hwre:     "true",
      fields: [
        { bits: "5-1:0",
          name: "CL_TAG",
          desc: "Tag Address"
        }
      ]
    },
    {
      name:     "STATUS_1709",
      desc:     "Status register of cache line 1709",
      swaccess: "rw",
      hwaccess: "hrw",
      hwext:    "true",
      hwqe:     "true", // enable `qe` latched signal of software write pulse
      hwre:     "true",
      fields: [
        {
          bits: "5+3:5", // 2 bits for status
          name: "CL_STATUS",
          desc: "Contain the current status of the corresponding cache line                [0]: valid, [1]: dirty, [2]: cmpt",
        }
      ]
    },
    { name:     "TAG_1709",
      desc:     "Tag Address stored in cache line 1709",
      swaccess: "rw",
      hwaccess: "hrw",
      hwext:    "true",
      hwqe:     "true", // enable `qe` latched signal of software write pulse
      hwre:     "true",
      fields: [
        { bits: "5-1:0",
          name: "CL_TAG",
          desc: "Tag Address"
        }
      ]
    },
    {
      name:     "STATUS_1710",
      desc:     "Status register of cache line 1710",
      swaccess: "rw",
      hwaccess: "hrw",
      hwext:    "true",
      hwqe:     "true", // enable `qe` latched signal of software write pulse
      hwre:     "true",
      fields: [
        {
          bits: "5+3:5", // 2 bits for status
          name: "CL_STATUS",
          desc: "Contain the current status of the corresponding cache line                [0]: valid, [1]: dirty, [2]: cmpt",
        }
      ]
    },
    { name:     "TAG_1710",
      desc:     "Tag Address stored in cache line 1710",
      swaccess: "rw",
      hwaccess: "hrw",
      hwext:    "true",
      hwqe:     "true", // enable `qe` latched signal of software write pulse
      hwre:     "true",
      fields: [
        { bits: "5-1:0",
          name: "CL_TAG",
          desc: "Tag Address"
        }
      ]
    },
    {
      name:     "STATUS_1711",
      desc:     "Status register of cache line 1711",
      swaccess: "rw",
      hwaccess: "hrw",
      hwext:    "true",
      hwqe:     "true", // enable `qe` latched signal of software write pulse
      hwre:     "true",
      fields: [
        {
          bits: "5+3:5", // 2 bits for status
          name: "CL_STATUS",
          desc: "Contain the current status of the corresponding cache line                [0]: valid, [1]: dirty, [2]: cmpt",
        }
      ]
    },
    { name:     "TAG_1711",
      desc:     "Tag Address stored in cache line 1711",
      swaccess: "rw",
      hwaccess: "hrw",
      hwext:    "true",
      hwqe:     "true", // enable `qe` latched signal of software write pulse
      hwre:     "true",
      fields: [
        { bits: "5-1:0",
          name: "CL_TAG",
          desc: "Tag Address"
        }
      ]
    },
    {
      name:     "STATUS_1712",
      desc:     "Status register of cache line 1712",
      swaccess: "rw",
      hwaccess: "hrw",
      hwext:    "true",
      hwqe:     "true", // enable `qe` latched signal of software write pulse
      hwre:     "true",
      fields: [
        {
          bits: "5+3:5", // 2 bits for status
          name: "CL_STATUS",
          desc: "Contain the current status of the corresponding cache line                [0]: valid, [1]: dirty, [2]: cmpt",
        }
      ]
    },
    { name:     "TAG_1712",
      desc:     "Tag Address stored in cache line 1712",
      swaccess: "rw",
      hwaccess: "hrw",
      hwext:    "true",
      hwqe:     "true", // enable `qe` latched signal of software write pulse
      hwre:     "true",
      fields: [
        { bits: "5-1:0",
          name: "CL_TAG",
          desc: "Tag Address"
        }
      ]
    },
    {
      name:     "STATUS_1713",
      desc:     "Status register of cache line 1713",
      swaccess: "rw",
      hwaccess: "hrw",
      hwext:    "true",
      hwqe:     "true", // enable `qe` latched signal of software write pulse
      hwre:     "true",
      fields: [
        {
          bits: "5+3:5", // 2 bits for status
          name: "CL_STATUS",
          desc: "Contain the current status of the corresponding cache line                [0]: valid, [1]: dirty, [2]: cmpt",
        }
      ]
    },
    { name:     "TAG_1713",
      desc:     "Tag Address stored in cache line 1713",
      swaccess: "rw",
      hwaccess: "hrw",
      hwext:    "true",
      hwqe:     "true", // enable `qe` latched signal of software write pulse
      hwre:     "true",
      fields: [
        { bits: "5-1:0",
          name: "CL_TAG",
          desc: "Tag Address"
        }
      ]
    },
    {
      name:     "STATUS_1714",
      desc:     "Status register of cache line 1714",
      swaccess: "rw",
      hwaccess: "hrw",
      hwext:    "true",
      hwqe:     "true", // enable `qe` latched signal of software write pulse
      hwre:     "true",
      fields: [
        {
          bits: "5+3:5", // 2 bits for status
          name: "CL_STATUS",
          desc: "Contain the current status of the corresponding cache line                [0]: valid, [1]: dirty, [2]: cmpt",
        }
      ]
    },
    { name:     "TAG_1714",
      desc:     "Tag Address stored in cache line 1714",
      swaccess: "rw",
      hwaccess: "hrw",
      hwext:    "true",
      hwqe:     "true", // enable `qe` latched signal of software write pulse
      hwre:     "true",
      fields: [
        { bits: "5-1:0",
          name: "CL_TAG",
          desc: "Tag Address"
        }
      ]
    },
    {
      name:     "STATUS_1715",
      desc:     "Status register of cache line 1715",
      swaccess: "rw",
      hwaccess: "hrw",
      hwext:    "true",
      hwqe:     "true", // enable `qe` latched signal of software write pulse
      hwre:     "true",
      fields: [
        {
          bits: "5+3:5", // 2 bits for status
          name: "CL_STATUS",
          desc: "Contain the current status of the corresponding cache line                [0]: valid, [1]: dirty, [2]: cmpt",
        }
      ]
    },
    { name:     "TAG_1715",
      desc:     "Tag Address stored in cache line 1715",
      swaccess: "rw",
      hwaccess: "hrw",
      hwext:    "true",
      hwqe:     "true", // enable `qe` latched signal of software write pulse
      hwre:     "true",
      fields: [
        { bits: "5-1:0",
          name: "CL_TAG",
          desc: "Tag Address"
        }
      ]
    },
    {
      name:     "STATUS_1716",
      desc:     "Status register of cache line 1716",
      swaccess: "rw",
      hwaccess: "hrw",
      hwext:    "true",
      hwqe:     "true", // enable `qe` latched signal of software write pulse
      hwre:     "true",
      fields: [
        {
          bits: "5+3:5", // 2 bits for status
          name: "CL_STATUS",
          desc: "Contain the current status of the corresponding cache line                [0]: valid, [1]: dirty, [2]: cmpt",
        }
      ]
    },
    { name:     "TAG_1716",
      desc:     "Tag Address stored in cache line 1716",
      swaccess: "rw",
      hwaccess: "hrw",
      hwext:    "true",
      hwqe:     "true", // enable `qe` latched signal of software write pulse
      hwre:     "true",
      fields: [
        { bits: "5-1:0",
          name: "CL_TAG",
          desc: "Tag Address"
        }
      ]
    },
    {
      name:     "STATUS_1717",
      desc:     "Status register of cache line 1717",
      swaccess: "rw",
      hwaccess: "hrw",
      hwext:    "true",
      hwqe:     "true", // enable `qe` latched signal of software write pulse
      hwre:     "true",
      fields: [
        {
          bits: "5+3:5", // 2 bits for status
          name: "CL_STATUS",
          desc: "Contain the current status of the corresponding cache line                [0]: valid, [1]: dirty, [2]: cmpt",
        }
      ]
    },
    { name:     "TAG_1717",
      desc:     "Tag Address stored in cache line 1717",
      swaccess: "rw",
      hwaccess: "hrw",
      hwext:    "true",
      hwqe:     "true", // enable `qe` latched signal of software write pulse
      hwre:     "true",
      fields: [
        { bits: "5-1:0",
          name: "CL_TAG",
          desc: "Tag Address"
        }
      ]
    },
    {
      name:     "STATUS_1718",
      desc:     "Status register of cache line 1718",
      swaccess: "rw",
      hwaccess: "hrw",
      hwext:    "true",
      hwqe:     "true", // enable `qe` latched signal of software write pulse
      hwre:     "true",
      fields: [
        {
          bits: "5+3:5", // 2 bits for status
          name: "CL_STATUS",
          desc: "Contain the current status of the corresponding cache line                [0]: valid, [1]: dirty, [2]: cmpt",
        }
      ]
    },
    { name:     "TAG_1718",
      desc:     "Tag Address stored in cache line 1718",
      swaccess: "rw",
      hwaccess: "hrw",
      hwext:    "true",
      hwqe:     "true", // enable `qe` latched signal of software write pulse
      hwre:     "true",
      fields: [
        { bits: "5-1:0",
          name: "CL_TAG",
          desc: "Tag Address"
        }
      ]
    },
    {
      name:     "STATUS_1719",
      desc:     "Status register of cache line 1719",
      swaccess: "rw",
      hwaccess: "hrw",
      hwext:    "true",
      hwqe:     "true", // enable `qe` latched signal of software write pulse
      hwre:     "true",
      fields: [
        {
          bits: "5+3:5", // 2 bits for status
          name: "CL_STATUS",
          desc: "Contain the current status of the corresponding cache line                [0]: valid, [1]: dirty, [2]: cmpt",
        }
      ]
    },
    { name:     "TAG_1719",
      desc:     "Tag Address stored in cache line 1719",
      swaccess: "rw",
      hwaccess: "hrw",
      hwext:    "true",
      hwqe:     "true", // enable `qe` latched signal of software write pulse
      hwre:     "true",
      fields: [
        { bits: "5-1:0",
          name: "CL_TAG",
          desc: "Tag Address"
        }
      ]
    },
    {
      name:     "STATUS_1720",
      desc:     "Status register of cache line 1720",
      swaccess: "rw",
      hwaccess: "hrw",
      hwext:    "true",
      hwqe:     "true", // enable `qe` latched signal of software write pulse
      hwre:     "true",
      fields: [
        {
          bits: "5+3:5", // 2 bits for status
          name: "CL_STATUS",
          desc: "Contain the current status of the corresponding cache line                [0]: valid, [1]: dirty, [2]: cmpt",
        }
      ]
    },
    { name:     "TAG_1720",
      desc:     "Tag Address stored in cache line 1720",
      swaccess: "rw",
      hwaccess: "hrw",
      hwext:    "true",
      hwqe:     "true", // enable `qe` latched signal of software write pulse
      hwre:     "true",
      fields: [
        { bits: "5-1:0",
          name: "CL_TAG",
          desc: "Tag Address"
        }
      ]
    },
    {
      name:     "STATUS_1721",
      desc:     "Status register of cache line 1721",
      swaccess: "rw",
      hwaccess: "hrw",
      hwext:    "true",
      hwqe:     "true", // enable `qe` latched signal of software write pulse
      hwre:     "true",
      fields: [
        {
          bits: "5+3:5", // 2 bits for status
          name: "CL_STATUS",
          desc: "Contain the current status of the corresponding cache line                [0]: valid, [1]: dirty, [2]: cmpt",
        }
      ]
    },
    { name:     "TAG_1721",
      desc:     "Tag Address stored in cache line 1721",
      swaccess: "rw",
      hwaccess: "hrw",
      hwext:    "true",
      hwqe:     "true", // enable `qe` latched signal of software write pulse
      hwre:     "true",
      fields: [
        { bits: "5-1:0",
          name: "CL_TAG",
          desc: "Tag Address"
        }
      ]
    },
    {
      name:     "STATUS_1722",
      desc:     "Status register of cache line 1722",
      swaccess: "rw",
      hwaccess: "hrw",
      hwext:    "true",
      hwqe:     "true", // enable `qe` latched signal of software write pulse
      hwre:     "true",
      fields: [
        {
          bits: "5+3:5", // 2 bits for status
          name: "CL_STATUS",
          desc: "Contain the current status of the corresponding cache line                [0]: valid, [1]: dirty, [2]: cmpt",
        }
      ]
    },
    { name:     "TAG_1722",
      desc:     "Tag Address stored in cache line 1722",
      swaccess: "rw",
      hwaccess: "hrw",
      hwext:    "true",
      hwqe:     "true", // enable `qe` latched signal of software write pulse
      hwre:     "true",
      fields: [
        { bits: "5-1:0",
          name: "CL_TAG",
          desc: "Tag Address"
        }
      ]
    },
    {
      name:     "STATUS_1723",
      desc:     "Status register of cache line 1723",
      swaccess: "rw",
      hwaccess: "hrw",
      hwext:    "true",
      hwqe:     "true", // enable `qe` latched signal of software write pulse
      hwre:     "true",
      fields: [
        {
          bits: "5+3:5", // 2 bits for status
          name: "CL_STATUS",
          desc: "Contain the current status of the corresponding cache line                [0]: valid, [1]: dirty, [2]: cmpt",
        }
      ]
    },
    { name:     "TAG_1723",
      desc:     "Tag Address stored in cache line 1723",
      swaccess: "rw",
      hwaccess: "hrw",
      hwext:    "true",
      hwqe:     "true", // enable `qe` latched signal of software write pulse
      hwre:     "true",
      fields: [
        { bits: "5-1:0",
          name: "CL_TAG",
          desc: "Tag Address"
        }
      ]
    },
    {
      name:     "STATUS_1724",
      desc:     "Status register of cache line 1724",
      swaccess: "rw",
      hwaccess: "hrw",
      hwext:    "true",
      hwqe:     "true", // enable `qe` latched signal of software write pulse
      hwre:     "true",
      fields: [
        {
          bits: "5+3:5", // 2 bits for status
          name: "CL_STATUS",
          desc: "Contain the current status of the corresponding cache line                [0]: valid, [1]: dirty, [2]: cmpt",
        }
      ]
    },
    { name:     "TAG_1724",
      desc:     "Tag Address stored in cache line 1724",
      swaccess: "rw",
      hwaccess: "hrw",
      hwext:    "true",
      hwqe:     "true", // enable `qe` latched signal of software write pulse
      hwre:     "true",
      fields: [
        { bits: "5-1:0",
          name: "CL_TAG",
          desc: "Tag Address"
        }
      ]
    },
    {
      name:     "STATUS_1725",
      desc:     "Status register of cache line 1725",
      swaccess: "rw",
      hwaccess: "hrw",
      hwext:    "true",
      hwqe:     "true", // enable `qe` latched signal of software write pulse
      hwre:     "true",
      fields: [
        {
          bits: "5+3:5", // 2 bits for status
          name: "CL_STATUS",
          desc: "Contain the current status of the corresponding cache line                [0]: valid, [1]: dirty, [2]: cmpt",
        }
      ]
    },
    { name:     "TAG_1725",
      desc:     "Tag Address stored in cache line 1725",
      swaccess: "rw",
      hwaccess: "hrw",
      hwext:    "true",
      hwqe:     "true", // enable `qe` latched signal of software write pulse
      hwre:     "true",
      fields: [
        { bits: "5-1:0",
          name: "CL_TAG",
          desc: "Tag Address"
        }
      ]
    },
    {
      name:     "STATUS_1726",
      desc:     "Status register of cache line 1726",
      swaccess: "rw",
      hwaccess: "hrw",
      hwext:    "true",
      hwqe:     "true", // enable `qe` latched signal of software write pulse
      hwre:     "true",
      fields: [
        {
          bits: "5+3:5", // 2 bits for status
          name: "CL_STATUS",
          desc: "Contain the current status of the corresponding cache line                [0]: valid, [1]: dirty, [2]: cmpt",
        }
      ]
    },
    { name:     "TAG_1726",
      desc:     "Tag Address stored in cache line 1726",
      swaccess: "rw",
      hwaccess: "hrw",
      hwext:    "true",
      hwqe:     "true", // enable `qe` latched signal of software write pulse
      hwre:     "true",
      fields: [
        { bits: "5-1:0",
          name: "CL_TAG",
          desc: "Tag Address"
        }
      ]
    },
    {
      name:     "STATUS_1727",
      desc:     "Status register of cache line 1727",
      swaccess: "rw",
      hwaccess: "hrw",
      hwext:    "true",
      hwqe:     "true", // enable `qe` latched signal of software write pulse
      hwre:     "true",
      fields: [
        {
          bits: "5+3:5", // 2 bits for status
          name: "CL_STATUS",
          desc: "Contain the current status of the corresponding cache line                [0]: valid, [1]: dirty, [2]: cmpt",
        }
      ]
    },
    { name:     "TAG_1727",
      desc:     "Tag Address stored in cache line 1727",
      swaccess: "rw",
      hwaccess: "hrw",
      hwext:    "true",
      hwqe:     "true", // enable `qe` latched signal of software write pulse
      hwre:     "true",
      fields: [
        { bits: "5-1:0",
          name: "CL_TAG",
          desc: "Tag Address"
        }
      ]
    },
    {
      name:     "STATUS_1728",
      desc:     "Status register of cache line 1728",
      swaccess: "rw",
      hwaccess: "hrw",
      hwext:    "true",
      hwqe:     "true", // enable `qe` latched signal of software write pulse
      hwre:     "true",
      fields: [
        {
          bits: "5+3:5", // 2 bits for status
          name: "CL_STATUS",
          desc: "Contain the current status of the corresponding cache line                [0]: valid, [1]: dirty, [2]: cmpt",
        }
      ]
    },
    { name:     "TAG_1728",
      desc:     "Tag Address stored in cache line 1728",
      swaccess: "rw",
      hwaccess: "hrw",
      hwext:    "true",
      hwqe:     "true", // enable `qe` latched signal of software write pulse
      hwre:     "true",
      fields: [
        { bits: "5-1:0",
          name: "CL_TAG",
          desc: "Tag Address"
        }
      ]
    },
    {
      name:     "STATUS_1729",
      desc:     "Status register of cache line 1729",
      swaccess: "rw",
      hwaccess: "hrw",
      hwext:    "true",
      hwqe:     "true", // enable `qe` latched signal of software write pulse
      hwre:     "true",
      fields: [
        {
          bits: "5+3:5", // 2 bits for status
          name: "CL_STATUS",
          desc: "Contain the current status of the corresponding cache line                [0]: valid, [1]: dirty, [2]: cmpt",
        }
      ]
    },
    { name:     "TAG_1729",
      desc:     "Tag Address stored in cache line 1729",
      swaccess: "rw",
      hwaccess: "hrw",
      hwext:    "true",
      hwqe:     "true", // enable `qe` latched signal of software write pulse
      hwre:     "true",
      fields: [
        { bits: "5-1:0",
          name: "CL_TAG",
          desc: "Tag Address"
        }
      ]
    },
    {
      name:     "STATUS_1730",
      desc:     "Status register of cache line 1730",
      swaccess: "rw",
      hwaccess: "hrw",
      hwext:    "true",
      hwqe:     "true", // enable `qe` latched signal of software write pulse
      hwre:     "true",
      fields: [
        {
          bits: "5+3:5", // 2 bits for status
          name: "CL_STATUS",
          desc: "Contain the current status of the corresponding cache line                [0]: valid, [1]: dirty, [2]: cmpt",
        }
      ]
    },
    { name:     "TAG_1730",
      desc:     "Tag Address stored in cache line 1730",
      swaccess: "rw",
      hwaccess: "hrw",
      hwext:    "true",
      hwqe:     "true", // enable `qe` latched signal of software write pulse
      hwre:     "true",
      fields: [
        { bits: "5-1:0",
          name: "CL_TAG",
          desc: "Tag Address"
        }
      ]
    },
    {
      name:     "STATUS_1731",
      desc:     "Status register of cache line 1731",
      swaccess: "rw",
      hwaccess: "hrw",
      hwext:    "true",
      hwqe:     "true", // enable `qe` latched signal of software write pulse
      hwre:     "true",
      fields: [
        {
          bits: "5+3:5", // 2 bits for status
          name: "CL_STATUS",
          desc: "Contain the current status of the corresponding cache line                [0]: valid, [1]: dirty, [2]: cmpt",
        }
      ]
    },
    { name:     "TAG_1731",
      desc:     "Tag Address stored in cache line 1731",
      swaccess: "rw",
      hwaccess: "hrw",
      hwext:    "true",
      hwqe:     "true", // enable `qe` latched signal of software write pulse
      hwre:     "true",
      fields: [
        { bits: "5-1:0",
          name: "CL_TAG",
          desc: "Tag Address"
        }
      ]
    },
    {
      name:     "STATUS_1732",
      desc:     "Status register of cache line 1732",
      swaccess: "rw",
      hwaccess: "hrw",
      hwext:    "true",
      hwqe:     "true", // enable `qe` latched signal of software write pulse
      hwre:     "true",
      fields: [
        {
          bits: "5+3:5", // 2 bits for status
          name: "CL_STATUS",
          desc: "Contain the current status of the corresponding cache line                [0]: valid, [1]: dirty, [2]: cmpt",
        }
      ]
    },
    { name:     "TAG_1732",
      desc:     "Tag Address stored in cache line 1732",
      swaccess: "rw",
      hwaccess: "hrw",
      hwext:    "true",
      hwqe:     "true", // enable `qe` latched signal of software write pulse
      hwre:     "true",
      fields: [
        { bits: "5-1:0",
          name: "CL_TAG",
          desc: "Tag Address"
        }
      ]
    },
    {
      name:     "STATUS_1733",
      desc:     "Status register of cache line 1733",
      swaccess: "rw",
      hwaccess: "hrw",
      hwext:    "true",
      hwqe:     "true", // enable `qe` latched signal of software write pulse
      hwre:     "true",
      fields: [
        {
          bits: "5+3:5", // 2 bits for status
          name: "CL_STATUS",
          desc: "Contain the current status of the corresponding cache line                [0]: valid, [1]: dirty, [2]: cmpt",
        }
      ]
    },
    { name:     "TAG_1733",
      desc:     "Tag Address stored in cache line 1733",
      swaccess: "rw",
      hwaccess: "hrw",
      hwext:    "true",
      hwqe:     "true", // enable `qe` latched signal of software write pulse
      hwre:     "true",
      fields: [
        { bits: "5-1:0",
          name: "CL_TAG",
          desc: "Tag Address"
        }
      ]
    },
    {
      name:     "STATUS_1734",
      desc:     "Status register of cache line 1734",
      swaccess: "rw",
      hwaccess: "hrw",
      hwext:    "true",
      hwqe:     "true", // enable `qe` latched signal of software write pulse
      hwre:     "true",
      fields: [
        {
          bits: "5+3:5", // 2 bits for status
          name: "CL_STATUS",
          desc: "Contain the current status of the corresponding cache line                [0]: valid, [1]: dirty, [2]: cmpt",
        }
      ]
    },
    { name:     "TAG_1734",
      desc:     "Tag Address stored in cache line 1734",
      swaccess: "rw",
      hwaccess: "hrw",
      hwext:    "true",
      hwqe:     "true", // enable `qe` latched signal of software write pulse
      hwre:     "true",
      fields: [
        { bits: "5-1:0",
          name: "CL_TAG",
          desc: "Tag Address"
        }
      ]
    },
    {
      name:     "STATUS_1735",
      desc:     "Status register of cache line 1735",
      swaccess: "rw",
      hwaccess: "hrw",
      hwext:    "true",
      hwqe:     "true", // enable `qe` latched signal of software write pulse
      hwre:     "true",
      fields: [
        {
          bits: "5+3:5", // 2 bits for status
          name: "CL_STATUS",
          desc: "Contain the current status of the corresponding cache line                [0]: valid, [1]: dirty, [2]: cmpt",
        }
      ]
    },
    { name:     "TAG_1735",
      desc:     "Tag Address stored in cache line 1735",
      swaccess: "rw",
      hwaccess: "hrw",
      hwext:    "true",
      hwqe:     "true", // enable `qe` latched signal of software write pulse
      hwre:     "true",
      fields: [
        { bits: "5-1:0",
          name: "CL_TAG",
          desc: "Tag Address"
        }
      ]
    },
    {
      name:     "STATUS_1736",
      desc:     "Status register of cache line 1736",
      swaccess: "rw",
      hwaccess: "hrw",
      hwext:    "true",
      hwqe:     "true", // enable `qe` latched signal of software write pulse
      hwre:     "true",
      fields: [
        {
          bits: "5+3:5", // 2 bits for status
          name: "CL_STATUS",
          desc: "Contain the current status of the corresponding cache line                [0]: valid, [1]: dirty, [2]: cmpt",
        }
      ]
    },
    { name:     "TAG_1736",
      desc:     "Tag Address stored in cache line 1736",
      swaccess: "rw",
      hwaccess: "hrw",
      hwext:    "true",
      hwqe:     "true", // enable `qe` latched signal of software write pulse
      hwre:     "true",
      fields: [
        { bits: "5-1:0",
          name: "CL_TAG",
          desc: "Tag Address"
        }
      ]
    },
    {
      name:     "STATUS_1737",
      desc:     "Status register of cache line 1737",
      swaccess: "rw",
      hwaccess: "hrw",
      hwext:    "true",
      hwqe:     "true", // enable `qe` latched signal of software write pulse
      hwre:     "true",
      fields: [
        {
          bits: "5+3:5", // 2 bits for status
          name: "CL_STATUS",
          desc: "Contain the current status of the corresponding cache line                [0]: valid, [1]: dirty, [2]: cmpt",
        }
      ]
    },
    { name:     "TAG_1737",
      desc:     "Tag Address stored in cache line 1737",
      swaccess: "rw",
      hwaccess: "hrw",
      hwext:    "true",
      hwqe:     "true", // enable `qe` latched signal of software write pulse
      hwre:     "true",
      fields: [
        { bits: "5-1:0",
          name: "CL_TAG",
          desc: "Tag Address"
        }
      ]
    },
    {
      name:     "STATUS_1738",
      desc:     "Status register of cache line 1738",
      swaccess: "rw",
      hwaccess: "hrw",
      hwext:    "true",
      hwqe:     "true", // enable `qe` latched signal of software write pulse
      hwre:     "true",
      fields: [
        {
          bits: "5+3:5", // 2 bits for status
          name: "CL_STATUS",
          desc: "Contain the current status of the corresponding cache line                [0]: valid, [1]: dirty, [2]: cmpt",
        }
      ]
    },
    { name:     "TAG_1738",
      desc:     "Tag Address stored in cache line 1738",
      swaccess: "rw",
      hwaccess: "hrw",
      hwext:    "true",
      hwqe:     "true", // enable `qe` latched signal of software write pulse
      hwre:     "true",
      fields: [
        { bits: "5-1:0",
          name: "CL_TAG",
          desc: "Tag Address"
        }
      ]
    },
    {
      name:     "STATUS_1739",
      desc:     "Status register of cache line 1739",
      swaccess: "rw",
      hwaccess: "hrw",
      hwext:    "true",
      hwqe:     "true", // enable `qe` latched signal of software write pulse
      hwre:     "true",
      fields: [
        {
          bits: "5+3:5", // 2 bits for status
          name: "CL_STATUS",
          desc: "Contain the current status of the corresponding cache line                [0]: valid, [1]: dirty, [2]: cmpt",
        }
      ]
    },
    { name:     "TAG_1739",
      desc:     "Tag Address stored in cache line 1739",
      swaccess: "rw",
      hwaccess: "hrw",
      hwext:    "true",
      hwqe:     "true", // enable `qe` latched signal of software write pulse
      hwre:     "true",
      fields: [
        { bits: "5-1:0",
          name: "CL_TAG",
          desc: "Tag Address"
        }
      ]
    },
    {
      name:     "STATUS_1740",
      desc:     "Status register of cache line 1740",
      swaccess: "rw",
      hwaccess: "hrw",
      hwext:    "true",
      hwqe:     "true", // enable `qe` latched signal of software write pulse
      hwre:     "true",
      fields: [
        {
          bits: "5+3:5", // 2 bits for status
          name: "CL_STATUS",
          desc: "Contain the current status of the corresponding cache line                [0]: valid, [1]: dirty, [2]: cmpt",
        }
      ]
    },
    { name:     "TAG_1740",
      desc:     "Tag Address stored in cache line 1740",
      swaccess: "rw",
      hwaccess: "hrw",
      hwext:    "true",
      hwqe:     "true", // enable `qe` latched signal of software write pulse
      hwre:     "true",
      fields: [
        { bits: "5-1:0",
          name: "CL_TAG",
          desc: "Tag Address"
        }
      ]
    },
    {
      name:     "STATUS_1741",
      desc:     "Status register of cache line 1741",
      swaccess: "rw",
      hwaccess: "hrw",
      hwext:    "true",
      hwqe:     "true", // enable `qe` latched signal of software write pulse
      hwre:     "true",
      fields: [
        {
          bits: "5+3:5", // 2 bits for status
          name: "CL_STATUS",
          desc: "Contain the current status of the corresponding cache line                [0]: valid, [1]: dirty, [2]: cmpt",
        }
      ]
    },
    { name:     "TAG_1741",
      desc:     "Tag Address stored in cache line 1741",
      swaccess: "rw",
      hwaccess: "hrw",
      hwext:    "true",
      hwqe:     "true", // enable `qe` latched signal of software write pulse
      hwre:     "true",
      fields: [
        { bits: "5-1:0",
          name: "CL_TAG",
          desc: "Tag Address"
        }
      ]
    },
    {
      name:     "STATUS_1742",
      desc:     "Status register of cache line 1742",
      swaccess: "rw",
      hwaccess: "hrw",
      hwext:    "true",
      hwqe:     "true", // enable `qe` latched signal of software write pulse
      hwre:     "true",
      fields: [
        {
          bits: "5+3:5", // 2 bits for status
          name: "CL_STATUS",
          desc: "Contain the current status of the corresponding cache line                [0]: valid, [1]: dirty, [2]: cmpt",
        }
      ]
    },
    { name:     "TAG_1742",
      desc:     "Tag Address stored in cache line 1742",
      swaccess: "rw",
      hwaccess: "hrw",
      hwext:    "true",
      hwqe:     "true", // enable `qe` latched signal of software write pulse
      hwre:     "true",
      fields: [
        { bits: "5-1:0",
          name: "CL_TAG",
          desc: "Tag Address"
        }
      ]
    },
    {
      name:     "STATUS_1743",
      desc:     "Status register of cache line 1743",
      swaccess: "rw",
      hwaccess: "hrw",
      hwext:    "true",
      hwqe:     "true", // enable `qe` latched signal of software write pulse
      hwre:     "true",
      fields: [
        {
          bits: "5+3:5", // 2 bits for status
          name: "CL_STATUS",
          desc: "Contain the current status of the corresponding cache line                [0]: valid, [1]: dirty, [2]: cmpt",
        }
      ]
    },
    { name:     "TAG_1743",
      desc:     "Tag Address stored in cache line 1743",
      swaccess: "rw",
      hwaccess: "hrw",
      hwext:    "true",
      hwqe:     "true", // enable `qe` latched signal of software write pulse
      hwre:     "true",
      fields: [
        { bits: "5-1:0",
          name: "CL_TAG",
          desc: "Tag Address"
        }
      ]
    },
    {
      name:     "STATUS_1744",
      desc:     "Status register of cache line 1744",
      swaccess: "rw",
      hwaccess: "hrw",
      hwext:    "true",
      hwqe:     "true", // enable `qe` latched signal of software write pulse
      hwre:     "true",
      fields: [
        {
          bits: "5+3:5", // 2 bits for status
          name: "CL_STATUS",
          desc: "Contain the current status of the corresponding cache line                [0]: valid, [1]: dirty, [2]: cmpt",
        }
      ]
    },
    { name:     "TAG_1744",
      desc:     "Tag Address stored in cache line 1744",
      swaccess: "rw",
      hwaccess: "hrw",
      hwext:    "true",
      hwqe:     "true", // enable `qe` latched signal of software write pulse
      hwre:     "true",
      fields: [
        { bits: "5-1:0",
          name: "CL_TAG",
          desc: "Tag Address"
        }
      ]
    },
    {
      name:     "STATUS_1745",
      desc:     "Status register of cache line 1745",
      swaccess: "rw",
      hwaccess: "hrw",
      hwext:    "true",
      hwqe:     "true", // enable `qe` latched signal of software write pulse
      hwre:     "true",
      fields: [
        {
          bits: "5+3:5", // 2 bits for status
          name: "CL_STATUS",
          desc: "Contain the current status of the corresponding cache line                [0]: valid, [1]: dirty, [2]: cmpt",
        }
      ]
    },
    { name:     "TAG_1745",
      desc:     "Tag Address stored in cache line 1745",
      swaccess: "rw",
      hwaccess: "hrw",
      hwext:    "true",
      hwqe:     "true", // enable `qe` latched signal of software write pulse
      hwre:     "true",
      fields: [
        { bits: "5-1:0",
          name: "CL_TAG",
          desc: "Tag Address"
        }
      ]
    },
    {
      name:     "STATUS_1746",
      desc:     "Status register of cache line 1746",
      swaccess: "rw",
      hwaccess: "hrw",
      hwext:    "true",
      hwqe:     "true", // enable `qe` latched signal of software write pulse
      hwre:     "true",
      fields: [
        {
          bits: "5+3:5", // 2 bits for status
          name: "CL_STATUS",
          desc: "Contain the current status of the corresponding cache line                [0]: valid, [1]: dirty, [2]: cmpt",
        }
      ]
    },
    { name:     "TAG_1746",
      desc:     "Tag Address stored in cache line 1746",
      swaccess: "rw",
      hwaccess: "hrw",
      hwext:    "true",
      hwqe:     "true", // enable `qe` latched signal of software write pulse
      hwre:     "true",
      fields: [
        { bits: "5-1:0",
          name: "CL_TAG",
          desc: "Tag Address"
        }
      ]
    },
    {
      name:     "STATUS_1747",
      desc:     "Status register of cache line 1747",
      swaccess: "rw",
      hwaccess: "hrw",
      hwext:    "true",
      hwqe:     "true", // enable `qe` latched signal of software write pulse
      hwre:     "true",
      fields: [
        {
          bits: "5+3:5", // 2 bits for status
          name: "CL_STATUS",
          desc: "Contain the current status of the corresponding cache line                [0]: valid, [1]: dirty, [2]: cmpt",
        }
      ]
    },
    { name:     "TAG_1747",
      desc:     "Tag Address stored in cache line 1747",
      swaccess: "rw",
      hwaccess: "hrw",
      hwext:    "true",
      hwqe:     "true", // enable `qe` latched signal of software write pulse
      hwre:     "true",
      fields: [
        { bits: "5-1:0",
          name: "CL_TAG",
          desc: "Tag Address"
        }
      ]
    },
    {
      name:     "STATUS_1748",
      desc:     "Status register of cache line 1748",
      swaccess: "rw",
      hwaccess: "hrw",
      hwext:    "true",
      hwqe:     "true", // enable `qe` latched signal of software write pulse
      hwre:     "true",
      fields: [
        {
          bits: "5+3:5", // 2 bits for status
          name: "CL_STATUS",
          desc: "Contain the current status of the corresponding cache line                [0]: valid, [1]: dirty, [2]: cmpt",
        }
      ]
    },
    { name:     "TAG_1748",
      desc:     "Tag Address stored in cache line 1748",
      swaccess: "rw",
      hwaccess: "hrw",
      hwext:    "true",
      hwqe:     "true", // enable `qe` latched signal of software write pulse
      hwre:     "true",
      fields: [
        { bits: "5-1:0",
          name: "CL_TAG",
          desc: "Tag Address"
        }
      ]
    },
    {
      name:     "STATUS_1749",
      desc:     "Status register of cache line 1749",
      swaccess: "rw",
      hwaccess: "hrw",
      hwext:    "true",
      hwqe:     "true", // enable `qe` latched signal of software write pulse
      hwre:     "true",
      fields: [
        {
          bits: "5+3:5", // 2 bits for status
          name: "CL_STATUS",
          desc: "Contain the current status of the corresponding cache line                [0]: valid, [1]: dirty, [2]: cmpt",
        }
      ]
    },
    { name:     "TAG_1749",
      desc:     "Tag Address stored in cache line 1749",
      swaccess: "rw",
      hwaccess: "hrw",
      hwext:    "true",
      hwqe:     "true", // enable `qe` latched signal of software write pulse
      hwre:     "true",
      fields: [
        { bits: "5-1:0",
          name: "CL_TAG",
          desc: "Tag Address"
        }
      ]
    },
    {
      name:     "STATUS_1750",
      desc:     "Status register of cache line 1750",
      swaccess: "rw",
      hwaccess: "hrw",
      hwext:    "true",
      hwqe:     "true", // enable `qe` latched signal of software write pulse
      hwre:     "true",
      fields: [
        {
          bits: "5+3:5", // 2 bits for status
          name: "CL_STATUS",
          desc: "Contain the current status of the corresponding cache line                [0]: valid, [1]: dirty, [2]: cmpt",
        }
      ]
    },
    { name:     "TAG_1750",
      desc:     "Tag Address stored in cache line 1750",
      swaccess: "rw",
      hwaccess: "hrw",
      hwext:    "true",
      hwqe:     "true", // enable `qe` latched signal of software write pulse
      hwre:     "true",
      fields: [
        { bits: "5-1:0",
          name: "CL_TAG",
          desc: "Tag Address"
        }
      ]
    },
    {
      name:     "STATUS_1751",
      desc:     "Status register of cache line 1751",
      swaccess: "rw",
      hwaccess: "hrw",
      hwext:    "true",
      hwqe:     "true", // enable `qe` latched signal of software write pulse
      hwre:     "true",
      fields: [
        {
          bits: "5+3:5", // 2 bits for status
          name: "CL_STATUS",
          desc: "Contain the current status of the corresponding cache line                [0]: valid, [1]: dirty, [2]: cmpt",
        }
      ]
    },
    { name:     "TAG_1751",
      desc:     "Tag Address stored in cache line 1751",
      swaccess: "rw",
      hwaccess: "hrw",
      hwext:    "true",
      hwqe:     "true", // enable `qe` latched signal of software write pulse
      hwre:     "true",
      fields: [
        { bits: "5-1:0",
          name: "CL_TAG",
          desc: "Tag Address"
        }
      ]
    },
    {
      name:     "STATUS_1752",
      desc:     "Status register of cache line 1752",
      swaccess: "rw",
      hwaccess: "hrw",
      hwext:    "true",
      hwqe:     "true", // enable `qe` latched signal of software write pulse
      hwre:     "true",
      fields: [
        {
          bits: "5+3:5", // 2 bits for status
          name: "CL_STATUS",
          desc: "Contain the current status of the corresponding cache line                [0]: valid, [1]: dirty, [2]: cmpt",
        }
      ]
    },
    { name:     "TAG_1752",
      desc:     "Tag Address stored in cache line 1752",
      swaccess: "rw",
      hwaccess: "hrw",
      hwext:    "true",
      hwqe:     "true", // enable `qe` latched signal of software write pulse
      hwre:     "true",
      fields: [
        { bits: "5-1:0",
          name: "CL_TAG",
          desc: "Tag Address"
        }
      ]
    },
    {
      name:     "STATUS_1753",
      desc:     "Status register of cache line 1753",
      swaccess: "rw",
      hwaccess: "hrw",
      hwext:    "true",
      hwqe:     "true", // enable `qe` latched signal of software write pulse
      hwre:     "true",
      fields: [
        {
          bits: "5+3:5", // 2 bits for status
          name: "CL_STATUS",
          desc: "Contain the current status of the corresponding cache line                [0]: valid, [1]: dirty, [2]: cmpt",
        }
      ]
    },
    { name:     "TAG_1753",
      desc:     "Tag Address stored in cache line 1753",
      swaccess: "rw",
      hwaccess: "hrw",
      hwext:    "true",
      hwqe:     "true", // enable `qe` latched signal of software write pulse
      hwre:     "true",
      fields: [
        { bits: "5-1:0",
          name: "CL_TAG",
          desc: "Tag Address"
        }
      ]
    },
    {
      name:     "STATUS_1754",
      desc:     "Status register of cache line 1754",
      swaccess: "rw",
      hwaccess: "hrw",
      hwext:    "true",
      hwqe:     "true", // enable `qe` latched signal of software write pulse
      hwre:     "true",
      fields: [
        {
          bits: "5+3:5", // 2 bits for status
          name: "CL_STATUS",
          desc: "Contain the current status of the corresponding cache line                [0]: valid, [1]: dirty, [2]: cmpt",
        }
      ]
    },
    { name:     "TAG_1754",
      desc:     "Tag Address stored in cache line 1754",
      swaccess: "rw",
      hwaccess: "hrw",
      hwext:    "true",
      hwqe:     "true", // enable `qe` latched signal of software write pulse
      hwre:     "true",
      fields: [
        { bits: "5-1:0",
          name: "CL_TAG",
          desc: "Tag Address"
        }
      ]
    },
    {
      name:     "STATUS_1755",
      desc:     "Status register of cache line 1755",
      swaccess: "rw",
      hwaccess: "hrw",
      hwext:    "true",
      hwqe:     "true", // enable `qe` latched signal of software write pulse
      hwre:     "true",
      fields: [
        {
          bits: "5+3:5", // 2 bits for status
          name: "CL_STATUS",
          desc: "Contain the current status of the corresponding cache line                [0]: valid, [1]: dirty, [2]: cmpt",
        }
      ]
    },
    { name:     "TAG_1755",
      desc:     "Tag Address stored in cache line 1755",
      swaccess: "rw",
      hwaccess: "hrw",
      hwext:    "true",
      hwqe:     "true", // enable `qe` latched signal of software write pulse
      hwre:     "true",
      fields: [
        { bits: "5-1:0",
          name: "CL_TAG",
          desc: "Tag Address"
        }
      ]
    },
    {
      name:     "STATUS_1756",
      desc:     "Status register of cache line 1756",
      swaccess: "rw",
      hwaccess: "hrw",
      hwext:    "true",
      hwqe:     "true", // enable `qe` latched signal of software write pulse
      hwre:     "true",
      fields: [
        {
          bits: "5+3:5", // 2 bits for status
          name: "CL_STATUS",
          desc: "Contain the current status of the corresponding cache line                [0]: valid, [1]: dirty, [2]: cmpt",
        }
      ]
    },
    { name:     "TAG_1756",
      desc:     "Tag Address stored in cache line 1756",
      swaccess: "rw",
      hwaccess: "hrw",
      hwext:    "true",
      hwqe:     "true", // enable `qe` latched signal of software write pulse
      hwre:     "true",
      fields: [
        { bits: "5-1:0",
          name: "CL_TAG",
          desc: "Tag Address"
        }
      ]
    },
    {
      name:     "STATUS_1757",
      desc:     "Status register of cache line 1757",
      swaccess: "rw",
      hwaccess: "hrw",
      hwext:    "true",
      hwqe:     "true", // enable `qe` latched signal of software write pulse
      hwre:     "true",
      fields: [
        {
          bits: "5+3:5", // 2 bits for status
          name: "CL_STATUS",
          desc: "Contain the current status of the corresponding cache line                [0]: valid, [1]: dirty, [2]: cmpt",
        }
      ]
    },
    { name:     "TAG_1757",
      desc:     "Tag Address stored in cache line 1757",
      swaccess: "rw",
      hwaccess: "hrw",
      hwext:    "true",
      hwqe:     "true", // enable `qe` latched signal of software write pulse
      hwre:     "true",
      fields: [
        { bits: "5-1:0",
          name: "CL_TAG",
          desc: "Tag Address"
        }
      ]
    },
    {
      name:     "STATUS_1758",
      desc:     "Status register of cache line 1758",
      swaccess: "rw",
      hwaccess: "hrw",
      hwext:    "true",
      hwqe:     "true", // enable `qe` latched signal of software write pulse
      hwre:     "true",
      fields: [
        {
          bits: "5+3:5", // 2 bits for status
          name: "CL_STATUS",
          desc: "Contain the current status of the corresponding cache line                [0]: valid, [1]: dirty, [2]: cmpt",
        }
      ]
    },
    { name:     "TAG_1758",
      desc:     "Tag Address stored in cache line 1758",
      swaccess: "rw",
      hwaccess: "hrw",
      hwext:    "true",
      hwqe:     "true", // enable `qe` latched signal of software write pulse
      hwre:     "true",
      fields: [
        { bits: "5-1:0",
          name: "CL_TAG",
          desc: "Tag Address"
        }
      ]
    },
    {
      name:     "STATUS_1759",
      desc:     "Status register of cache line 1759",
      swaccess: "rw",
      hwaccess: "hrw",
      hwext:    "true",
      hwqe:     "true", // enable `qe` latched signal of software write pulse
      hwre:     "true",
      fields: [
        {
          bits: "5+3:5", // 2 bits for status
          name: "CL_STATUS",
          desc: "Contain the current status of the corresponding cache line                [0]: valid, [1]: dirty, [2]: cmpt",
        }
      ]
    },
    { name:     "TAG_1759",
      desc:     "Tag Address stored in cache line 1759",
      swaccess: "rw",
      hwaccess: "hrw",
      hwext:    "true",
      hwqe:     "true", // enable `qe` latched signal of software write pulse
      hwre:     "true",
      fields: [
        { bits: "5-1:0",
          name: "CL_TAG",
          desc: "Tag Address"
        }
      ]
    },
    {
      name:     "STATUS_1760",
      desc:     "Status register of cache line 1760",
      swaccess: "rw",
      hwaccess: "hrw",
      hwext:    "true",
      hwqe:     "true", // enable `qe` latched signal of software write pulse
      hwre:     "true",
      fields: [
        {
          bits: "5+3:5", // 2 bits for status
          name: "CL_STATUS",
          desc: "Contain the current status of the corresponding cache line                [0]: valid, [1]: dirty, [2]: cmpt",
        }
      ]
    },
    { name:     "TAG_1760",
      desc:     "Tag Address stored in cache line 1760",
      swaccess: "rw",
      hwaccess: "hrw",
      hwext:    "true",
      hwqe:     "true", // enable `qe` latched signal of software write pulse
      hwre:     "true",
      fields: [
        { bits: "5-1:0",
          name: "CL_TAG",
          desc: "Tag Address"
        }
      ]
    },
    {
      name:     "STATUS_1761",
      desc:     "Status register of cache line 1761",
      swaccess: "rw",
      hwaccess: "hrw",
      hwext:    "true",
      hwqe:     "true", // enable `qe` latched signal of software write pulse
      hwre:     "true",
      fields: [
        {
          bits: "5+3:5", // 2 bits for status
          name: "CL_STATUS",
          desc: "Contain the current status of the corresponding cache line                [0]: valid, [1]: dirty, [2]: cmpt",
        }
      ]
    },
    { name:     "TAG_1761",
      desc:     "Tag Address stored in cache line 1761",
      swaccess: "rw",
      hwaccess: "hrw",
      hwext:    "true",
      hwqe:     "true", // enable `qe` latched signal of software write pulse
      hwre:     "true",
      fields: [
        { bits: "5-1:0",
          name: "CL_TAG",
          desc: "Tag Address"
        }
      ]
    },
    {
      name:     "STATUS_1762",
      desc:     "Status register of cache line 1762",
      swaccess: "rw",
      hwaccess: "hrw",
      hwext:    "true",
      hwqe:     "true", // enable `qe` latched signal of software write pulse
      hwre:     "true",
      fields: [
        {
          bits: "5+3:5", // 2 bits for status
          name: "CL_STATUS",
          desc: "Contain the current status of the corresponding cache line                [0]: valid, [1]: dirty, [2]: cmpt",
        }
      ]
    },
    { name:     "TAG_1762",
      desc:     "Tag Address stored in cache line 1762",
      swaccess: "rw",
      hwaccess: "hrw",
      hwext:    "true",
      hwqe:     "true", // enable `qe` latched signal of software write pulse
      hwre:     "true",
      fields: [
        { bits: "5-1:0",
          name: "CL_TAG",
          desc: "Tag Address"
        }
      ]
    },
    {
      name:     "STATUS_1763",
      desc:     "Status register of cache line 1763",
      swaccess: "rw",
      hwaccess: "hrw",
      hwext:    "true",
      hwqe:     "true", // enable `qe` latched signal of software write pulse
      hwre:     "true",
      fields: [
        {
          bits: "5+3:5", // 2 bits for status
          name: "CL_STATUS",
          desc: "Contain the current status of the corresponding cache line                [0]: valid, [1]: dirty, [2]: cmpt",
        }
      ]
    },
    { name:     "TAG_1763",
      desc:     "Tag Address stored in cache line 1763",
      swaccess: "rw",
      hwaccess: "hrw",
      hwext:    "true",
      hwqe:     "true", // enable `qe` latched signal of software write pulse
      hwre:     "true",
      fields: [
        { bits: "5-1:0",
          name: "CL_TAG",
          desc: "Tag Address"
        }
      ]
    },
    {
      name:     "STATUS_1764",
      desc:     "Status register of cache line 1764",
      swaccess: "rw",
      hwaccess: "hrw",
      hwext:    "true",
      hwqe:     "true", // enable `qe` latched signal of software write pulse
      hwre:     "true",
      fields: [
        {
          bits: "5+3:5", // 2 bits for status
          name: "CL_STATUS",
          desc: "Contain the current status of the corresponding cache line                [0]: valid, [1]: dirty, [2]: cmpt",
        }
      ]
    },
    { name:     "TAG_1764",
      desc:     "Tag Address stored in cache line 1764",
      swaccess: "rw",
      hwaccess: "hrw",
      hwext:    "true",
      hwqe:     "true", // enable `qe` latched signal of software write pulse
      hwre:     "true",
      fields: [
        { bits: "5-1:0",
          name: "CL_TAG",
          desc: "Tag Address"
        }
      ]
    },
    {
      name:     "STATUS_1765",
      desc:     "Status register of cache line 1765",
      swaccess: "rw",
      hwaccess: "hrw",
      hwext:    "true",
      hwqe:     "true", // enable `qe` latched signal of software write pulse
      hwre:     "true",
      fields: [
        {
          bits: "5+3:5", // 2 bits for status
          name: "CL_STATUS",
          desc: "Contain the current status of the corresponding cache line                [0]: valid, [1]: dirty, [2]: cmpt",
        }
      ]
    },
    { name:     "TAG_1765",
      desc:     "Tag Address stored in cache line 1765",
      swaccess: "rw",
      hwaccess: "hrw",
      hwext:    "true",
      hwqe:     "true", // enable `qe` latched signal of software write pulse
      hwre:     "true",
      fields: [
        { bits: "5-1:0",
          name: "CL_TAG",
          desc: "Tag Address"
        }
      ]
    },
    {
      name:     "STATUS_1766",
      desc:     "Status register of cache line 1766",
      swaccess: "rw",
      hwaccess: "hrw",
      hwext:    "true",
      hwqe:     "true", // enable `qe` latched signal of software write pulse
      hwre:     "true",
      fields: [
        {
          bits: "5+3:5", // 2 bits for status
          name: "CL_STATUS",
          desc: "Contain the current status of the corresponding cache line                [0]: valid, [1]: dirty, [2]: cmpt",
        }
      ]
    },
    { name:     "TAG_1766",
      desc:     "Tag Address stored in cache line 1766",
      swaccess: "rw",
      hwaccess: "hrw",
      hwext:    "true",
      hwqe:     "true", // enable `qe` latched signal of software write pulse
      hwre:     "true",
      fields: [
        { bits: "5-1:0",
          name: "CL_TAG",
          desc: "Tag Address"
        }
      ]
    },
    {
      name:     "STATUS_1767",
      desc:     "Status register of cache line 1767",
      swaccess: "rw",
      hwaccess: "hrw",
      hwext:    "true",
      hwqe:     "true", // enable `qe` latched signal of software write pulse
      hwre:     "true",
      fields: [
        {
          bits: "5+3:5", // 2 bits for status
          name: "CL_STATUS",
          desc: "Contain the current status of the corresponding cache line                [0]: valid, [1]: dirty, [2]: cmpt",
        }
      ]
    },
    { name:     "TAG_1767",
      desc:     "Tag Address stored in cache line 1767",
      swaccess: "rw",
      hwaccess: "hrw",
      hwext:    "true",
      hwqe:     "true", // enable `qe` latched signal of software write pulse
      hwre:     "true",
      fields: [
        { bits: "5-1:0",
          name: "CL_TAG",
          desc: "Tag Address"
        }
      ]
    },
    {
      name:     "STATUS_1768",
      desc:     "Status register of cache line 1768",
      swaccess: "rw",
      hwaccess: "hrw",
      hwext:    "true",
      hwqe:     "true", // enable `qe` latched signal of software write pulse
      hwre:     "true",
      fields: [
        {
          bits: "5+3:5", // 2 bits for status
          name: "CL_STATUS",
          desc: "Contain the current status of the corresponding cache line                [0]: valid, [1]: dirty, [2]: cmpt",
        }
      ]
    },
    { name:     "TAG_1768",
      desc:     "Tag Address stored in cache line 1768",
      swaccess: "rw",
      hwaccess: "hrw",
      hwext:    "true",
      hwqe:     "true", // enable `qe` latched signal of software write pulse
      hwre:     "true",
      fields: [
        { bits: "5-1:0",
          name: "CL_TAG",
          desc: "Tag Address"
        }
      ]
    },
    {
      name:     "STATUS_1769",
      desc:     "Status register of cache line 1769",
      swaccess: "rw",
      hwaccess: "hrw",
      hwext:    "true",
      hwqe:     "true", // enable `qe` latched signal of software write pulse
      hwre:     "true",
      fields: [
        {
          bits: "5+3:5", // 2 bits for status
          name: "CL_STATUS",
          desc: "Contain the current status of the corresponding cache line                [0]: valid, [1]: dirty, [2]: cmpt",
        }
      ]
    },
    { name:     "TAG_1769",
      desc:     "Tag Address stored in cache line 1769",
      swaccess: "rw",
      hwaccess: "hrw",
      hwext:    "true",
      hwqe:     "true", // enable `qe` latched signal of software write pulse
      hwre:     "true",
      fields: [
        { bits: "5-1:0",
          name: "CL_TAG",
          desc: "Tag Address"
        }
      ]
    },
    {
      name:     "STATUS_1770",
      desc:     "Status register of cache line 1770",
      swaccess: "rw",
      hwaccess: "hrw",
      hwext:    "true",
      hwqe:     "true", // enable `qe` latched signal of software write pulse
      hwre:     "true",
      fields: [
        {
          bits: "5+3:5", // 2 bits for status
          name: "CL_STATUS",
          desc: "Contain the current status of the corresponding cache line                [0]: valid, [1]: dirty, [2]: cmpt",
        }
      ]
    },
    { name:     "TAG_1770",
      desc:     "Tag Address stored in cache line 1770",
      swaccess: "rw",
      hwaccess: "hrw",
      hwext:    "true",
      hwqe:     "true", // enable `qe` latched signal of software write pulse
      hwre:     "true",
      fields: [
        { bits: "5-1:0",
          name: "CL_TAG",
          desc: "Tag Address"
        }
      ]
    },
    {
      name:     "STATUS_1771",
      desc:     "Status register of cache line 1771",
      swaccess: "rw",
      hwaccess: "hrw",
      hwext:    "true",
      hwqe:     "true", // enable `qe` latched signal of software write pulse
      hwre:     "true",
      fields: [
        {
          bits: "5+3:5", // 2 bits for status
          name: "CL_STATUS",
          desc: "Contain the current status of the corresponding cache line                [0]: valid, [1]: dirty, [2]: cmpt",
        }
      ]
    },
    { name:     "TAG_1771",
      desc:     "Tag Address stored in cache line 1771",
      swaccess: "rw",
      hwaccess: "hrw",
      hwext:    "true",
      hwqe:     "true", // enable `qe` latched signal of software write pulse
      hwre:     "true",
      fields: [
        { bits: "5-1:0",
          name: "CL_TAG",
          desc: "Tag Address"
        }
      ]
    },
    {
      name:     "STATUS_1772",
      desc:     "Status register of cache line 1772",
      swaccess: "rw",
      hwaccess: "hrw",
      hwext:    "true",
      hwqe:     "true", // enable `qe` latched signal of software write pulse
      hwre:     "true",
      fields: [
        {
          bits: "5+3:5", // 2 bits for status
          name: "CL_STATUS",
          desc: "Contain the current status of the corresponding cache line                [0]: valid, [1]: dirty, [2]: cmpt",
        }
      ]
    },
    { name:     "TAG_1772",
      desc:     "Tag Address stored in cache line 1772",
      swaccess: "rw",
      hwaccess: "hrw",
      hwext:    "true",
      hwqe:     "true", // enable `qe` latched signal of software write pulse
      hwre:     "true",
      fields: [
        { bits: "5-1:0",
          name: "CL_TAG",
          desc: "Tag Address"
        }
      ]
    },
    {
      name:     "STATUS_1773",
      desc:     "Status register of cache line 1773",
      swaccess: "rw",
      hwaccess: "hrw",
      hwext:    "true",
      hwqe:     "true", // enable `qe` latched signal of software write pulse
      hwre:     "true",
      fields: [
        {
          bits: "5+3:5", // 2 bits for status
          name: "CL_STATUS",
          desc: "Contain the current status of the corresponding cache line                [0]: valid, [1]: dirty, [2]: cmpt",
        }
      ]
    },
    { name:     "TAG_1773",
      desc:     "Tag Address stored in cache line 1773",
      swaccess: "rw",
      hwaccess: "hrw",
      hwext:    "true",
      hwqe:     "true", // enable `qe` latched signal of software write pulse
      hwre:     "true",
      fields: [
        { bits: "5-1:0",
          name: "CL_TAG",
          desc: "Tag Address"
        }
      ]
    },
    {
      name:     "STATUS_1774",
      desc:     "Status register of cache line 1774",
      swaccess: "rw",
      hwaccess: "hrw",
      hwext:    "true",
      hwqe:     "true", // enable `qe` latched signal of software write pulse
      hwre:     "true",
      fields: [
        {
          bits: "5+3:5", // 2 bits for status
          name: "CL_STATUS",
          desc: "Contain the current status of the corresponding cache line                [0]: valid, [1]: dirty, [2]: cmpt",
        }
      ]
    },
    { name:     "TAG_1774",
      desc:     "Tag Address stored in cache line 1774",
      swaccess: "rw",
      hwaccess: "hrw",
      hwext:    "true",
      hwqe:     "true", // enable `qe` latched signal of software write pulse
      hwre:     "true",
      fields: [
        { bits: "5-1:0",
          name: "CL_TAG",
          desc: "Tag Address"
        }
      ]
    },
    {
      name:     "STATUS_1775",
      desc:     "Status register of cache line 1775",
      swaccess: "rw",
      hwaccess: "hrw",
      hwext:    "true",
      hwqe:     "true", // enable `qe` latched signal of software write pulse
      hwre:     "true",
      fields: [
        {
          bits: "5+3:5", // 2 bits for status
          name: "CL_STATUS",
          desc: "Contain the current status of the corresponding cache line                [0]: valid, [1]: dirty, [2]: cmpt",
        }
      ]
    },
    { name:     "TAG_1775",
      desc:     "Tag Address stored in cache line 1775",
      swaccess: "rw",
      hwaccess: "hrw",
      hwext:    "true",
      hwqe:     "true", // enable `qe` latched signal of software write pulse
      hwre:     "true",
      fields: [
        { bits: "5-1:0",
          name: "CL_TAG",
          desc: "Tag Address"
        }
      ]
    },
    {
      name:     "STATUS_1776",
      desc:     "Status register of cache line 1776",
      swaccess: "rw",
      hwaccess: "hrw",
      hwext:    "true",
      hwqe:     "true", // enable `qe` latched signal of software write pulse
      hwre:     "true",
      fields: [
        {
          bits: "5+3:5", // 2 bits for status
          name: "CL_STATUS",
          desc: "Contain the current status of the corresponding cache line                [0]: valid, [1]: dirty, [2]: cmpt",
        }
      ]
    },
    { name:     "TAG_1776",
      desc:     "Tag Address stored in cache line 1776",
      swaccess: "rw",
      hwaccess: "hrw",
      hwext:    "true",
      hwqe:     "true", // enable `qe` latched signal of software write pulse
      hwre:     "true",
      fields: [
        { bits: "5-1:0",
          name: "CL_TAG",
          desc: "Tag Address"
        }
      ]
    },
    {
      name:     "STATUS_1777",
      desc:     "Status register of cache line 1777",
      swaccess: "rw",
      hwaccess: "hrw",
      hwext:    "true",
      hwqe:     "true", // enable `qe` latched signal of software write pulse
      hwre:     "true",
      fields: [
        {
          bits: "5+3:5", // 2 bits for status
          name: "CL_STATUS",
          desc: "Contain the current status of the corresponding cache line                [0]: valid, [1]: dirty, [2]: cmpt",
        }
      ]
    },
    { name:     "TAG_1777",
      desc:     "Tag Address stored in cache line 1777",
      swaccess: "rw",
      hwaccess: "hrw",
      hwext:    "true",
      hwqe:     "true", // enable `qe` latched signal of software write pulse
      hwre:     "true",
      fields: [
        { bits: "5-1:0",
          name: "CL_TAG",
          desc: "Tag Address"
        }
      ]
    },
    {
      name:     "STATUS_1778",
      desc:     "Status register of cache line 1778",
      swaccess: "rw",
      hwaccess: "hrw",
      hwext:    "true",
      hwqe:     "true", // enable `qe` latched signal of software write pulse
      hwre:     "true",
      fields: [
        {
          bits: "5+3:5", // 2 bits for status
          name: "CL_STATUS",
          desc: "Contain the current status of the corresponding cache line                [0]: valid, [1]: dirty, [2]: cmpt",
        }
      ]
    },
    { name:     "TAG_1778",
      desc:     "Tag Address stored in cache line 1778",
      swaccess: "rw",
      hwaccess: "hrw",
      hwext:    "true",
      hwqe:     "true", // enable `qe` latched signal of software write pulse
      hwre:     "true",
      fields: [
        { bits: "5-1:0",
          name: "CL_TAG",
          desc: "Tag Address"
        }
      ]
    },
    {
      name:     "STATUS_1779",
      desc:     "Status register of cache line 1779",
      swaccess: "rw",
      hwaccess: "hrw",
      hwext:    "true",
      hwqe:     "true", // enable `qe` latched signal of software write pulse
      hwre:     "true",
      fields: [
        {
          bits: "5+3:5", // 2 bits for status
          name: "CL_STATUS",
          desc: "Contain the current status of the corresponding cache line                [0]: valid, [1]: dirty, [2]: cmpt",
        }
      ]
    },
    { name:     "TAG_1779",
      desc:     "Tag Address stored in cache line 1779",
      swaccess: "rw",
      hwaccess: "hrw",
      hwext:    "true",
      hwqe:     "true", // enable `qe` latched signal of software write pulse
      hwre:     "true",
      fields: [
        { bits: "5-1:0",
          name: "CL_TAG",
          desc: "Tag Address"
        }
      ]
    },
    {
      name:     "STATUS_1780",
      desc:     "Status register of cache line 1780",
      swaccess: "rw",
      hwaccess: "hrw",
      hwext:    "true",
      hwqe:     "true", // enable `qe` latched signal of software write pulse
      hwre:     "true",
      fields: [
        {
          bits: "5+3:5", // 2 bits for status
          name: "CL_STATUS",
          desc: "Contain the current status of the corresponding cache line                [0]: valid, [1]: dirty, [2]: cmpt",
        }
      ]
    },
    { name:     "TAG_1780",
      desc:     "Tag Address stored in cache line 1780",
      swaccess: "rw",
      hwaccess: "hrw",
      hwext:    "true",
      hwqe:     "true", // enable `qe` latched signal of software write pulse
      hwre:     "true",
      fields: [
        { bits: "5-1:0",
          name: "CL_TAG",
          desc: "Tag Address"
        }
      ]
    },
    {
      name:     "STATUS_1781",
      desc:     "Status register of cache line 1781",
      swaccess: "rw",
      hwaccess: "hrw",
      hwext:    "true",
      hwqe:     "true", // enable `qe` latched signal of software write pulse
      hwre:     "true",
      fields: [
        {
          bits: "5+3:5", // 2 bits for status
          name: "CL_STATUS",
          desc: "Contain the current status of the corresponding cache line                [0]: valid, [1]: dirty, [2]: cmpt",
        }
      ]
    },
    { name:     "TAG_1781",
      desc:     "Tag Address stored in cache line 1781",
      swaccess: "rw",
      hwaccess: "hrw",
      hwext:    "true",
      hwqe:     "true", // enable `qe` latched signal of software write pulse
      hwre:     "true",
      fields: [
        { bits: "5-1:0",
          name: "CL_TAG",
          desc: "Tag Address"
        }
      ]
    },
    {
      name:     "STATUS_1782",
      desc:     "Status register of cache line 1782",
      swaccess: "rw",
      hwaccess: "hrw",
      hwext:    "true",
      hwqe:     "true", // enable `qe` latched signal of software write pulse
      hwre:     "true",
      fields: [
        {
          bits: "5+3:5", // 2 bits for status
          name: "CL_STATUS",
          desc: "Contain the current status of the corresponding cache line                [0]: valid, [1]: dirty, [2]: cmpt",
        }
      ]
    },
    { name:     "TAG_1782",
      desc:     "Tag Address stored in cache line 1782",
      swaccess: "rw",
      hwaccess: "hrw",
      hwext:    "true",
      hwqe:     "true", // enable `qe` latched signal of software write pulse
      hwre:     "true",
      fields: [
        { bits: "5-1:0",
          name: "CL_TAG",
          desc: "Tag Address"
        }
      ]
    },
    {
      name:     "STATUS_1783",
      desc:     "Status register of cache line 1783",
      swaccess: "rw",
      hwaccess: "hrw",
      hwext:    "true",
      hwqe:     "true", // enable `qe` latched signal of software write pulse
      hwre:     "true",
      fields: [
        {
          bits: "5+3:5", // 2 bits for status
          name: "CL_STATUS",
          desc: "Contain the current status of the corresponding cache line                [0]: valid, [1]: dirty, [2]: cmpt",
        }
      ]
    },
    { name:     "TAG_1783",
      desc:     "Tag Address stored in cache line 1783",
      swaccess: "rw",
      hwaccess: "hrw",
      hwext:    "true",
      hwqe:     "true", // enable `qe` latched signal of software write pulse
      hwre:     "true",
      fields: [
        { bits: "5-1:0",
          name: "CL_TAG",
          desc: "Tag Address"
        }
      ]
    },
    {
      name:     "STATUS_1784",
      desc:     "Status register of cache line 1784",
      swaccess: "rw",
      hwaccess: "hrw",
      hwext:    "true",
      hwqe:     "true", // enable `qe` latched signal of software write pulse
      hwre:     "true",
      fields: [
        {
          bits: "5+3:5", // 2 bits for status
          name: "CL_STATUS",
          desc: "Contain the current status of the corresponding cache line                [0]: valid, [1]: dirty, [2]: cmpt",
        }
      ]
    },
    { name:     "TAG_1784",
      desc:     "Tag Address stored in cache line 1784",
      swaccess: "rw",
      hwaccess: "hrw",
      hwext:    "true",
      hwqe:     "true", // enable `qe` latched signal of software write pulse
      hwre:     "true",
      fields: [
        { bits: "5-1:0",
          name: "CL_TAG",
          desc: "Tag Address"
        }
      ]
    },
    {
      name:     "STATUS_1785",
      desc:     "Status register of cache line 1785",
      swaccess: "rw",
      hwaccess: "hrw",
      hwext:    "true",
      hwqe:     "true", // enable `qe` latched signal of software write pulse
      hwre:     "true",
      fields: [
        {
          bits: "5+3:5", // 2 bits for status
          name: "CL_STATUS",
          desc: "Contain the current status of the corresponding cache line                [0]: valid, [1]: dirty, [2]: cmpt",
        }
      ]
    },
    { name:     "TAG_1785",
      desc:     "Tag Address stored in cache line 1785",
      swaccess: "rw",
      hwaccess: "hrw",
      hwext:    "true",
      hwqe:     "true", // enable `qe` latched signal of software write pulse
      hwre:     "true",
      fields: [
        { bits: "5-1:0",
          name: "CL_TAG",
          desc: "Tag Address"
        }
      ]
    },
    {
      name:     "STATUS_1786",
      desc:     "Status register of cache line 1786",
      swaccess: "rw",
      hwaccess: "hrw",
      hwext:    "true",
      hwqe:     "true", // enable `qe` latched signal of software write pulse
      hwre:     "true",
      fields: [
        {
          bits: "5+3:5", // 2 bits for status
          name: "CL_STATUS",
          desc: "Contain the current status of the corresponding cache line                [0]: valid, [1]: dirty, [2]: cmpt",
        }
      ]
    },
    { name:     "TAG_1786",
      desc:     "Tag Address stored in cache line 1786",
      swaccess: "rw",
      hwaccess: "hrw",
      hwext:    "true",
      hwqe:     "true", // enable `qe` latched signal of software write pulse
      hwre:     "true",
      fields: [
        { bits: "5-1:0",
          name: "CL_TAG",
          desc: "Tag Address"
        }
      ]
    },
    {
      name:     "STATUS_1787",
      desc:     "Status register of cache line 1787",
      swaccess: "rw",
      hwaccess: "hrw",
      hwext:    "true",
      hwqe:     "true", // enable `qe` latched signal of software write pulse
      hwre:     "true",
      fields: [
        {
          bits: "5+3:5", // 2 bits for status
          name: "CL_STATUS",
          desc: "Contain the current status of the corresponding cache line                [0]: valid, [1]: dirty, [2]: cmpt",
        }
      ]
    },
    { name:     "TAG_1787",
      desc:     "Tag Address stored in cache line 1787",
      swaccess: "rw",
      hwaccess: "hrw",
      hwext:    "true",
      hwqe:     "true", // enable `qe` latched signal of software write pulse
      hwre:     "true",
      fields: [
        { bits: "5-1:0",
          name: "CL_TAG",
          desc: "Tag Address"
        }
      ]
    },
    {
      name:     "STATUS_1788",
      desc:     "Status register of cache line 1788",
      swaccess: "rw",
      hwaccess: "hrw",
      hwext:    "true",
      hwqe:     "true", // enable `qe` latched signal of software write pulse
      hwre:     "true",
      fields: [
        {
          bits: "5+3:5", // 2 bits for status
          name: "CL_STATUS",
          desc: "Contain the current status of the corresponding cache line                [0]: valid, [1]: dirty, [2]: cmpt",
        }
      ]
    },
    { name:     "TAG_1788",
      desc:     "Tag Address stored in cache line 1788",
      swaccess: "rw",
      hwaccess: "hrw",
      hwext:    "true",
      hwqe:     "true", // enable `qe` latched signal of software write pulse
      hwre:     "true",
      fields: [
        { bits: "5-1:0",
          name: "CL_TAG",
          desc: "Tag Address"
        }
      ]
    },
    {
      name:     "STATUS_1789",
      desc:     "Status register of cache line 1789",
      swaccess: "rw",
      hwaccess: "hrw",
      hwext:    "true",
      hwqe:     "true", // enable `qe` latched signal of software write pulse
      hwre:     "true",
      fields: [
        {
          bits: "5+3:5", // 2 bits for status
          name: "CL_STATUS",
          desc: "Contain the current status of the corresponding cache line                [0]: valid, [1]: dirty, [2]: cmpt",
        }
      ]
    },
    { name:     "TAG_1789",
      desc:     "Tag Address stored in cache line 1789",
      swaccess: "rw",
      hwaccess: "hrw",
      hwext:    "true",
      hwqe:     "true", // enable `qe` latched signal of software write pulse
      hwre:     "true",
      fields: [
        { bits: "5-1:0",
          name: "CL_TAG",
          desc: "Tag Address"
        }
      ]
    },
    {
      name:     "STATUS_1790",
      desc:     "Status register of cache line 1790",
      swaccess: "rw",
      hwaccess: "hrw",
      hwext:    "true",
      hwqe:     "true", // enable `qe` latched signal of software write pulse
      hwre:     "true",
      fields: [
        {
          bits: "5+3:5", // 2 bits for status
          name: "CL_STATUS",
          desc: "Contain the current status of the corresponding cache line                [0]: valid, [1]: dirty, [2]: cmpt",
        }
      ]
    },
    { name:     "TAG_1790",
      desc:     "Tag Address stored in cache line 1790",
      swaccess: "rw",
      hwaccess: "hrw",
      hwext:    "true",
      hwqe:     "true", // enable `qe` latched signal of software write pulse
      hwre:     "true",
      fields: [
        { bits: "5-1:0",
          name: "CL_TAG",
          desc: "Tag Address"
        }
      ]
    },
    {
      name:     "STATUS_1791",
      desc:     "Status register of cache line 1791",
      swaccess: "rw",
      hwaccess: "hrw",
      hwext:    "true",
      hwqe:     "true", // enable `qe` latched signal of software write pulse
      hwre:     "true",
      fields: [
        {
          bits: "5+3:5", // 2 bits for status
          name: "CL_STATUS",
          desc: "Contain the current status of the corresponding cache line                [0]: valid, [1]: dirty, [2]: cmpt",
        }
      ]
    },
    { name:     "TAG_1791",
      desc:     "Tag Address stored in cache line 1791",
      swaccess: "rw",
      hwaccess: "hrw",
      hwext:    "true",
      hwqe:     "true", // enable `qe` latched signal of software write pulse
      hwre:     "true",
      fields: [
        { bits: "5-1:0",
          name: "CL_TAG",
          desc: "Tag Address"
        }
      ]
    },
    {
      name:     "STATUS_1792",
      desc:     "Status register of cache line 1792",
      swaccess: "rw",
      hwaccess: "hrw",
      hwext:    "true",
      hwqe:     "true", // enable `qe` latched signal of software write pulse
      hwre:     "true",
      fields: [
        {
          bits: "5+3:5", // 2 bits for status
          name: "CL_STATUS",
          desc: "Contain the current status of the corresponding cache line                [0]: valid, [1]: dirty, [2]: cmpt",
        }
      ]
    },
    { name:     "TAG_1792",
      desc:     "Tag Address stored in cache line 1792",
      swaccess: "rw",
      hwaccess: "hrw",
      hwext:    "true",
      hwqe:     "true", // enable `qe` latched signal of software write pulse
      hwre:     "true",
      fields: [
        { bits: "5-1:0",
          name: "CL_TAG",
          desc: "Tag Address"
        }
      ]
    },
    {
      name:     "STATUS_1793",
      desc:     "Status register of cache line 1793",
      swaccess: "rw",
      hwaccess: "hrw",
      hwext:    "true",
      hwqe:     "true", // enable `qe` latched signal of software write pulse
      hwre:     "true",
      fields: [
        {
          bits: "5+3:5", // 2 bits for status
          name: "CL_STATUS",
          desc: "Contain the current status of the corresponding cache line                [0]: valid, [1]: dirty, [2]: cmpt",
        }
      ]
    },
    { name:     "TAG_1793",
      desc:     "Tag Address stored in cache line 1793",
      swaccess: "rw",
      hwaccess: "hrw",
      hwext:    "true",
      hwqe:     "true", // enable `qe` latched signal of software write pulse
      hwre:     "true",
      fields: [
        { bits: "5-1:0",
          name: "CL_TAG",
          desc: "Tag Address"
        }
      ]
    },
    {
      name:     "STATUS_1794",
      desc:     "Status register of cache line 1794",
      swaccess: "rw",
      hwaccess: "hrw",
      hwext:    "true",
      hwqe:     "true", // enable `qe` latched signal of software write pulse
      hwre:     "true",
      fields: [
        {
          bits: "5+3:5", // 2 bits for status
          name: "CL_STATUS",
          desc: "Contain the current status of the corresponding cache line                [0]: valid, [1]: dirty, [2]: cmpt",
        }
      ]
    },
    { name:     "TAG_1794",
      desc:     "Tag Address stored in cache line 1794",
      swaccess: "rw",
      hwaccess: "hrw",
      hwext:    "true",
      hwqe:     "true", // enable `qe` latched signal of software write pulse
      hwre:     "true",
      fields: [
        { bits: "5-1:0",
          name: "CL_TAG",
          desc: "Tag Address"
        }
      ]
    },
    {
      name:     "STATUS_1795",
      desc:     "Status register of cache line 1795",
      swaccess: "rw",
      hwaccess: "hrw",
      hwext:    "true",
      hwqe:     "true", // enable `qe` latched signal of software write pulse
      hwre:     "true",
      fields: [
        {
          bits: "5+3:5", // 2 bits for status
          name: "CL_STATUS",
          desc: "Contain the current status of the corresponding cache line                [0]: valid, [1]: dirty, [2]: cmpt",
        }
      ]
    },
    { name:     "TAG_1795",
      desc:     "Tag Address stored in cache line 1795",
      swaccess: "rw",
      hwaccess: "hrw",
      hwext:    "true",
      hwqe:     "true", // enable `qe` latched signal of software write pulse
      hwre:     "true",
      fields: [
        { bits: "5-1:0",
          name: "CL_TAG",
          desc: "Tag Address"
        }
      ]
    },
    {
      name:     "STATUS_1796",
      desc:     "Status register of cache line 1796",
      swaccess: "rw",
      hwaccess: "hrw",
      hwext:    "true",
      hwqe:     "true", // enable `qe` latched signal of software write pulse
      hwre:     "true",
      fields: [
        {
          bits: "5+3:5", // 2 bits for status
          name: "CL_STATUS",
          desc: "Contain the current status of the corresponding cache line                [0]: valid, [1]: dirty, [2]: cmpt",
        }
      ]
    },
    { name:     "TAG_1796",
      desc:     "Tag Address stored in cache line 1796",
      swaccess: "rw",
      hwaccess: "hrw",
      hwext:    "true",
      hwqe:     "true", // enable `qe` latched signal of software write pulse
      hwre:     "true",
      fields: [
        { bits: "5-1:0",
          name: "CL_TAG",
          desc: "Tag Address"
        }
      ]
    },
    {
      name:     "STATUS_1797",
      desc:     "Status register of cache line 1797",
      swaccess: "rw",
      hwaccess: "hrw",
      hwext:    "true",
      hwqe:     "true", // enable `qe` latched signal of software write pulse
      hwre:     "true",
      fields: [
        {
          bits: "5+3:5", // 2 bits for status
          name: "CL_STATUS",
          desc: "Contain the current status of the corresponding cache line                [0]: valid, [1]: dirty, [2]: cmpt",
        }
      ]
    },
    { name:     "TAG_1797",
      desc:     "Tag Address stored in cache line 1797",
      swaccess: "rw",
      hwaccess: "hrw",
      hwext:    "true",
      hwqe:     "true", // enable `qe` latched signal of software write pulse
      hwre:     "true",
      fields: [
        { bits: "5-1:0",
          name: "CL_TAG",
          desc: "Tag Address"
        }
      ]
    },
    {
      name:     "STATUS_1798",
      desc:     "Status register of cache line 1798",
      swaccess: "rw",
      hwaccess: "hrw",
      hwext:    "true",
      hwqe:     "true", // enable `qe` latched signal of software write pulse
      hwre:     "true",
      fields: [
        {
          bits: "5+3:5", // 2 bits for status
          name: "CL_STATUS",
          desc: "Contain the current status of the corresponding cache line                [0]: valid, [1]: dirty, [2]: cmpt",
        }
      ]
    },
    { name:     "TAG_1798",
      desc:     "Tag Address stored in cache line 1798",
      swaccess: "rw",
      hwaccess: "hrw",
      hwext:    "true",
      hwqe:     "true", // enable `qe` latched signal of software write pulse
      hwre:     "true",
      fields: [
        { bits: "5-1:0",
          name: "CL_TAG",
          desc: "Tag Address"
        }
      ]
    },
    {
      name:     "STATUS_1799",
      desc:     "Status register of cache line 1799",
      swaccess: "rw",
      hwaccess: "hrw",
      hwext:    "true",
      hwqe:     "true", // enable `qe` latched signal of software write pulse
      hwre:     "true",
      fields: [
        {
          bits: "5+3:5", // 2 bits for status
          name: "CL_STATUS",
          desc: "Contain the current status of the corresponding cache line                [0]: valid, [1]: dirty, [2]: cmpt",
        }
      ]
    },
    { name:     "TAG_1799",
      desc:     "Tag Address stored in cache line 1799",
      swaccess: "rw",
      hwaccess: "hrw",
      hwext:    "true",
      hwqe:     "true", // enable `qe` latched signal of software write pulse
      hwre:     "true",
      fields: [
        { bits: "5-1:0",
          name: "CL_TAG",
          desc: "Tag Address"
        }
      ]
    },
    {
      name:     "STATUS_1800",
      desc:     "Status register of cache line 1800",
      swaccess: "rw",
      hwaccess: "hrw",
      hwext:    "true",
      hwqe:     "true", // enable `qe` latched signal of software write pulse
      hwre:     "true",
      fields: [
        {
          bits: "5+3:5", // 2 bits for status
          name: "CL_STATUS",
          desc: "Contain the current status of the corresponding cache line                [0]: valid, [1]: dirty, [2]: cmpt",
        }
      ]
    },
    { name:     "TAG_1800",
      desc:     "Tag Address stored in cache line 1800",
      swaccess: "rw",
      hwaccess: "hrw",
      hwext:    "true",
      hwqe:     "true", // enable `qe` latched signal of software write pulse
      hwre:     "true",
      fields: [
        { bits: "5-1:0",
          name: "CL_TAG",
          desc: "Tag Address"
        }
      ]
    },
    {
      name:     "STATUS_1801",
      desc:     "Status register of cache line 1801",
      swaccess: "rw",
      hwaccess: "hrw",
      hwext:    "true",
      hwqe:     "true", // enable `qe` latched signal of software write pulse
      hwre:     "true",
      fields: [
        {
          bits: "5+3:5", // 2 bits for status
          name: "CL_STATUS",
          desc: "Contain the current status of the corresponding cache line                [0]: valid, [1]: dirty, [2]: cmpt",
        }
      ]
    },
    { name:     "TAG_1801",
      desc:     "Tag Address stored in cache line 1801",
      swaccess: "rw",
      hwaccess: "hrw",
      hwext:    "true",
      hwqe:     "true", // enable `qe` latched signal of software write pulse
      hwre:     "true",
      fields: [
        { bits: "5-1:0",
          name: "CL_TAG",
          desc: "Tag Address"
        }
      ]
    },
    {
      name:     "STATUS_1802",
      desc:     "Status register of cache line 1802",
      swaccess: "rw",
      hwaccess: "hrw",
      hwext:    "true",
      hwqe:     "true", // enable `qe` latched signal of software write pulse
      hwre:     "true",
      fields: [
        {
          bits: "5+3:5", // 2 bits for status
          name: "CL_STATUS",
          desc: "Contain the current status of the corresponding cache line                [0]: valid, [1]: dirty, [2]: cmpt",
        }
      ]
    },
    { name:     "TAG_1802",
      desc:     "Tag Address stored in cache line 1802",
      swaccess: "rw",
      hwaccess: "hrw",
      hwext:    "true",
      hwqe:     "true", // enable `qe` latched signal of software write pulse
      hwre:     "true",
      fields: [
        { bits: "5-1:0",
          name: "CL_TAG",
          desc: "Tag Address"
        }
      ]
    },
    {
      name:     "STATUS_1803",
      desc:     "Status register of cache line 1803",
      swaccess: "rw",
      hwaccess: "hrw",
      hwext:    "true",
      hwqe:     "true", // enable `qe` latched signal of software write pulse
      hwre:     "true",
      fields: [
        {
          bits: "5+3:5", // 2 bits for status
          name: "CL_STATUS",
          desc: "Contain the current status of the corresponding cache line                [0]: valid, [1]: dirty, [2]: cmpt",
        }
      ]
    },
    { name:     "TAG_1803",
      desc:     "Tag Address stored in cache line 1803",
      swaccess: "rw",
      hwaccess: "hrw",
      hwext:    "true",
      hwqe:     "true", // enable `qe` latched signal of software write pulse
      hwre:     "true",
      fields: [
        { bits: "5-1:0",
          name: "CL_TAG",
          desc: "Tag Address"
        }
      ]
    },
    {
      name:     "STATUS_1804",
      desc:     "Status register of cache line 1804",
      swaccess: "rw",
      hwaccess: "hrw",
      hwext:    "true",
      hwqe:     "true", // enable `qe` latched signal of software write pulse
      hwre:     "true",
      fields: [
        {
          bits: "5+3:5", // 2 bits for status
          name: "CL_STATUS",
          desc: "Contain the current status of the corresponding cache line                [0]: valid, [1]: dirty, [2]: cmpt",
        }
      ]
    },
    { name:     "TAG_1804",
      desc:     "Tag Address stored in cache line 1804",
      swaccess: "rw",
      hwaccess: "hrw",
      hwext:    "true",
      hwqe:     "true", // enable `qe` latched signal of software write pulse
      hwre:     "true",
      fields: [
        { bits: "5-1:0",
          name: "CL_TAG",
          desc: "Tag Address"
        }
      ]
    },
    {
      name:     "STATUS_1805",
      desc:     "Status register of cache line 1805",
      swaccess: "rw",
      hwaccess: "hrw",
      hwext:    "true",
      hwqe:     "true", // enable `qe` latched signal of software write pulse
      hwre:     "true",
      fields: [
        {
          bits: "5+3:5", // 2 bits for status
          name: "CL_STATUS",
          desc: "Contain the current status of the corresponding cache line                [0]: valid, [1]: dirty, [2]: cmpt",
        }
      ]
    },
    { name:     "TAG_1805",
      desc:     "Tag Address stored in cache line 1805",
      swaccess: "rw",
      hwaccess: "hrw",
      hwext:    "true",
      hwqe:     "true", // enable `qe` latched signal of software write pulse
      hwre:     "true",
      fields: [
        { bits: "5-1:0",
          name: "CL_TAG",
          desc: "Tag Address"
        }
      ]
    },
    {
      name:     "STATUS_1806",
      desc:     "Status register of cache line 1806",
      swaccess: "rw",
      hwaccess: "hrw",
      hwext:    "true",
      hwqe:     "true", // enable `qe` latched signal of software write pulse
      hwre:     "true",
      fields: [
        {
          bits: "5+3:5", // 2 bits for status
          name: "CL_STATUS",
          desc: "Contain the current status of the corresponding cache line                [0]: valid, [1]: dirty, [2]: cmpt",
        }
      ]
    },
    { name:     "TAG_1806",
      desc:     "Tag Address stored in cache line 1806",
      swaccess: "rw",
      hwaccess: "hrw",
      hwext:    "true",
      hwqe:     "true", // enable `qe` latched signal of software write pulse
      hwre:     "true",
      fields: [
        { bits: "5-1:0",
          name: "CL_TAG",
          desc: "Tag Address"
        }
      ]
    },
    {
      name:     "STATUS_1807",
      desc:     "Status register of cache line 1807",
      swaccess: "rw",
      hwaccess: "hrw",
      hwext:    "true",
      hwqe:     "true", // enable `qe` latched signal of software write pulse
      hwre:     "true",
      fields: [
        {
          bits: "5+3:5", // 2 bits for status
          name: "CL_STATUS",
          desc: "Contain the current status of the corresponding cache line                [0]: valid, [1]: dirty, [2]: cmpt",
        }
      ]
    },
    { name:     "TAG_1807",
      desc:     "Tag Address stored in cache line 1807",
      swaccess: "rw",
      hwaccess: "hrw",
      hwext:    "true",
      hwqe:     "true", // enable `qe` latched signal of software write pulse
      hwre:     "true",
      fields: [
        { bits: "5-1:0",
          name: "CL_TAG",
          desc: "Tag Address"
        }
      ]
    },
    {
      name:     "STATUS_1808",
      desc:     "Status register of cache line 1808",
      swaccess: "rw",
      hwaccess: "hrw",
      hwext:    "true",
      hwqe:     "true", // enable `qe` latched signal of software write pulse
      hwre:     "true",
      fields: [
        {
          bits: "5+3:5", // 2 bits for status
          name: "CL_STATUS",
          desc: "Contain the current status of the corresponding cache line                [0]: valid, [1]: dirty, [2]: cmpt",
        }
      ]
    },
    { name:     "TAG_1808",
      desc:     "Tag Address stored in cache line 1808",
      swaccess: "rw",
      hwaccess: "hrw",
      hwext:    "true",
      hwqe:     "true", // enable `qe` latched signal of software write pulse
      hwre:     "true",
      fields: [
        { bits: "5-1:0",
          name: "CL_TAG",
          desc: "Tag Address"
        }
      ]
    },
    {
      name:     "STATUS_1809",
      desc:     "Status register of cache line 1809",
      swaccess: "rw",
      hwaccess: "hrw",
      hwext:    "true",
      hwqe:     "true", // enable `qe` latched signal of software write pulse
      hwre:     "true",
      fields: [
        {
          bits: "5+3:5", // 2 bits for status
          name: "CL_STATUS",
          desc: "Contain the current status of the corresponding cache line                [0]: valid, [1]: dirty, [2]: cmpt",
        }
      ]
    },
    { name:     "TAG_1809",
      desc:     "Tag Address stored in cache line 1809",
      swaccess: "rw",
      hwaccess: "hrw",
      hwext:    "true",
      hwqe:     "true", // enable `qe` latched signal of software write pulse
      hwre:     "true",
      fields: [
        { bits: "5-1:0",
          name: "CL_TAG",
          desc: "Tag Address"
        }
      ]
    },
    {
      name:     "STATUS_1810",
      desc:     "Status register of cache line 1810",
      swaccess: "rw",
      hwaccess: "hrw",
      hwext:    "true",
      hwqe:     "true", // enable `qe` latched signal of software write pulse
      hwre:     "true",
      fields: [
        {
          bits: "5+3:5", // 2 bits for status
          name: "CL_STATUS",
          desc: "Contain the current status of the corresponding cache line                [0]: valid, [1]: dirty, [2]: cmpt",
        }
      ]
    },
    { name:     "TAG_1810",
      desc:     "Tag Address stored in cache line 1810",
      swaccess: "rw",
      hwaccess: "hrw",
      hwext:    "true",
      hwqe:     "true", // enable `qe` latched signal of software write pulse
      hwre:     "true",
      fields: [
        { bits: "5-1:0",
          name: "CL_TAG",
          desc: "Tag Address"
        }
      ]
    },
    {
      name:     "STATUS_1811",
      desc:     "Status register of cache line 1811",
      swaccess: "rw",
      hwaccess: "hrw",
      hwext:    "true",
      hwqe:     "true", // enable `qe` latched signal of software write pulse
      hwre:     "true",
      fields: [
        {
          bits: "5+3:5", // 2 bits for status
          name: "CL_STATUS",
          desc: "Contain the current status of the corresponding cache line                [0]: valid, [1]: dirty, [2]: cmpt",
        }
      ]
    },
    { name:     "TAG_1811",
      desc:     "Tag Address stored in cache line 1811",
      swaccess: "rw",
      hwaccess: "hrw",
      hwext:    "true",
      hwqe:     "true", // enable `qe` latched signal of software write pulse
      hwre:     "true",
      fields: [
        { bits: "5-1:0",
          name: "CL_TAG",
          desc: "Tag Address"
        }
      ]
    },
    {
      name:     "STATUS_1812",
      desc:     "Status register of cache line 1812",
      swaccess: "rw",
      hwaccess: "hrw",
      hwext:    "true",
      hwqe:     "true", // enable `qe` latched signal of software write pulse
      hwre:     "true",
      fields: [
        {
          bits: "5+3:5", // 2 bits for status
          name: "CL_STATUS",
          desc: "Contain the current status of the corresponding cache line                [0]: valid, [1]: dirty, [2]: cmpt",
        }
      ]
    },
    { name:     "TAG_1812",
      desc:     "Tag Address stored in cache line 1812",
      swaccess: "rw",
      hwaccess: "hrw",
      hwext:    "true",
      hwqe:     "true", // enable `qe` latched signal of software write pulse
      hwre:     "true",
      fields: [
        { bits: "5-1:0",
          name: "CL_TAG",
          desc: "Tag Address"
        }
      ]
    },
    {
      name:     "STATUS_1813",
      desc:     "Status register of cache line 1813",
      swaccess: "rw",
      hwaccess: "hrw",
      hwext:    "true",
      hwqe:     "true", // enable `qe` latched signal of software write pulse
      hwre:     "true",
      fields: [
        {
          bits: "5+3:5", // 2 bits for status
          name: "CL_STATUS",
          desc: "Contain the current status of the corresponding cache line                [0]: valid, [1]: dirty, [2]: cmpt",
        }
      ]
    },
    { name:     "TAG_1813",
      desc:     "Tag Address stored in cache line 1813",
      swaccess: "rw",
      hwaccess: "hrw",
      hwext:    "true",
      hwqe:     "true", // enable `qe` latched signal of software write pulse
      hwre:     "true",
      fields: [
        { bits: "5-1:0",
          name: "CL_TAG",
          desc: "Tag Address"
        }
      ]
    },
    {
      name:     "STATUS_1814",
      desc:     "Status register of cache line 1814",
      swaccess: "rw",
      hwaccess: "hrw",
      hwext:    "true",
      hwqe:     "true", // enable `qe` latched signal of software write pulse
      hwre:     "true",
      fields: [
        {
          bits: "5+3:5", // 2 bits for status
          name: "CL_STATUS",
          desc: "Contain the current status of the corresponding cache line                [0]: valid, [1]: dirty, [2]: cmpt",
        }
      ]
    },
    { name:     "TAG_1814",
      desc:     "Tag Address stored in cache line 1814",
      swaccess: "rw",
      hwaccess: "hrw",
      hwext:    "true",
      hwqe:     "true", // enable `qe` latched signal of software write pulse
      hwre:     "true",
      fields: [
        { bits: "5-1:0",
          name: "CL_TAG",
          desc: "Tag Address"
        }
      ]
    },
    {
      name:     "STATUS_1815",
      desc:     "Status register of cache line 1815",
      swaccess: "rw",
      hwaccess: "hrw",
      hwext:    "true",
      hwqe:     "true", // enable `qe` latched signal of software write pulse
      hwre:     "true",
      fields: [
        {
          bits: "5+3:5", // 2 bits for status
          name: "CL_STATUS",
          desc: "Contain the current status of the corresponding cache line                [0]: valid, [1]: dirty, [2]: cmpt",
        }
      ]
    },
    { name:     "TAG_1815",
      desc:     "Tag Address stored in cache line 1815",
      swaccess: "rw",
      hwaccess: "hrw",
      hwext:    "true",
      hwqe:     "true", // enable `qe` latched signal of software write pulse
      hwre:     "true",
      fields: [
        { bits: "5-1:0",
          name: "CL_TAG",
          desc: "Tag Address"
        }
      ]
    },
    {
      name:     "STATUS_1816",
      desc:     "Status register of cache line 1816",
      swaccess: "rw",
      hwaccess: "hrw",
      hwext:    "true",
      hwqe:     "true", // enable `qe` latched signal of software write pulse
      hwre:     "true",
      fields: [
        {
          bits: "5+3:5", // 2 bits for status
          name: "CL_STATUS",
          desc: "Contain the current status of the corresponding cache line                [0]: valid, [1]: dirty, [2]: cmpt",
        }
      ]
    },
    { name:     "TAG_1816",
      desc:     "Tag Address stored in cache line 1816",
      swaccess: "rw",
      hwaccess: "hrw",
      hwext:    "true",
      hwqe:     "true", // enable `qe` latched signal of software write pulse
      hwre:     "true",
      fields: [
        { bits: "5-1:0",
          name: "CL_TAG",
          desc: "Tag Address"
        }
      ]
    },
    {
      name:     "STATUS_1817",
      desc:     "Status register of cache line 1817",
      swaccess: "rw",
      hwaccess: "hrw",
      hwext:    "true",
      hwqe:     "true", // enable `qe` latched signal of software write pulse
      hwre:     "true",
      fields: [
        {
          bits: "5+3:5", // 2 bits for status
          name: "CL_STATUS",
          desc: "Contain the current status of the corresponding cache line                [0]: valid, [1]: dirty, [2]: cmpt",
        }
      ]
    },
    { name:     "TAG_1817",
      desc:     "Tag Address stored in cache line 1817",
      swaccess: "rw",
      hwaccess: "hrw",
      hwext:    "true",
      hwqe:     "true", // enable `qe` latched signal of software write pulse
      hwre:     "true",
      fields: [
        { bits: "5-1:0",
          name: "CL_TAG",
          desc: "Tag Address"
        }
      ]
    },
    {
      name:     "STATUS_1818",
      desc:     "Status register of cache line 1818",
      swaccess: "rw",
      hwaccess: "hrw",
      hwext:    "true",
      hwqe:     "true", // enable `qe` latched signal of software write pulse
      hwre:     "true",
      fields: [
        {
          bits: "5+3:5", // 2 bits for status
          name: "CL_STATUS",
          desc: "Contain the current status of the corresponding cache line                [0]: valid, [1]: dirty, [2]: cmpt",
        }
      ]
    },
    { name:     "TAG_1818",
      desc:     "Tag Address stored in cache line 1818",
      swaccess: "rw",
      hwaccess: "hrw",
      hwext:    "true",
      hwqe:     "true", // enable `qe` latched signal of software write pulse
      hwre:     "true",
      fields: [
        { bits: "5-1:0",
          name: "CL_TAG",
          desc: "Tag Address"
        }
      ]
    },
    {
      name:     "STATUS_1819",
      desc:     "Status register of cache line 1819",
      swaccess: "rw",
      hwaccess: "hrw",
      hwext:    "true",
      hwqe:     "true", // enable `qe` latched signal of software write pulse
      hwre:     "true",
      fields: [
        {
          bits: "5+3:5", // 2 bits for status
          name: "CL_STATUS",
          desc: "Contain the current status of the corresponding cache line                [0]: valid, [1]: dirty, [2]: cmpt",
        }
      ]
    },
    { name:     "TAG_1819",
      desc:     "Tag Address stored in cache line 1819",
      swaccess: "rw",
      hwaccess: "hrw",
      hwext:    "true",
      hwqe:     "true", // enable `qe` latched signal of software write pulse
      hwre:     "true",
      fields: [
        { bits: "5-1:0",
          name: "CL_TAG",
          desc: "Tag Address"
        }
      ]
    },
    {
      name:     "STATUS_1820",
      desc:     "Status register of cache line 1820",
      swaccess: "rw",
      hwaccess: "hrw",
      hwext:    "true",
      hwqe:     "true", // enable `qe` latched signal of software write pulse
      hwre:     "true",
      fields: [
        {
          bits: "5+3:5", // 2 bits for status
          name: "CL_STATUS",
          desc: "Contain the current status of the corresponding cache line                [0]: valid, [1]: dirty, [2]: cmpt",
        }
      ]
    },
    { name:     "TAG_1820",
      desc:     "Tag Address stored in cache line 1820",
      swaccess: "rw",
      hwaccess: "hrw",
      hwext:    "true",
      hwqe:     "true", // enable `qe` latched signal of software write pulse
      hwre:     "true",
      fields: [
        { bits: "5-1:0",
          name: "CL_TAG",
          desc: "Tag Address"
        }
      ]
    },
    {
      name:     "STATUS_1821",
      desc:     "Status register of cache line 1821",
      swaccess: "rw",
      hwaccess: "hrw",
      hwext:    "true",
      hwqe:     "true", // enable `qe` latched signal of software write pulse
      hwre:     "true",
      fields: [
        {
          bits: "5+3:5", // 2 bits for status
          name: "CL_STATUS",
          desc: "Contain the current status of the corresponding cache line                [0]: valid, [1]: dirty, [2]: cmpt",
        }
      ]
    },
    { name:     "TAG_1821",
      desc:     "Tag Address stored in cache line 1821",
      swaccess: "rw",
      hwaccess: "hrw",
      hwext:    "true",
      hwqe:     "true", // enable `qe` latched signal of software write pulse
      hwre:     "true",
      fields: [
        { bits: "5-1:0",
          name: "CL_TAG",
          desc: "Tag Address"
        }
      ]
    },
    {
      name:     "STATUS_1822",
      desc:     "Status register of cache line 1822",
      swaccess: "rw",
      hwaccess: "hrw",
      hwext:    "true",
      hwqe:     "true", // enable `qe` latched signal of software write pulse
      hwre:     "true",
      fields: [
        {
          bits: "5+3:5", // 2 bits for status
          name: "CL_STATUS",
          desc: "Contain the current status of the corresponding cache line                [0]: valid, [1]: dirty, [2]: cmpt",
        }
      ]
    },
    { name:     "TAG_1822",
      desc:     "Tag Address stored in cache line 1822",
      swaccess: "rw",
      hwaccess: "hrw",
      hwext:    "true",
      hwqe:     "true", // enable `qe` latched signal of software write pulse
      hwre:     "true",
      fields: [
        { bits: "5-1:0",
          name: "CL_TAG",
          desc: "Tag Address"
        }
      ]
    },
    {
      name:     "STATUS_1823",
      desc:     "Status register of cache line 1823",
      swaccess: "rw",
      hwaccess: "hrw",
      hwext:    "true",
      hwqe:     "true", // enable `qe` latched signal of software write pulse
      hwre:     "true",
      fields: [
        {
          bits: "5+3:5", // 2 bits for status
          name: "CL_STATUS",
          desc: "Contain the current status of the corresponding cache line                [0]: valid, [1]: dirty, [2]: cmpt",
        }
      ]
    },
    { name:     "TAG_1823",
      desc:     "Tag Address stored in cache line 1823",
      swaccess: "rw",
      hwaccess: "hrw",
      hwext:    "true",
      hwqe:     "true", // enable `qe` latched signal of software write pulse
      hwre:     "true",
      fields: [
        { bits: "5-1:0",
          name: "CL_TAG",
          desc: "Tag Address"
        }
      ]
    },
    {
      name:     "STATUS_1824",
      desc:     "Status register of cache line 1824",
      swaccess: "rw",
      hwaccess: "hrw",
      hwext:    "true",
      hwqe:     "true", // enable `qe` latched signal of software write pulse
      hwre:     "true",
      fields: [
        {
          bits: "5+3:5", // 2 bits for status
          name: "CL_STATUS",
          desc: "Contain the current status of the corresponding cache line                [0]: valid, [1]: dirty, [2]: cmpt",
        }
      ]
    },
    { name:     "TAG_1824",
      desc:     "Tag Address stored in cache line 1824",
      swaccess: "rw",
      hwaccess: "hrw",
      hwext:    "true",
      hwqe:     "true", // enable `qe` latched signal of software write pulse
      hwre:     "true",
      fields: [
        { bits: "5-1:0",
          name: "CL_TAG",
          desc: "Tag Address"
        }
      ]
    },
    {
      name:     "STATUS_1825",
      desc:     "Status register of cache line 1825",
      swaccess: "rw",
      hwaccess: "hrw",
      hwext:    "true",
      hwqe:     "true", // enable `qe` latched signal of software write pulse
      hwre:     "true",
      fields: [
        {
          bits: "5+3:5", // 2 bits for status
          name: "CL_STATUS",
          desc: "Contain the current status of the corresponding cache line                [0]: valid, [1]: dirty, [2]: cmpt",
        }
      ]
    },
    { name:     "TAG_1825",
      desc:     "Tag Address stored in cache line 1825",
      swaccess: "rw",
      hwaccess: "hrw",
      hwext:    "true",
      hwqe:     "true", // enable `qe` latched signal of software write pulse
      hwre:     "true",
      fields: [
        { bits: "5-1:0",
          name: "CL_TAG",
          desc: "Tag Address"
        }
      ]
    },
    {
      name:     "STATUS_1826",
      desc:     "Status register of cache line 1826",
      swaccess: "rw",
      hwaccess: "hrw",
      hwext:    "true",
      hwqe:     "true", // enable `qe` latched signal of software write pulse
      hwre:     "true",
      fields: [
        {
          bits: "5+3:5", // 2 bits for status
          name: "CL_STATUS",
          desc: "Contain the current status of the corresponding cache line                [0]: valid, [1]: dirty, [2]: cmpt",
        }
      ]
    },
    { name:     "TAG_1826",
      desc:     "Tag Address stored in cache line 1826",
      swaccess: "rw",
      hwaccess: "hrw",
      hwext:    "true",
      hwqe:     "true", // enable `qe` latched signal of software write pulse
      hwre:     "true",
      fields: [
        { bits: "5-1:0",
          name: "CL_TAG",
          desc: "Tag Address"
        }
      ]
    },
    {
      name:     "STATUS_1827",
      desc:     "Status register of cache line 1827",
      swaccess: "rw",
      hwaccess: "hrw",
      hwext:    "true",
      hwqe:     "true", // enable `qe` latched signal of software write pulse
      hwre:     "true",
      fields: [
        {
          bits: "5+3:5", // 2 bits for status
          name: "CL_STATUS",
          desc: "Contain the current status of the corresponding cache line                [0]: valid, [1]: dirty, [2]: cmpt",
        }
      ]
    },
    { name:     "TAG_1827",
      desc:     "Tag Address stored in cache line 1827",
      swaccess: "rw",
      hwaccess: "hrw",
      hwext:    "true",
      hwqe:     "true", // enable `qe` latched signal of software write pulse
      hwre:     "true",
      fields: [
        { bits: "5-1:0",
          name: "CL_TAG",
          desc: "Tag Address"
        }
      ]
    },
    {
      name:     "STATUS_1828",
      desc:     "Status register of cache line 1828",
      swaccess: "rw",
      hwaccess: "hrw",
      hwext:    "true",
      hwqe:     "true", // enable `qe` latched signal of software write pulse
      hwre:     "true",
      fields: [
        {
          bits: "5+3:5", // 2 bits for status
          name: "CL_STATUS",
          desc: "Contain the current status of the corresponding cache line                [0]: valid, [1]: dirty, [2]: cmpt",
        }
      ]
    },
    { name:     "TAG_1828",
      desc:     "Tag Address stored in cache line 1828",
      swaccess: "rw",
      hwaccess: "hrw",
      hwext:    "true",
      hwqe:     "true", // enable `qe` latched signal of software write pulse
      hwre:     "true",
      fields: [
        { bits: "5-1:0",
          name: "CL_TAG",
          desc: "Tag Address"
        }
      ]
    },
    {
      name:     "STATUS_1829",
      desc:     "Status register of cache line 1829",
      swaccess: "rw",
      hwaccess: "hrw",
      hwext:    "true",
      hwqe:     "true", // enable `qe` latched signal of software write pulse
      hwre:     "true",
      fields: [
        {
          bits: "5+3:5", // 2 bits for status
          name: "CL_STATUS",
          desc: "Contain the current status of the corresponding cache line                [0]: valid, [1]: dirty, [2]: cmpt",
        }
      ]
    },
    { name:     "TAG_1829",
      desc:     "Tag Address stored in cache line 1829",
      swaccess: "rw",
      hwaccess: "hrw",
      hwext:    "true",
      hwqe:     "true", // enable `qe` latched signal of software write pulse
      hwre:     "true",
      fields: [
        { bits: "5-1:0",
          name: "CL_TAG",
          desc: "Tag Address"
        }
      ]
    },
    {
      name:     "STATUS_1830",
      desc:     "Status register of cache line 1830",
      swaccess: "rw",
      hwaccess: "hrw",
      hwext:    "true",
      hwqe:     "true", // enable `qe` latched signal of software write pulse
      hwre:     "true",
      fields: [
        {
          bits: "5+3:5", // 2 bits for status
          name: "CL_STATUS",
          desc: "Contain the current status of the corresponding cache line                [0]: valid, [1]: dirty, [2]: cmpt",
        }
      ]
    },
    { name:     "TAG_1830",
      desc:     "Tag Address stored in cache line 1830",
      swaccess: "rw",
      hwaccess: "hrw",
      hwext:    "true",
      hwqe:     "true", // enable `qe` latched signal of software write pulse
      hwre:     "true",
      fields: [
        { bits: "5-1:0",
          name: "CL_TAG",
          desc: "Tag Address"
        }
      ]
    },
    {
      name:     "STATUS_1831",
      desc:     "Status register of cache line 1831",
      swaccess: "rw",
      hwaccess: "hrw",
      hwext:    "true",
      hwqe:     "true", // enable `qe` latched signal of software write pulse
      hwre:     "true",
      fields: [
        {
          bits: "5+3:5", // 2 bits for status
          name: "CL_STATUS",
          desc: "Contain the current status of the corresponding cache line                [0]: valid, [1]: dirty, [2]: cmpt",
        }
      ]
    },
    { name:     "TAG_1831",
      desc:     "Tag Address stored in cache line 1831",
      swaccess: "rw",
      hwaccess: "hrw",
      hwext:    "true",
      hwqe:     "true", // enable `qe` latched signal of software write pulse
      hwre:     "true",
      fields: [
        { bits: "5-1:0",
          name: "CL_TAG",
          desc: "Tag Address"
        }
      ]
    },
    {
      name:     "STATUS_1832",
      desc:     "Status register of cache line 1832",
      swaccess: "rw",
      hwaccess: "hrw",
      hwext:    "true",
      hwqe:     "true", // enable `qe` latched signal of software write pulse
      hwre:     "true",
      fields: [
        {
          bits: "5+3:5", // 2 bits for status
          name: "CL_STATUS",
          desc: "Contain the current status of the corresponding cache line                [0]: valid, [1]: dirty, [2]: cmpt",
        }
      ]
    },
    { name:     "TAG_1832",
      desc:     "Tag Address stored in cache line 1832",
      swaccess: "rw",
      hwaccess: "hrw",
      hwext:    "true",
      hwqe:     "true", // enable `qe` latched signal of software write pulse
      hwre:     "true",
      fields: [
        { bits: "5-1:0",
          name: "CL_TAG",
          desc: "Tag Address"
        }
      ]
    },
    {
      name:     "STATUS_1833",
      desc:     "Status register of cache line 1833",
      swaccess: "rw",
      hwaccess: "hrw",
      hwext:    "true",
      hwqe:     "true", // enable `qe` latched signal of software write pulse
      hwre:     "true",
      fields: [
        {
          bits: "5+3:5", // 2 bits for status
          name: "CL_STATUS",
          desc: "Contain the current status of the corresponding cache line                [0]: valid, [1]: dirty, [2]: cmpt",
        }
      ]
    },
    { name:     "TAG_1833",
      desc:     "Tag Address stored in cache line 1833",
      swaccess: "rw",
      hwaccess: "hrw",
      hwext:    "true",
      hwqe:     "true", // enable `qe` latched signal of software write pulse
      hwre:     "true",
      fields: [
        { bits: "5-1:0",
          name: "CL_TAG",
          desc: "Tag Address"
        }
      ]
    },
    {
      name:     "STATUS_1834",
      desc:     "Status register of cache line 1834",
      swaccess: "rw",
      hwaccess: "hrw",
      hwext:    "true",
      hwqe:     "true", // enable `qe` latched signal of software write pulse
      hwre:     "true",
      fields: [
        {
          bits: "5+3:5", // 2 bits for status
          name: "CL_STATUS",
          desc: "Contain the current status of the corresponding cache line                [0]: valid, [1]: dirty, [2]: cmpt",
        }
      ]
    },
    { name:     "TAG_1834",
      desc:     "Tag Address stored in cache line 1834",
      swaccess: "rw",
      hwaccess: "hrw",
      hwext:    "true",
      hwqe:     "true", // enable `qe` latched signal of software write pulse
      hwre:     "true",
      fields: [
        { bits: "5-1:0",
          name: "CL_TAG",
          desc: "Tag Address"
        }
      ]
    },
    {
      name:     "STATUS_1835",
      desc:     "Status register of cache line 1835",
      swaccess: "rw",
      hwaccess: "hrw",
      hwext:    "true",
      hwqe:     "true", // enable `qe` latched signal of software write pulse
      hwre:     "true",
      fields: [
        {
          bits: "5+3:5", // 2 bits for status
          name: "CL_STATUS",
          desc: "Contain the current status of the corresponding cache line                [0]: valid, [1]: dirty, [2]: cmpt",
        }
      ]
    },
    { name:     "TAG_1835",
      desc:     "Tag Address stored in cache line 1835",
      swaccess: "rw",
      hwaccess: "hrw",
      hwext:    "true",
      hwqe:     "true", // enable `qe` latched signal of software write pulse
      hwre:     "true",
      fields: [
        { bits: "5-1:0",
          name: "CL_TAG",
          desc: "Tag Address"
        }
      ]
    },
    {
      name:     "STATUS_1836",
      desc:     "Status register of cache line 1836",
      swaccess: "rw",
      hwaccess: "hrw",
      hwext:    "true",
      hwqe:     "true", // enable `qe` latched signal of software write pulse
      hwre:     "true",
      fields: [
        {
          bits: "5+3:5", // 2 bits for status
          name: "CL_STATUS",
          desc: "Contain the current status of the corresponding cache line                [0]: valid, [1]: dirty, [2]: cmpt",
        }
      ]
    },
    { name:     "TAG_1836",
      desc:     "Tag Address stored in cache line 1836",
      swaccess: "rw",
      hwaccess: "hrw",
      hwext:    "true",
      hwqe:     "true", // enable `qe` latched signal of software write pulse
      hwre:     "true",
      fields: [
        { bits: "5-1:0",
          name: "CL_TAG",
          desc: "Tag Address"
        }
      ]
    },
    {
      name:     "STATUS_1837",
      desc:     "Status register of cache line 1837",
      swaccess: "rw",
      hwaccess: "hrw",
      hwext:    "true",
      hwqe:     "true", // enable `qe` latched signal of software write pulse
      hwre:     "true",
      fields: [
        {
          bits: "5+3:5", // 2 bits for status
          name: "CL_STATUS",
          desc: "Contain the current status of the corresponding cache line                [0]: valid, [1]: dirty, [2]: cmpt",
        }
      ]
    },
    { name:     "TAG_1837",
      desc:     "Tag Address stored in cache line 1837",
      swaccess: "rw",
      hwaccess: "hrw",
      hwext:    "true",
      hwqe:     "true", // enable `qe` latched signal of software write pulse
      hwre:     "true",
      fields: [
        { bits: "5-1:0",
          name: "CL_TAG",
          desc: "Tag Address"
        }
      ]
    },
    {
      name:     "STATUS_1838",
      desc:     "Status register of cache line 1838",
      swaccess: "rw",
      hwaccess: "hrw",
      hwext:    "true",
      hwqe:     "true", // enable `qe` latched signal of software write pulse
      hwre:     "true",
      fields: [
        {
          bits: "5+3:5", // 2 bits for status
          name: "CL_STATUS",
          desc: "Contain the current status of the corresponding cache line                [0]: valid, [1]: dirty, [2]: cmpt",
        }
      ]
    },
    { name:     "TAG_1838",
      desc:     "Tag Address stored in cache line 1838",
      swaccess: "rw",
      hwaccess: "hrw",
      hwext:    "true",
      hwqe:     "true", // enable `qe` latched signal of software write pulse
      hwre:     "true",
      fields: [
        { bits: "5-1:0",
          name: "CL_TAG",
          desc: "Tag Address"
        }
      ]
    },
    {
      name:     "STATUS_1839",
      desc:     "Status register of cache line 1839",
      swaccess: "rw",
      hwaccess: "hrw",
      hwext:    "true",
      hwqe:     "true", // enable `qe` latched signal of software write pulse
      hwre:     "true",
      fields: [
        {
          bits: "5+3:5", // 2 bits for status
          name: "CL_STATUS",
          desc: "Contain the current status of the corresponding cache line                [0]: valid, [1]: dirty, [2]: cmpt",
        }
      ]
    },
    { name:     "TAG_1839",
      desc:     "Tag Address stored in cache line 1839",
      swaccess: "rw",
      hwaccess: "hrw",
      hwext:    "true",
      hwqe:     "true", // enable `qe` latched signal of software write pulse
      hwre:     "true",
      fields: [
        { bits: "5-1:0",
          name: "CL_TAG",
          desc: "Tag Address"
        }
      ]
    },
    {
      name:     "STATUS_1840",
      desc:     "Status register of cache line 1840",
      swaccess: "rw",
      hwaccess: "hrw",
      hwext:    "true",
      hwqe:     "true", // enable `qe` latched signal of software write pulse
      hwre:     "true",
      fields: [
        {
          bits: "5+3:5", // 2 bits for status
          name: "CL_STATUS",
          desc: "Contain the current status of the corresponding cache line                [0]: valid, [1]: dirty, [2]: cmpt",
        }
      ]
    },
    { name:     "TAG_1840",
      desc:     "Tag Address stored in cache line 1840",
      swaccess: "rw",
      hwaccess: "hrw",
      hwext:    "true",
      hwqe:     "true", // enable `qe` latched signal of software write pulse
      hwre:     "true",
      fields: [
        { bits: "5-1:0",
          name: "CL_TAG",
          desc: "Tag Address"
        }
      ]
    },
    {
      name:     "STATUS_1841",
      desc:     "Status register of cache line 1841",
      swaccess: "rw",
      hwaccess: "hrw",
      hwext:    "true",
      hwqe:     "true", // enable `qe` latched signal of software write pulse
      hwre:     "true",
      fields: [
        {
          bits: "5+3:5", // 2 bits for status
          name: "CL_STATUS",
          desc: "Contain the current status of the corresponding cache line                [0]: valid, [1]: dirty, [2]: cmpt",
        }
      ]
    },
    { name:     "TAG_1841",
      desc:     "Tag Address stored in cache line 1841",
      swaccess: "rw",
      hwaccess: "hrw",
      hwext:    "true",
      hwqe:     "true", // enable `qe` latched signal of software write pulse
      hwre:     "true",
      fields: [
        { bits: "5-1:0",
          name: "CL_TAG",
          desc: "Tag Address"
        }
      ]
    },
    {
      name:     "STATUS_1842",
      desc:     "Status register of cache line 1842",
      swaccess: "rw",
      hwaccess: "hrw",
      hwext:    "true",
      hwqe:     "true", // enable `qe` latched signal of software write pulse
      hwre:     "true",
      fields: [
        {
          bits: "5+3:5", // 2 bits for status
          name: "CL_STATUS",
          desc: "Contain the current status of the corresponding cache line                [0]: valid, [1]: dirty, [2]: cmpt",
        }
      ]
    },
    { name:     "TAG_1842",
      desc:     "Tag Address stored in cache line 1842",
      swaccess: "rw",
      hwaccess: "hrw",
      hwext:    "true",
      hwqe:     "true", // enable `qe` latched signal of software write pulse
      hwre:     "true",
      fields: [
        { bits: "5-1:0",
          name: "CL_TAG",
          desc: "Tag Address"
        }
      ]
    },
    {
      name:     "STATUS_1843",
      desc:     "Status register of cache line 1843",
      swaccess: "rw",
      hwaccess: "hrw",
      hwext:    "true",
      hwqe:     "true", // enable `qe` latched signal of software write pulse
      hwre:     "true",
      fields: [
        {
          bits: "5+3:5", // 2 bits for status
          name: "CL_STATUS",
          desc: "Contain the current status of the corresponding cache line                [0]: valid, [1]: dirty, [2]: cmpt",
        }
      ]
    },
    { name:     "TAG_1843",
      desc:     "Tag Address stored in cache line 1843",
      swaccess: "rw",
      hwaccess: "hrw",
      hwext:    "true",
      hwqe:     "true", // enable `qe` latched signal of software write pulse
      hwre:     "true",
      fields: [
        { bits: "5-1:0",
          name: "CL_TAG",
          desc: "Tag Address"
        }
      ]
    },
    {
      name:     "STATUS_1844",
      desc:     "Status register of cache line 1844",
      swaccess: "rw",
      hwaccess: "hrw",
      hwext:    "true",
      hwqe:     "true", // enable `qe` latched signal of software write pulse
      hwre:     "true",
      fields: [
        {
          bits: "5+3:5", // 2 bits for status
          name: "CL_STATUS",
          desc: "Contain the current status of the corresponding cache line                [0]: valid, [1]: dirty, [2]: cmpt",
        }
      ]
    },
    { name:     "TAG_1844",
      desc:     "Tag Address stored in cache line 1844",
      swaccess: "rw",
      hwaccess: "hrw",
      hwext:    "true",
      hwqe:     "true", // enable `qe` latched signal of software write pulse
      hwre:     "true",
      fields: [
        { bits: "5-1:0",
          name: "CL_TAG",
          desc: "Tag Address"
        }
      ]
    },
    {
      name:     "STATUS_1845",
      desc:     "Status register of cache line 1845",
      swaccess: "rw",
      hwaccess: "hrw",
      hwext:    "true",
      hwqe:     "true", // enable `qe` latched signal of software write pulse
      hwre:     "true",
      fields: [
        {
          bits: "5+3:5", // 2 bits for status
          name: "CL_STATUS",
          desc: "Contain the current status of the corresponding cache line                [0]: valid, [1]: dirty, [2]: cmpt",
        }
      ]
    },
    { name:     "TAG_1845",
      desc:     "Tag Address stored in cache line 1845",
      swaccess: "rw",
      hwaccess: "hrw",
      hwext:    "true",
      hwqe:     "true", // enable `qe` latched signal of software write pulse
      hwre:     "true",
      fields: [
        { bits: "5-1:0",
          name: "CL_TAG",
          desc: "Tag Address"
        }
      ]
    },
    {
      name:     "STATUS_1846",
      desc:     "Status register of cache line 1846",
      swaccess: "rw",
      hwaccess: "hrw",
      hwext:    "true",
      hwqe:     "true", // enable `qe` latched signal of software write pulse
      hwre:     "true",
      fields: [
        {
          bits: "5+3:5", // 2 bits for status
          name: "CL_STATUS",
          desc: "Contain the current status of the corresponding cache line                [0]: valid, [1]: dirty, [2]: cmpt",
        }
      ]
    },
    { name:     "TAG_1846",
      desc:     "Tag Address stored in cache line 1846",
      swaccess: "rw",
      hwaccess: "hrw",
      hwext:    "true",
      hwqe:     "true", // enable `qe` latched signal of software write pulse
      hwre:     "true",
      fields: [
        { bits: "5-1:0",
          name: "CL_TAG",
          desc: "Tag Address"
        }
      ]
    },
    {
      name:     "STATUS_1847",
      desc:     "Status register of cache line 1847",
      swaccess: "rw",
      hwaccess: "hrw",
      hwext:    "true",
      hwqe:     "true", // enable `qe` latched signal of software write pulse
      hwre:     "true",
      fields: [
        {
          bits: "5+3:5", // 2 bits for status
          name: "CL_STATUS",
          desc: "Contain the current status of the corresponding cache line                [0]: valid, [1]: dirty, [2]: cmpt",
        }
      ]
    },
    { name:     "TAG_1847",
      desc:     "Tag Address stored in cache line 1847",
      swaccess: "rw",
      hwaccess: "hrw",
      hwext:    "true",
      hwqe:     "true", // enable `qe` latched signal of software write pulse
      hwre:     "true",
      fields: [
        { bits: "5-1:0",
          name: "CL_TAG",
          desc: "Tag Address"
        }
      ]
    },
    {
      name:     "STATUS_1848",
      desc:     "Status register of cache line 1848",
      swaccess: "rw",
      hwaccess: "hrw",
      hwext:    "true",
      hwqe:     "true", // enable `qe` latched signal of software write pulse
      hwre:     "true",
      fields: [
        {
          bits: "5+3:5", // 2 bits for status
          name: "CL_STATUS",
          desc: "Contain the current status of the corresponding cache line                [0]: valid, [1]: dirty, [2]: cmpt",
        }
      ]
    },
    { name:     "TAG_1848",
      desc:     "Tag Address stored in cache line 1848",
      swaccess: "rw",
      hwaccess: "hrw",
      hwext:    "true",
      hwqe:     "true", // enable `qe` latched signal of software write pulse
      hwre:     "true",
      fields: [
        { bits: "5-1:0",
          name: "CL_TAG",
          desc: "Tag Address"
        }
      ]
    },
    {
      name:     "STATUS_1849",
      desc:     "Status register of cache line 1849",
      swaccess: "rw",
      hwaccess: "hrw",
      hwext:    "true",
      hwqe:     "true", // enable `qe` latched signal of software write pulse
      hwre:     "true",
      fields: [
        {
          bits: "5+3:5", // 2 bits for status
          name: "CL_STATUS",
          desc: "Contain the current status of the corresponding cache line                [0]: valid, [1]: dirty, [2]: cmpt",
        }
      ]
    },
    { name:     "TAG_1849",
      desc:     "Tag Address stored in cache line 1849",
      swaccess: "rw",
      hwaccess: "hrw",
      hwext:    "true",
      hwqe:     "true", // enable `qe` latched signal of software write pulse
      hwre:     "true",
      fields: [
        { bits: "5-1:0",
          name: "CL_TAG",
          desc: "Tag Address"
        }
      ]
    },
    {
      name:     "STATUS_1850",
      desc:     "Status register of cache line 1850",
      swaccess: "rw",
      hwaccess: "hrw",
      hwext:    "true",
      hwqe:     "true", // enable `qe` latched signal of software write pulse
      hwre:     "true",
      fields: [
        {
          bits: "5+3:5", // 2 bits for status
          name: "CL_STATUS",
          desc: "Contain the current status of the corresponding cache line                [0]: valid, [1]: dirty, [2]: cmpt",
        }
      ]
    },
    { name:     "TAG_1850",
      desc:     "Tag Address stored in cache line 1850",
      swaccess: "rw",
      hwaccess: "hrw",
      hwext:    "true",
      hwqe:     "true", // enable `qe` latched signal of software write pulse
      hwre:     "true",
      fields: [
        { bits: "5-1:0",
          name: "CL_TAG",
          desc: "Tag Address"
        }
      ]
    },
    {
      name:     "STATUS_1851",
      desc:     "Status register of cache line 1851",
      swaccess: "rw",
      hwaccess: "hrw",
      hwext:    "true",
      hwqe:     "true", // enable `qe` latched signal of software write pulse
      hwre:     "true",
      fields: [
        {
          bits: "5+3:5", // 2 bits for status
          name: "CL_STATUS",
          desc: "Contain the current status of the corresponding cache line                [0]: valid, [1]: dirty, [2]: cmpt",
        }
      ]
    },
    { name:     "TAG_1851",
      desc:     "Tag Address stored in cache line 1851",
      swaccess: "rw",
      hwaccess: "hrw",
      hwext:    "true",
      hwqe:     "true", // enable `qe` latched signal of software write pulse
      hwre:     "true",
      fields: [
        { bits: "5-1:0",
          name: "CL_TAG",
          desc: "Tag Address"
        }
      ]
    },
    {
      name:     "STATUS_1852",
      desc:     "Status register of cache line 1852",
      swaccess: "rw",
      hwaccess: "hrw",
      hwext:    "true",
      hwqe:     "true", // enable `qe` latched signal of software write pulse
      hwre:     "true",
      fields: [
        {
          bits: "5+3:5", // 2 bits for status
          name: "CL_STATUS",
          desc: "Contain the current status of the corresponding cache line                [0]: valid, [1]: dirty, [2]: cmpt",
        }
      ]
    },
    { name:     "TAG_1852",
      desc:     "Tag Address stored in cache line 1852",
      swaccess: "rw",
      hwaccess: "hrw",
      hwext:    "true",
      hwqe:     "true", // enable `qe` latched signal of software write pulse
      hwre:     "true",
      fields: [
        { bits: "5-1:0",
          name: "CL_TAG",
          desc: "Tag Address"
        }
      ]
    },
    {
      name:     "STATUS_1853",
      desc:     "Status register of cache line 1853",
      swaccess: "rw",
      hwaccess: "hrw",
      hwext:    "true",
      hwqe:     "true", // enable `qe` latched signal of software write pulse
      hwre:     "true",
      fields: [
        {
          bits: "5+3:5", // 2 bits for status
          name: "CL_STATUS",
          desc: "Contain the current status of the corresponding cache line                [0]: valid, [1]: dirty, [2]: cmpt",
        }
      ]
    },
    { name:     "TAG_1853",
      desc:     "Tag Address stored in cache line 1853",
      swaccess: "rw",
      hwaccess: "hrw",
      hwext:    "true",
      hwqe:     "true", // enable `qe` latched signal of software write pulse
      hwre:     "true",
      fields: [
        { bits: "5-1:0",
          name: "CL_TAG",
          desc: "Tag Address"
        }
      ]
    },
    {
      name:     "STATUS_1854",
      desc:     "Status register of cache line 1854",
      swaccess: "rw",
      hwaccess: "hrw",
      hwext:    "true",
      hwqe:     "true", // enable `qe` latched signal of software write pulse
      hwre:     "true",
      fields: [
        {
          bits: "5+3:5", // 2 bits for status
          name: "CL_STATUS",
          desc: "Contain the current status of the corresponding cache line                [0]: valid, [1]: dirty, [2]: cmpt",
        }
      ]
    },
    { name:     "TAG_1854",
      desc:     "Tag Address stored in cache line 1854",
      swaccess: "rw",
      hwaccess: "hrw",
      hwext:    "true",
      hwqe:     "true", // enable `qe` latched signal of software write pulse
      hwre:     "true",
      fields: [
        { bits: "5-1:0",
          name: "CL_TAG",
          desc: "Tag Address"
        }
      ]
    },
    {
      name:     "STATUS_1855",
      desc:     "Status register of cache line 1855",
      swaccess: "rw",
      hwaccess: "hrw",
      hwext:    "true",
      hwqe:     "true", // enable `qe` latched signal of software write pulse
      hwre:     "true",
      fields: [
        {
          bits: "5+3:5", // 2 bits for status
          name: "CL_STATUS",
          desc: "Contain the current status of the corresponding cache line                [0]: valid, [1]: dirty, [2]: cmpt",
        }
      ]
    },
    { name:     "TAG_1855",
      desc:     "Tag Address stored in cache line 1855",
      swaccess: "rw",
      hwaccess: "hrw",
      hwext:    "true",
      hwqe:     "true", // enable `qe` latched signal of software write pulse
      hwre:     "true",
      fields: [
        { bits: "5-1:0",
          name: "CL_TAG",
          desc: "Tag Address"
        }
      ]
    },
    {
      name:     "STATUS_1856",
      desc:     "Status register of cache line 1856",
      swaccess: "rw",
      hwaccess: "hrw",
      hwext:    "true",
      hwqe:     "true", // enable `qe` latched signal of software write pulse
      hwre:     "true",
      fields: [
        {
          bits: "5+3:5", // 2 bits for status
          name: "CL_STATUS",
          desc: "Contain the current status of the corresponding cache line                [0]: valid, [1]: dirty, [2]: cmpt",
        }
      ]
    },
    { name:     "TAG_1856",
      desc:     "Tag Address stored in cache line 1856",
      swaccess: "rw",
      hwaccess: "hrw",
      hwext:    "true",
      hwqe:     "true", // enable `qe` latched signal of software write pulse
      hwre:     "true",
      fields: [
        { bits: "5-1:0",
          name: "CL_TAG",
          desc: "Tag Address"
        }
      ]
    },
    {
      name:     "STATUS_1857",
      desc:     "Status register of cache line 1857",
      swaccess: "rw",
      hwaccess: "hrw",
      hwext:    "true",
      hwqe:     "true", // enable `qe` latched signal of software write pulse
      hwre:     "true",
      fields: [
        {
          bits: "5+3:5", // 2 bits for status
          name: "CL_STATUS",
          desc: "Contain the current status of the corresponding cache line                [0]: valid, [1]: dirty, [2]: cmpt",
        }
      ]
    },
    { name:     "TAG_1857",
      desc:     "Tag Address stored in cache line 1857",
      swaccess: "rw",
      hwaccess: "hrw",
      hwext:    "true",
      hwqe:     "true", // enable `qe` latched signal of software write pulse
      hwre:     "true",
      fields: [
        { bits: "5-1:0",
          name: "CL_TAG",
          desc: "Tag Address"
        }
      ]
    },
    {
      name:     "STATUS_1858",
      desc:     "Status register of cache line 1858",
      swaccess: "rw",
      hwaccess: "hrw",
      hwext:    "true",
      hwqe:     "true", // enable `qe` latched signal of software write pulse
      hwre:     "true",
      fields: [
        {
          bits: "5+3:5", // 2 bits for status
          name: "CL_STATUS",
          desc: "Contain the current status of the corresponding cache line                [0]: valid, [1]: dirty, [2]: cmpt",
        }
      ]
    },
    { name:     "TAG_1858",
      desc:     "Tag Address stored in cache line 1858",
      swaccess: "rw",
      hwaccess: "hrw",
      hwext:    "true",
      hwqe:     "true", // enable `qe` latched signal of software write pulse
      hwre:     "true",
      fields: [
        { bits: "5-1:0",
          name: "CL_TAG",
          desc: "Tag Address"
        }
      ]
    },
    {
      name:     "STATUS_1859",
      desc:     "Status register of cache line 1859",
      swaccess: "rw",
      hwaccess: "hrw",
      hwext:    "true",
      hwqe:     "true", // enable `qe` latched signal of software write pulse
      hwre:     "true",
      fields: [
        {
          bits: "5+3:5", // 2 bits for status
          name: "CL_STATUS",
          desc: "Contain the current status of the corresponding cache line                [0]: valid, [1]: dirty, [2]: cmpt",
        }
      ]
    },
    { name:     "TAG_1859",
      desc:     "Tag Address stored in cache line 1859",
      swaccess: "rw",
      hwaccess: "hrw",
      hwext:    "true",
      hwqe:     "true", // enable `qe` latched signal of software write pulse
      hwre:     "true",
      fields: [
        { bits: "5-1:0",
          name: "CL_TAG",
          desc: "Tag Address"
        }
      ]
    },
    {
      name:     "STATUS_1860",
      desc:     "Status register of cache line 1860",
      swaccess: "rw",
      hwaccess: "hrw",
      hwext:    "true",
      hwqe:     "true", // enable `qe` latched signal of software write pulse
      hwre:     "true",
      fields: [
        {
          bits: "5+3:5", // 2 bits for status
          name: "CL_STATUS",
          desc: "Contain the current status of the corresponding cache line                [0]: valid, [1]: dirty, [2]: cmpt",
        }
      ]
    },
    { name:     "TAG_1860",
      desc:     "Tag Address stored in cache line 1860",
      swaccess: "rw",
      hwaccess: "hrw",
      hwext:    "true",
      hwqe:     "true", // enable `qe` latched signal of software write pulse
      hwre:     "true",
      fields: [
        { bits: "5-1:0",
          name: "CL_TAG",
          desc: "Tag Address"
        }
      ]
    },
    {
      name:     "STATUS_1861",
      desc:     "Status register of cache line 1861",
      swaccess: "rw",
      hwaccess: "hrw",
      hwext:    "true",
      hwqe:     "true", // enable `qe` latched signal of software write pulse
      hwre:     "true",
      fields: [
        {
          bits: "5+3:5", // 2 bits for status
          name: "CL_STATUS",
          desc: "Contain the current status of the corresponding cache line                [0]: valid, [1]: dirty, [2]: cmpt",
        }
      ]
    },
    { name:     "TAG_1861",
      desc:     "Tag Address stored in cache line 1861",
      swaccess: "rw",
      hwaccess: "hrw",
      hwext:    "true",
      hwqe:     "true", // enable `qe` latched signal of software write pulse
      hwre:     "true",
      fields: [
        { bits: "5-1:0",
          name: "CL_TAG",
          desc: "Tag Address"
        }
      ]
    },
    {
      name:     "STATUS_1862",
      desc:     "Status register of cache line 1862",
      swaccess: "rw",
      hwaccess: "hrw",
      hwext:    "true",
      hwqe:     "true", // enable `qe` latched signal of software write pulse
      hwre:     "true",
      fields: [
        {
          bits: "5+3:5", // 2 bits for status
          name: "CL_STATUS",
          desc: "Contain the current status of the corresponding cache line                [0]: valid, [1]: dirty, [2]: cmpt",
        }
      ]
    },
    { name:     "TAG_1862",
      desc:     "Tag Address stored in cache line 1862",
      swaccess: "rw",
      hwaccess: "hrw",
      hwext:    "true",
      hwqe:     "true", // enable `qe` latched signal of software write pulse
      hwre:     "true",
      fields: [
        { bits: "5-1:0",
          name: "CL_TAG",
          desc: "Tag Address"
        }
      ]
    },
    {
      name:     "STATUS_1863",
      desc:     "Status register of cache line 1863",
      swaccess: "rw",
      hwaccess: "hrw",
      hwext:    "true",
      hwqe:     "true", // enable `qe` latched signal of software write pulse
      hwre:     "true",
      fields: [
        {
          bits: "5+3:5", // 2 bits for status
          name: "CL_STATUS",
          desc: "Contain the current status of the corresponding cache line                [0]: valid, [1]: dirty, [2]: cmpt",
        }
      ]
    },
    { name:     "TAG_1863",
      desc:     "Tag Address stored in cache line 1863",
      swaccess: "rw",
      hwaccess: "hrw",
      hwext:    "true",
      hwqe:     "true", // enable `qe` latched signal of software write pulse
      hwre:     "true",
      fields: [
        { bits: "5-1:0",
          name: "CL_TAG",
          desc: "Tag Address"
        }
      ]
    },
    {
      name:     "STATUS_1864",
      desc:     "Status register of cache line 1864",
      swaccess: "rw",
      hwaccess: "hrw",
      hwext:    "true",
      hwqe:     "true", // enable `qe` latched signal of software write pulse
      hwre:     "true",
      fields: [
        {
          bits: "5+3:5", // 2 bits for status
          name: "CL_STATUS",
          desc: "Contain the current status of the corresponding cache line                [0]: valid, [1]: dirty, [2]: cmpt",
        }
      ]
    },
    { name:     "TAG_1864",
      desc:     "Tag Address stored in cache line 1864",
      swaccess: "rw",
      hwaccess: "hrw",
      hwext:    "true",
      hwqe:     "true", // enable `qe` latched signal of software write pulse
      hwre:     "true",
      fields: [
        { bits: "5-1:0",
          name: "CL_TAG",
          desc: "Tag Address"
        }
      ]
    },
    {
      name:     "STATUS_1865",
      desc:     "Status register of cache line 1865",
      swaccess: "rw",
      hwaccess: "hrw",
      hwext:    "true",
      hwqe:     "true", // enable `qe` latched signal of software write pulse
      hwre:     "true",
      fields: [
        {
          bits: "5+3:5", // 2 bits for status
          name: "CL_STATUS",
          desc: "Contain the current status of the corresponding cache line                [0]: valid, [1]: dirty, [2]: cmpt",
        }
      ]
    },
    { name:     "TAG_1865",
      desc:     "Tag Address stored in cache line 1865",
      swaccess: "rw",
      hwaccess: "hrw",
      hwext:    "true",
      hwqe:     "true", // enable `qe` latched signal of software write pulse
      hwre:     "true",
      fields: [
        { bits: "5-1:0",
          name: "CL_TAG",
          desc: "Tag Address"
        }
      ]
    },
    {
      name:     "STATUS_1866",
      desc:     "Status register of cache line 1866",
      swaccess: "rw",
      hwaccess: "hrw",
      hwext:    "true",
      hwqe:     "true", // enable `qe` latched signal of software write pulse
      hwre:     "true",
      fields: [
        {
          bits: "5+3:5", // 2 bits for status
          name: "CL_STATUS",
          desc: "Contain the current status of the corresponding cache line                [0]: valid, [1]: dirty, [2]: cmpt",
        }
      ]
    },
    { name:     "TAG_1866",
      desc:     "Tag Address stored in cache line 1866",
      swaccess: "rw",
      hwaccess: "hrw",
      hwext:    "true",
      hwqe:     "true", // enable `qe` latched signal of software write pulse
      hwre:     "true",
      fields: [
        { bits: "5-1:0",
          name: "CL_TAG",
          desc: "Tag Address"
        }
      ]
    },
    {
      name:     "STATUS_1867",
      desc:     "Status register of cache line 1867",
      swaccess: "rw",
      hwaccess: "hrw",
      hwext:    "true",
      hwqe:     "true", // enable `qe` latched signal of software write pulse
      hwre:     "true",
      fields: [
        {
          bits: "5+3:5", // 2 bits for status
          name: "CL_STATUS",
          desc: "Contain the current status of the corresponding cache line                [0]: valid, [1]: dirty, [2]: cmpt",
        }
      ]
    },
    { name:     "TAG_1867",
      desc:     "Tag Address stored in cache line 1867",
      swaccess: "rw",
      hwaccess: "hrw",
      hwext:    "true",
      hwqe:     "true", // enable `qe` latched signal of software write pulse
      hwre:     "true",
      fields: [
        { bits: "5-1:0",
          name: "CL_TAG",
          desc: "Tag Address"
        }
      ]
    },
    {
      name:     "STATUS_1868",
      desc:     "Status register of cache line 1868",
      swaccess: "rw",
      hwaccess: "hrw",
      hwext:    "true",
      hwqe:     "true", // enable `qe` latched signal of software write pulse
      hwre:     "true",
      fields: [
        {
          bits: "5+3:5", // 2 bits for status
          name: "CL_STATUS",
          desc: "Contain the current status of the corresponding cache line                [0]: valid, [1]: dirty, [2]: cmpt",
        }
      ]
    },
    { name:     "TAG_1868",
      desc:     "Tag Address stored in cache line 1868",
      swaccess: "rw",
      hwaccess: "hrw",
      hwext:    "true",
      hwqe:     "true", // enable `qe` latched signal of software write pulse
      hwre:     "true",
      fields: [
        { bits: "5-1:0",
          name: "CL_TAG",
          desc: "Tag Address"
        }
      ]
    },
    {
      name:     "STATUS_1869",
      desc:     "Status register of cache line 1869",
      swaccess: "rw",
      hwaccess: "hrw",
      hwext:    "true",
      hwqe:     "true", // enable `qe` latched signal of software write pulse
      hwre:     "true",
      fields: [
        {
          bits: "5+3:5", // 2 bits for status
          name: "CL_STATUS",
          desc: "Contain the current status of the corresponding cache line                [0]: valid, [1]: dirty, [2]: cmpt",
        }
      ]
    },
    { name:     "TAG_1869",
      desc:     "Tag Address stored in cache line 1869",
      swaccess: "rw",
      hwaccess: "hrw",
      hwext:    "true",
      hwqe:     "true", // enable `qe` latched signal of software write pulse
      hwre:     "true",
      fields: [
        { bits: "5-1:0",
          name: "CL_TAG",
          desc: "Tag Address"
        }
      ]
    },
    {
      name:     "STATUS_1870",
      desc:     "Status register of cache line 1870",
      swaccess: "rw",
      hwaccess: "hrw",
      hwext:    "true",
      hwqe:     "true", // enable `qe` latched signal of software write pulse
      hwre:     "true",
      fields: [
        {
          bits: "5+3:5", // 2 bits for status
          name: "CL_STATUS",
          desc: "Contain the current status of the corresponding cache line                [0]: valid, [1]: dirty, [2]: cmpt",
        }
      ]
    },
    { name:     "TAG_1870",
      desc:     "Tag Address stored in cache line 1870",
      swaccess: "rw",
      hwaccess: "hrw",
      hwext:    "true",
      hwqe:     "true", // enable `qe` latched signal of software write pulse
      hwre:     "true",
      fields: [
        { bits: "5-1:0",
          name: "CL_TAG",
          desc: "Tag Address"
        }
      ]
    },
    {
      name:     "STATUS_1871",
      desc:     "Status register of cache line 1871",
      swaccess: "rw",
      hwaccess: "hrw",
      hwext:    "true",
      hwqe:     "true", // enable `qe` latched signal of software write pulse
      hwre:     "true",
      fields: [
        {
          bits: "5+3:5", // 2 bits for status
          name: "CL_STATUS",
          desc: "Contain the current status of the corresponding cache line                [0]: valid, [1]: dirty, [2]: cmpt",
        }
      ]
    },
    { name:     "TAG_1871",
      desc:     "Tag Address stored in cache line 1871",
      swaccess: "rw",
      hwaccess: "hrw",
      hwext:    "true",
      hwqe:     "true", // enable `qe` latched signal of software write pulse
      hwre:     "true",
      fields: [
        { bits: "5-1:0",
          name: "CL_TAG",
          desc: "Tag Address"
        }
      ]
    },
    {
      name:     "STATUS_1872",
      desc:     "Status register of cache line 1872",
      swaccess: "rw",
      hwaccess: "hrw",
      hwext:    "true",
      hwqe:     "true", // enable `qe` latched signal of software write pulse
      hwre:     "true",
      fields: [
        {
          bits: "5+3:5", // 2 bits for status
          name: "CL_STATUS",
          desc: "Contain the current status of the corresponding cache line                [0]: valid, [1]: dirty, [2]: cmpt",
        }
      ]
    },
    { name:     "TAG_1872",
      desc:     "Tag Address stored in cache line 1872",
      swaccess: "rw",
      hwaccess: "hrw",
      hwext:    "true",
      hwqe:     "true", // enable `qe` latched signal of software write pulse
      hwre:     "true",
      fields: [
        { bits: "5-1:0",
          name: "CL_TAG",
          desc: "Tag Address"
        }
      ]
    },
    {
      name:     "STATUS_1873",
      desc:     "Status register of cache line 1873",
      swaccess: "rw",
      hwaccess: "hrw",
      hwext:    "true",
      hwqe:     "true", // enable `qe` latched signal of software write pulse
      hwre:     "true",
      fields: [
        {
          bits: "5+3:5", // 2 bits for status
          name: "CL_STATUS",
          desc: "Contain the current status of the corresponding cache line                [0]: valid, [1]: dirty, [2]: cmpt",
        }
      ]
    },
    { name:     "TAG_1873",
      desc:     "Tag Address stored in cache line 1873",
      swaccess: "rw",
      hwaccess: "hrw",
      hwext:    "true",
      hwqe:     "true", // enable `qe` latched signal of software write pulse
      hwre:     "true",
      fields: [
        { bits: "5-1:0",
          name: "CL_TAG",
          desc: "Tag Address"
        }
      ]
    },
    {
      name:     "STATUS_1874",
      desc:     "Status register of cache line 1874",
      swaccess: "rw",
      hwaccess: "hrw",
      hwext:    "true",
      hwqe:     "true", // enable `qe` latched signal of software write pulse
      hwre:     "true",
      fields: [
        {
          bits: "5+3:5", // 2 bits for status
          name: "CL_STATUS",
          desc: "Contain the current status of the corresponding cache line                [0]: valid, [1]: dirty, [2]: cmpt",
        }
      ]
    },
    { name:     "TAG_1874",
      desc:     "Tag Address stored in cache line 1874",
      swaccess: "rw",
      hwaccess: "hrw",
      hwext:    "true",
      hwqe:     "true", // enable `qe` latched signal of software write pulse
      hwre:     "true",
      fields: [
        { bits: "5-1:0",
          name: "CL_TAG",
          desc: "Tag Address"
        }
      ]
    },
    {
      name:     "STATUS_1875",
      desc:     "Status register of cache line 1875",
      swaccess: "rw",
      hwaccess: "hrw",
      hwext:    "true",
      hwqe:     "true", // enable `qe` latched signal of software write pulse
      hwre:     "true",
      fields: [
        {
          bits: "5+3:5", // 2 bits for status
          name: "CL_STATUS",
          desc: "Contain the current status of the corresponding cache line                [0]: valid, [1]: dirty, [2]: cmpt",
        }
      ]
    },
    { name:     "TAG_1875",
      desc:     "Tag Address stored in cache line 1875",
      swaccess: "rw",
      hwaccess: "hrw",
      hwext:    "true",
      hwqe:     "true", // enable `qe` latched signal of software write pulse
      hwre:     "true",
      fields: [
        { bits: "5-1:0",
          name: "CL_TAG",
          desc: "Tag Address"
        }
      ]
    },
    {
      name:     "STATUS_1876",
      desc:     "Status register of cache line 1876",
      swaccess: "rw",
      hwaccess: "hrw",
      hwext:    "true",
      hwqe:     "true", // enable `qe` latched signal of software write pulse
      hwre:     "true",
      fields: [
        {
          bits: "5+3:5", // 2 bits for status
          name: "CL_STATUS",
          desc: "Contain the current status of the corresponding cache line                [0]: valid, [1]: dirty, [2]: cmpt",
        }
      ]
    },
    { name:     "TAG_1876",
      desc:     "Tag Address stored in cache line 1876",
      swaccess: "rw",
      hwaccess: "hrw",
      hwext:    "true",
      hwqe:     "true", // enable `qe` latched signal of software write pulse
      hwre:     "true",
      fields: [
        { bits: "5-1:0",
          name: "CL_TAG",
          desc: "Tag Address"
        }
      ]
    },
    {
      name:     "STATUS_1877",
      desc:     "Status register of cache line 1877",
      swaccess: "rw",
      hwaccess: "hrw",
      hwext:    "true",
      hwqe:     "true", // enable `qe` latched signal of software write pulse
      hwre:     "true",
      fields: [
        {
          bits: "5+3:5", // 2 bits for status
          name: "CL_STATUS",
          desc: "Contain the current status of the corresponding cache line                [0]: valid, [1]: dirty, [2]: cmpt",
        }
      ]
    },
    { name:     "TAG_1877",
      desc:     "Tag Address stored in cache line 1877",
      swaccess: "rw",
      hwaccess: "hrw",
      hwext:    "true",
      hwqe:     "true", // enable `qe` latched signal of software write pulse
      hwre:     "true",
      fields: [
        { bits: "5-1:0",
          name: "CL_TAG",
          desc: "Tag Address"
        }
      ]
    },
    {
      name:     "STATUS_1878",
      desc:     "Status register of cache line 1878",
      swaccess: "rw",
      hwaccess: "hrw",
      hwext:    "true",
      hwqe:     "true", // enable `qe` latched signal of software write pulse
      hwre:     "true",
      fields: [
        {
          bits: "5+3:5", // 2 bits for status
          name: "CL_STATUS",
          desc: "Contain the current status of the corresponding cache line                [0]: valid, [1]: dirty, [2]: cmpt",
        }
      ]
    },
    { name:     "TAG_1878",
      desc:     "Tag Address stored in cache line 1878",
      swaccess: "rw",
      hwaccess: "hrw",
      hwext:    "true",
      hwqe:     "true", // enable `qe` latched signal of software write pulse
      hwre:     "true",
      fields: [
        { bits: "5-1:0",
          name: "CL_TAG",
          desc: "Tag Address"
        }
      ]
    },
    {
      name:     "STATUS_1879",
      desc:     "Status register of cache line 1879",
      swaccess: "rw",
      hwaccess: "hrw",
      hwext:    "true",
      hwqe:     "true", // enable `qe` latched signal of software write pulse
      hwre:     "true",
      fields: [
        {
          bits: "5+3:5", // 2 bits for status
          name: "CL_STATUS",
          desc: "Contain the current status of the corresponding cache line                [0]: valid, [1]: dirty, [2]: cmpt",
        }
      ]
    },
    { name:     "TAG_1879",
      desc:     "Tag Address stored in cache line 1879",
      swaccess: "rw",
      hwaccess: "hrw",
      hwext:    "true",
      hwqe:     "true", // enable `qe` latched signal of software write pulse
      hwre:     "true",
      fields: [
        { bits: "5-1:0",
          name: "CL_TAG",
          desc: "Tag Address"
        }
      ]
    },
    {
      name:     "STATUS_1880",
      desc:     "Status register of cache line 1880",
      swaccess: "rw",
      hwaccess: "hrw",
      hwext:    "true",
      hwqe:     "true", // enable `qe` latched signal of software write pulse
      hwre:     "true",
      fields: [
        {
          bits: "5+3:5", // 2 bits for status
          name: "CL_STATUS",
          desc: "Contain the current status of the corresponding cache line                [0]: valid, [1]: dirty, [2]: cmpt",
        }
      ]
    },
    { name:     "TAG_1880",
      desc:     "Tag Address stored in cache line 1880",
      swaccess: "rw",
      hwaccess: "hrw",
      hwext:    "true",
      hwqe:     "true", // enable `qe` latched signal of software write pulse
      hwre:     "true",
      fields: [
        { bits: "5-1:0",
          name: "CL_TAG",
          desc: "Tag Address"
        }
      ]
    },
    {
      name:     "STATUS_1881",
      desc:     "Status register of cache line 1881",
      swaccess: "rw",
      hwaccess: "hrw",
      hwext:    "true",
      hwqe:     "true", // enable `qe` latched signal of software write pulse
      hwre:     "true",
      fields: [
        {
          bits: "5+3:5", // 2 bits for status
          name: "CL_STATUS",
          desc: "Contain the current status of the corresponding cache line                [0]: valid, [1]: dirty, [2]: cmpt",
        }
      ]
    },
    { name:     "TAG_1881",
      desc:     "Tag Address stored in cache line 1881",
      swaccess: "rw",
      hwaccess: "hrw",
      hwext:    "true",
      hwqe:     "true", // enable `qe` latched signal of software write pulse
      hwre:     "true",
      fields: [
        { bits: "5-1:0",
          name: "CL_TAG",
          desc: "Tag Address"
        }
      ]
    },
    {
      name:     "STATUS_1882",
      desc:     "Status register of cache line 1882",
      swaccess: "rw",
      hwaccess: "hrw",
      hwext:    "true",
      hwqe:     "true", // enable `qe` latched signal of software write pulse
      hwre:     "true",
      fields: [
        {
          bits: "5+3:5", // 2 bits for status
          name: "CL_STATUS",
          desc: "Contain the current status of the corresponding cache line                [0]: valid, [1]: dirty, [2]: cmpt",
        }
      ]
    },
    { name:     "TAG_1882",
      desc:     "Tag Address stored in cache line 1882",
      swaccess: "rw",
      hwaccess: "hrw",
      hwext:    "true",
      hwqe:     "true", // enable `qe` latched signal of software write pulse
      hwre:     "true",
      fields: [
        { bits: "5-1:0",
          name: "CL_TAG",
          desc: "Tag Address"
        }
      ]
    },
    {
      name:     "STATUS_1883",
      desc:     "Status register of cache line 1883",
      swaccess: "rw",
      hwaccess: "hrw",
      hwext:    "true",
      hwqe:     "true", // enable `qe` latched signal of software write pulse
      hwre:     "true",
      fields: [
        {
          bits: "5+3:5", // 2 bits for status
          name: "CL_STATUS",
          desc: "Contain the current status of the corresponding cache line                [0]: valid, [1]: dirty, [2]: cmpt",
        }
      ]
    },
    { name:     "TAG_1883",
      desc:     "Tag Address stored in cache line 1883",
      swaccess: "rw",
      hwaccess: "hrw",
      hwext:    "true",
      hwqe:     "true", // enable `qe` latched signal of software write pulse
      hwre:     "true",
      fields: [
        { bits: "5-1:0",
          name: "CL_TAG",
          desc: "Tag Address"
        }
      ]
    },
    {
      name:     "STATUS_1884",
      desc:     "Status register of cache line 1884",
      swaccess: "rw",
      hwaccess: "hrw",
      hwext:    "true",
      hwqe:     "true", // enable `qe` latched signal of software write pulse
      hwre:     "true",
      fields: [
        {
          bits: "5+3:5", // 2 bits for status
          name: "CL_STATUS",
          desc: "Contain the current status of the corresponding cache line                [0]: valid, [1]: dirty, [2]: cmpt",
        }
      ]
    },
    { name:     "TAG_1884",
      desc:     "Tag Address stored in cache line 1884",
      swaccess: "rw",
      hwaccess: "hrw",
      hwext:    "true",
      hwqe:     "true", // enable `qe` latched signal of software write pulse
      hwre:     "true",
      fields: [
        { bits: "5-1:0",
          name: "CL_TAG",
          desc: "Tag Address"
        }
      ]
    },
    {
      name:     "STATUS_1885",
      desc:     "Status register of cache line 1885",
      swaccess: "rw",
      hwaccess: "hrw",
      hwext:    "true",
      hwqe:     "true", // enable `qe` latched signal of software write pulse
      hwre:     "true",
      fields: [
        {
          bits: "5+3:5", // 2 bits for status
          name: "CL_STATUS",
          desc: "Contain the current status of the corresponding cache line                [0]: valid, [1]: dirty, [2]: cmpt",
        }
      ]
    },
    { name:     "TAG_1885",
      desc:     "Tag Address stored in cache line 1885",
      swaccess: "rw",
      hwaccess: "hrw",
      hwext:    "true",
      hwqe:     "true", // enable `qe` latched signal of software write pulse
      hwre:     "true",
      fields: [
        { bits: "5-1:0",
          name: "CL_TAG",
          desc: "Tag Address"
        }
      ]
    },
    {
      name:     "STATUS_1886",
      desc:     "Status register of cache line 1886",
      swaccess: "rw",
      hwaccess: "hrw",
      hwext:    "true",
      hwqe:     "true", // enable `qe` latched signal of software write pulse
      hwre:     "true",
      fields: [
        {
          bits: "5+3:5", // 2 bits for status
          name: "CL_STATUS",
          desc: "Contain the current status of the corresponding cache line                [0]: valid, [1]: dirty, [2]: cmpt",
        }
      ]
    },
    { name:     "TAG_1886",
      desc:     "Tag Address stored in cache line 1886",
      swaccess: "rw",
      hwaccess: "hrw",
      hwext:    "true",
      hwqe:     "true", // enable `qe` latched signal of software write pulse
      hwre:     "true",
      fields: [
        { bits: "5-1:0",
          name: "CL_TAG",
          desc: "Tag Address"
        }
      ]
    },
    {
      name:     "STATUS_1887",
      desc:     "Status register of cache line 1887",
      swaccess: "rw",
      hwaccess: "hrw",
      hwext:    "true",
      hwqe:     "true", // enable `qe` latched signal of software write pulse
      hwre:     "true",
      fields: [
        {
          bits: "5+3:5", // 2 bits for status
          name: "CL_STATUS",
          desc: "Contain the current status of the corresponding cache line                [0]: valid, [1]: dirty, [2]: cmpt",
        }
      ]
    },
    { name:     "TAG_1887",
      desc:     "Tag Address stored in cache line 1887",
      swaccess: "rw",
      hwaccess: "hrw",
      hwext:    "true",
      hwqe:     "true", // enable `qe` latched signal of software write pulse
      hwre:     "true",
      fields: [
        { bits: "5-1:0",
          name: "CL_TAG",
          desc: "Tag Address"
        }
      ]
    },
    {
      name:     "STATUS_1888",
      desc:     "Status register of cache line 1888",
      swaccess: "rw",
      hwaccess: "hrw",
      hwext:    "true",
      hwqe:     "true", // enable `qe` latched signal of software write pulse
      hwre:     "true",
      fields: [
        {
          bits: "5+3:5", // 2 bits for status
          name: "CL_STATUS",
          desc: "Contain the current status of the corresponding cache line                [0]: valid, [1]: dirty, [2]: cmpt",
        }
      ]
    },
    { name:     "TAG_1888",
      desc:     "Tag Address stored in cache line 1888",
      swaccess: "rw",
      hwaccess: "hrw",
      hwext:    "true",
      hwqe:     "true", // enable `qe` latched signal of software write pulse
      hwre:     "true",
      fields: [
        { bits: "5-1:0",
          name: "CL_TAG",
          desc: "Tag Address"
        }
      ]
    },
    {
      name:     "STATUS_1889",
      desc:     "Status register of cache line 1889",
      swaccess: "rw",
      hwaccess: "hrw",
      hwext:    "true",
      hwqe:     "true", // enable `qe` latched signal of software write pulse
      hwre:     "true",
      fields: [
        {
          bits: "5+3:5", // 2 bits for status
          name: "CL_STATUS",
          desc: "Contain the current status of the corresponding cache line                [0]: valid, [1]: dirty, [2]: cmpt",
        }
      ]
    },
    { name:     "TAG_1889",
      desc:     "Tag Address stored in cache line 1889",
      swaccess: "rw",
      hwaccess: "hrw",
      hwext:    "true",
      hwqe:     "true", // enable `qe` latched signal of software write pulse
      hwre:     "true",
      fields: [
        { bits: "5-1:0",
          name: "CL_TAG",
          desc: "Tag Address"
        }
      ]
    },
    {
      name:     "STATUS_1890",
      desc:     "Status register of cache line 1890",
      swaccess: "rw",
      hwaccess: "hrw",
      hwext:    "true",
      hwqe:     "true", // enable `qe` latched signal of software write pulse
      hwre:     "true",
      fields: [
        {
          bits: "5+3:5", // 2 bits for status
          name: "CL_STATUS",
          desc: "Contain the current status of the corresponding cache line                [0]: valid, [1]: dirty, [2]: cmpt",
        }
      ]
    },
    { name:     "TAG_1890",
      desc:     "Tag Address stored in cache line 1890",
      swaccess: "rw",
      hwaccess: "hrw",
      hwext:    "true",
      hwqe:     "true", // enable `qe` latched signal of software write pulse
      hwre:     "true",
      fields: [
        { bits: "5-1:0",
          name: "CL_TAG",
          desc: "Tag Address"
        }
      ]
    },
    {
      name:     "STATUS_1891",
      desc:     "Status register of cache line 1891",
      swaccess: "rw",
      hwaccess: "hrw",
      hwext:    "true",
      hwqe:     "true", // enable `qe` latched signal of software write pulse
      hwre:     "true",
      fields: [
        {
          bits: "5+3:5", // 2 bits for status
          name: "CL_STATUS",
          desc: "Contain the current status of the corresponding cache line                [0]: valid, [1]: dirty, [2]: cmpt",
        }
      ]
    },
    { name:     "TAG_1891",
      desc:     "Tag Address stored in cache line 1891",
      swaccess: "rw",
      hwaccess: "hrw",
      hwext:    "true",
      hwqe:     "true", // enable `qe` latched signal of software write pulse
      hwre:     "true",
      fields: [
        { bits: "5-1:0",
          name: "CL_TAG",
          desc: "Tag Address"
        }
      ]
    },
    {
      name:     "STATUS_1892",
      desc:     "Status register of cache line 1892",
      swaccess: "rw",
      hwaccess: "hrw",
      hwext:    "true",
      hwqe:     "true", // enable `qe` latched signal of software write pulse
      hwre:     "true",
      fields: [
        {
          bits: "5+3:5", // 2 bits for status
          name: "CL_STATUS",
          desc: "Contain the current status of the corresponding cache line                [0]: valid, [1]: dirty, [2]: cmpt",
        }
      ]
    },
    { name:     "TAG_1892",
      desc:     "Tag Address stored in cache line 1892",
      swaccess: "rw",
      hwaccess: "hrw",
      hwext:    "true",
      hwqe:     "true", // enable `qe` latched signal of software write pulse
      hwre:     "true",
      fields: [
        { bits: "5-1:0",
          name: "CL_TAG",
          desc: "Tag Address"
        }
      ]
    },
    {
      name:     "STATUS_1893",
      desc:     "Status register of cache line 1893",
      swaccess: "rw",
      hwaccess: "hrw",
      hwext:    "true",
      hwqe:     "true", // enable `qe` latched signal of software write pulse
      hwre:     "true",
      fields: [
        {
          bits: "5+3:5", // 2 bits for status
          name: "CL_STATUS",
          desc: "Contain the current status of the corresponding cache line                [0]: valid, [1]: dirty, [2]: cmpt",
        }
      ]
    },
    { name:     "TAG_1893",
      desc:     "Tag Address stored in cache line 1893",
      swaccess: "rw",
      hwaccess: "hrw",
      hwext:    "true",
      hwqe:     "true", // enable `qe` latched signal of software write pulse
      hwre:     "true",
      fields: [
        { bits: "5-1:0",
          name: "CL_TAG",
          desc: "Tag Address"
        }
      ]
    },
    {
      name:     "STATUS_1894",
      desc:     "Status register of cache line 1894",
      swaccess: "rw",
      hwaccess: "hrw",
      hwext:    "true",
      hwqe:     "true", // enable `qe` latched signal of software write pulse
      hwre:     "true",
      fields: [
        {
          bits: "5+3:5", // 2 bits for status
          name: "CL_STATUS",
          desc: "Contain the current status of the corresponding cache line                [0]: valid, [1]: dirty, [2]: cmpt",
        }
      ]
    },
    { name:     "TAG_1894",
      desc:     "Tag Address stored in cache line 1894",
      swaccess: "rw",
      hwaccess: "hrw",
      hwext:    "true",
      hwqe:     "true", // enable `qe` latched signal of software write pulse
      hwre:     "true",
      fields: [
        { bits: "5-1:0",
          name: "CL_TAG",
          desc: "Tag Address"
        }
      ]
    },
    {
      name:     "STATUS_1895",
      desc:     "Status register of cache line 1895",
      swaccess: "rw",
      hwaccess: "hrw",
      hwext:    "true",
      hwqe:     "true", // enable `qe` latched signal of software write pulse
      hwre:     "true",
      fields: [
        {
          bits: "5+3:5", // 2 bits for status
          name: "CL_STATUS",
          desc: "Contain the current status of the corresponding cache line                [0]: valid, [1]: dirty, [2]: cmpt",
        }
      ]
    },
    { name:     "TAG_1895",
      desc:     "Tag Address stored in cache line 1895",
      swaccess: "rw",
      hwaccess: "hrw",
      hwext:    "true",
      hwqe:     "true", // enable `qe` latched signal of software write pulse
      hwre:     "true",
      fields: [
        { bits: "5-1:0",
          name: "CL_TAG",
          desc: "Tag Address"
        }
      ]
    },
    {
      name:     "STATUS_1896",
      desc:     "Status register of cache line 1896",
      swaccess: "rw",
      hwaccess: "hrw",
      hwext:    "true",
      hwqe:     "true", // enable `qe` latched signal of software write pulse
      hwre:     "true",
      fields: [
        {
          bits: "5+3:5", // 2 bits for status
          name: "CL_STATUS",
          desc: "Contain the current status of the corresponding cache line                [0]: valid, [1]: dirty, [2]: cmpt",
        }
      ]
    },
    { name:     "TAG_1896",
      desc:     "Tag Address stored in cache line 1896",
      swaccess: "rw",
      hwaccess: "hrw",
      hwext:    "true",
      hwqe:     "true", // enable `qe` latched signal of software write pulse
      hwre:     "true",
      fields: [
        { bits: "5-1:0",
          name: "CL_TAG",
          desc: "Tag Address"
        }
      ]
    },
    {
      name:     "STATUS_1897",
      desc:     "Status register of cache line 1897",
      swaccess: "rw",
      hwaccess: "hrw",
      hwext:    "true",
      hwqe:     "true", // enable `qe` latched signal of software write pulse
      hwre:     "true",
      fields: [
        {
          bits: "5+3:5", // 2 bits for status
          name: "CL_STATUS",
          desc: "Contain the current status of the corresponding cache line                [0]: valid, [1]: dirty, [2]: cmpt",
        }
      ]
    },
    { name:     "TAG_1897",
      desc:     "Tag Address stored in cache line 1897",
      swaccess: "rw",
      hwaccess: "hrw",
      hwext:    "true",
      hwqe:     "true", // enable `qe` latched signal of software write pulse
      hwre:     "true",
      fields: [
        { bits: "5-1:0",
          name: "CL_TAG",
          desc: "Tag Address"
        }
      ]
    },
    {
      name:     "STATUS_1898",
      desc:     "Status register of cache line 1898",
      swaccess: "rw",
      hwaccess: "hrw",
      hwext:    "true",
      hwqe:     "true", // enable `qe` latched signal of software write pulse
      hwre:     "true",
      fields: [
        {
          bits: "5+3:5", // 2 bits for status
          name: "CL_STATUS",
          desc: "Contain the current status of the corresponding cache line                [0]: valid, [1]: dirty, [2]: cmpt",
        }
      ]
    },
    { name:     "TAG_1898",
      desc:     "Tag Address stored in cache line 1898",
      swaccess: "rw",
      hwaccess: "hrw",
      hwext:    "true",
      hwqe:     "true", // enable `qe` latched signal of software write pulse
      hwre:     "true",
      fields: [
        { bits: "5-1:0",
          name: "CL_TAG",
          desc: "Tag Address"
        }
      ]
    },
    {
      name:     "STATUS_1899",
      desc:     "Status register of cache line 1899",
      swaccess: "rw",
      hwaccess: "hrw",
      hwext:    "true",
      hwqe:     "true", // enable `qe` latched signal of software write pulse
      hwre:     "true",
      fields: [
        {
          bits: "5+3:5", // 2 bits for status
          name: "CL_STATUS",
          desc: "Contain the current status of the corresponding cache line                [0]: valid, [1]: dirty, [2]: cmpt",
        }
      ]
    },
    { name:     "TAG_1899",
      desc:     "Tag Address stored in cache line 1899",
      swaccess: "rw",
      hwaccess: "hrw",
      hwext:    "true",
      hwqe:     "true", // enable `qe` latched signal of software write pulse
      hwre:     "true",
      fields: [
        { bits: "5-1:0",
          name: "CL_TAG",
          desc: "Tag Address"
        }
      ]
    },
    {
      name:     "STATUS_1900",
      desc:     "Status register of cache line 1900",
      swaccess: "rw",
      hwaccess: "hrw",
      hwext:    "true",
      hwqe:     "true", // enable `qe` latched signal of software write pulse
      hwre:     "true",
      fields: [
        {
          bits: "5+3:5", // 2 bits for status
          name: "CL_STATUS",
          desc: "Contain the current status of the corresponding cache line                [0]: valid, [1]: dirty, [2]: cmpt",
        }
      ]
    },
    { name:     "TAG_1900",
      desc:     "Tag Address stored in cache line 1900",
      swaccess: "rw",
      hwaccess: "hrw",
      hwext:    "true",
      hwqe:     "true", // enable `qe` latched signal of software write pulse
      hwre:     "true",
      fields: [
        { bits: "5-1:0",
          name: "CL_TAG",
          desc: "Tag Address"
        }
      ]
    },
    {
      name:     "STATUS_1901",
      desc:     "Status register of cache line 1901",
      swaccess: "rw",
      hwaccess: "hrw",
      hwext:    "true",
      hwqe:     "true", // enable `qe` latched signal of software write pulse
      hwre:     "true",
      fields: [
        {
          bits: "5+3:5", // 2 bits for status
          name: "CL_STATUS",
          desc: "Contain the current status of the corresponding cache line                [0]: valid, [1]: dirty, [2]: cmpt",
        }
      ]
    },
    { name:     "TAG_1901",
      desc:     "Tag Address stored in cache line 1901",
      swaccess: "rw",
      hwaccess: "hrw",
      hwext:    "true",
      hwqe:     "true", // enable `qe` latched signal of software write pulse
      hwre:     "true",
      fields: [
        { bits: "5-1:0",
          name: "CL_TAG",
          desc: "Tag Address"
        }
      ]
    },
    {
      name:     "STATUS_1902",
      desc:     "Status register of cache line 1902",
      swaccess: "rw",
      hwaccess: "hrw",
      hwext:    "true",
      hwqe:     "true", // enable `qe` latched signal of software write pulse
      hwre:     "true",
      fields: [
        {
          bits: "5+3:5", // 2 bits for status
          name: "CL_STATUS",
          desc: "Contain the current status of the corresponding cache line                [0]: valid, [1]: dirty, [2]: cmpt",
        }
      ]
    },
    { name:     "TAG_1902",
      desc:     "Tag Address stored in cache line 1902",
      swaccess: "rw",
      hwaccess: "hrw",
      hwext:    "true",
      hwqe:     "true", // enable `qe` latched signal of software write pulse
      hwre:     "true",
      fields: [
        { bits: "5-1:0",
          name: "CL_TAG",
          desc: "Tag Address"
        }
      ]
    },
    {
      name:     "STATUS_1903",
      desc:     "Status register of cache line 1903",
      swaccess: "rw",
      hwaccess: "hrw",
      hwext:    "true",
      hwqe:     "true", // enable `qe` latched signal of software write pulse
      hwre:     "true",
      fields: [
        {
          bits: "5+3:5", // 2 bits for status
          name: "CL_STATUS",
          desc: "Contain the current status of the corresponding cache line                [0]: valid, [1]: dirty, [2]: cmpt",
        }
      ]
    },
    { name:     "TAG_1903",
      desc:     "Tag Address stored in cache line 1903",
      swaccess: "rw",
      hwaccess: "hrw",
      hwext:    "true",
      hwqe:     "true", // enable `qe` latched signal of software write pulse
      hwre:     "true",
      fields: [
        { bits: "5-1:0",
          name: "CL_TAG",
          desc: "Tag Address"
        }
      ]
    },
    {
      name:     "STATUS_1904",
      desc:     "Status register of cache line 1904",
      swaccess: "rw",
      hwaccess: "hrw",
      hwext:    "true",
      hwqe:     "true", // enable `qe` latched signal of software write pulse
      hwre:     "true",
      fields: [
        {
          bits: "5+3:5", // 2 bits for status
          name: "CL_STATUS",
          desc: "Contain the current status of the corresponding cache line                [0]: valid, [1]: dirty, [2]: cmpt",
        }
      ]
    },
    { name:     "TAG_1904",
      desc:     "Tag Address stored in cache line 1904",
      swaccess: "rw",
      hwaccess: "hrw",
      hwext:    "true",
      hwqe:     "true", // enable `qe` latched signal of software write pulse
      hwre:     "true",
      fields: [
        { bits: "5-1:0",
          name: "CL_TAG",
          desc: "Tag Address"
        }
      ]
    },
    {
      name:     "STATUS_1905",
      desc:     "Status register of cache line 1905",
      swaccess: "rw",
      hwaccess: "hrw",
      hwext:    "true",
      hwqe:     "true", // enable `qe` latched signal of software write pulse
      hwre:     "true",
      fields: [
        {
          bits: "5+3:5", // 2 bits for status
          name: "CL_STATUS",
          desc: "Contain the current status of the corresponding cache line                [0]: valid, [1]: dirty, [2]: cmpt",
        }
      ]
    },
    { name:     "TAG_1905",
      desc:     "Tag Address stored in cache line 1905",
      swaccess: "rw",
      hwaccess: "hrw",
      hwext:    "true",
      hwqe:     "true", // enable `qe` latched signal of software write pulse
      hwre:     "true",
      fields: [
        { bits: "5-1:0",
          name: "CL_TAG",
          desc: "Tag Address"
        }
      ]
    },
    {
      name:     "STATUS_1906",
      desc:     "Status register of cache line 1906",
      swaccess: "rw",
      hwaccess: "hrw",
      hwext:    "true",
      hwqe:     "true", // enable `qe` latched signal of software write pulse
      hwre:     "true",
      fields: [
        {
          bits: "5+3:5", // 2 bits for status
          name: "CL_STATUS",
          desc: "Contain the current status of the corresponding cache line                [0]: valid, [1]: dirty, [2]: cmpt",
        }
      ]
    },
    { name:     "TAG_1906",
      desc:     "Tag Address stored in cache line 1906",
      swaccess: "rw",
      hwaccess: "hrw",
      hwext:    "true",
      hwqe:     "true", // enable `qe` latched signal of software write pulse
      hwre:     "true",
      fields: [
        { bits: "5-1:0",
          name: "CL_TAG",
          desc: "Tag Address"
        }
      ]
    },
    {
      name:     "STATUS_1907",
      desc:     "Status register of cache line 1907",
      swaccess: "rw",
      hwaccess: "hrw",
      hwext:    "true",
      hwqe:     "true", // enable `qe` latched signal of software write pulse
      hwre:     "true",
      fields: [
        {
          bits: "5+3:5", // 2 bits for status
          name: "CL_STATUS",
          desc: "Contain the current status of the corresponding cache line                [0]: valid, [1]: dirty, [2]: cmpt",
        }
      ]
    },
    { name:     "TAG_1907",
      desc:     "Tag Address stored in cache line 1907",
      swaccess: "rw",
      hwaccess: "hrw",
      hwext:    "true",
      hwqe:     "true", // enable `qe` latched signal of software write pulse
      hwre:     "true",
      fields: [
        { bits: "5-1:0",
          name: "CL_TAG",
          desc: "Tag Address"
        }
      ]
    },
    {
      name:     "STATUS_1908",
      desc:     "Status register of cache line 1908",
      swaccess: "rw",
      hwaccess: "hrw",
      hwext:    "true",
      hwqe:     "true", // enable `qe` latched signal of software write pulse
      hwre:     "true",
      fields: [
        {
          bits: "5+3:5", // 2 bits for status
          name: "CL_STATUS",
          desc: "Contain the current status of the corresponding cache line                [0]: valid, [1]: dirty, [2]: cmpt",
        }
      ]
    },
    { name:     "TAG_1908",
      desc:     "Tag Address stored in cache line 1908",
      swaccess: "rw",
      hwaccess: "hrw",
      hwext:    "true",
      hwqe:     "true", // enable `qe` latched signal of software write pulse
      hwre:     "true",
      fields: [
        { bits: "5-1:0",
          name: "CL_TAG",
          desc: "Tag Address"
        }
      ]
    },
    {
      name:     "STATUS_1909",
      desc:     "Status register of cache line 1909",
      swaccess: "rw",
      hwaccess: "hrw",
      hwext:    "true",
      hwqe:     "true", // enable `qe` latched signal of software write pulse
      hwre:     "true",
      fields: [
        {
          bits: "5+3:5", // 2 bits for status
          name: "CL_STATUS",
          desc: "Contain the current status of the corresponding cache line                [0]: valid, [1]: dirty, [2]: cmpt",
        }
      ]
    },
    { name:     "TAG_1909",
      desc:     "Tag Address stored in cache line 1909",
      swaccess: "rw",
      hwaccess: "hrw",
      hwext:    "true",
      hwqe:     "true", // enable `qe` latched signal of software write pulse
      hwre:     "true",
      fields: [
        { bits: "5-1:0",
          name: "CL_TAG",
          desc: "Tag Address"
        }
      ]
    },
    {
      name:     "STATUS_1910",
      desc:     "Status register of cache line 1910",
      swaccess: "rw",
      hwaccess: "hrw",
      hwext:    "true",
      hwqe:     "true", // enable `qe` latched signal of software write pulse
      hwre:     "true",
      fields: [
        {
          bits: "5+3:5", // 2 bits for status
          name: "CL_STATUS",
          desc: "Contain the current status of the corresponding cache line                [0]: valid, [1]: dirty, [2]: cmpt",
        }
      ]
    },
    { name:     "TAG_1910",
      desc:     "Tag Address stored in cache line 1910",
      swaccess: "rw",
      hwaccess: "hrw",
      hwext:    "true",
      hwqe:     "true", // enable `qe` latched signal of software write pulse
      hwre:     "true",
      fields: [
        { bits: "5-1:0",
          name: "CL_TAG",
          desc: "Tag Address"
        }
      ]
    },
    {
      name:     "STATUS_1911",
      desc:     "Status register of cache line 1911",
      swaccess: "rw",
      hwaccess: "hrw",
      hwext:    "true",
      hwqe:     "true", // enable `qe` latched signal of software write pulse
      hwre:     "true",
      fields: [
        {
          bits: "5+3:5", // 2 bits for status
          name: "CL_STATUS",
          desc: "Contain the current status of the corresponding cache line                [0]: valid, [1]: dirty, [2]: cmpt",
        }
      ]
    },
    { name:     "TAG_1911",
      desc:     "Tag Address stored in cache line 1911",
      swaccess: "rw",
      hwaccess: "hrw",
      hwext:    "true",
      hwqe:     "true", // enable `qe` latched signal of software write pulse
      hwre:     "true",
      fields: [
        { bits: "5-1:0",
          name: "CL_TAG",
          desc: "Tag Address"
        }
      ]
    },
    {
      name:     "STATUS_1912",
      desc:     "Status register of cache line 1912",
      swaccess: "rw",
      hwaccess: "hrw",
      hwext:    "true",
      hwqe:     "true", // enable `qe` latched signal of software write pulse
      hwre:     "true",
      fields: [
        {
          bits: "5+3:5", // 2 bits for status
          name: "CL_STATUS",
          desc: "Contain the current status of the corresponding cache line                [0]: valid, [1]: dirty, [2]: cmpt",
        }
      ]
    },
    { name:     "TAG_1912",
      desc:     "Tag Address stored in cache line 1912",
      swaccess: "rw",
      hwaccess: "hrw",
      hwext:    "true",
      hwqe:     "true", // enable `qe` latched signal of software write pulse
      hwre:     "true",
      fields: [
        { bits: "5-1:0",
          name: "CL_TAG",
          desc: "Tag Address"
        }
      ]
    },
    {
      name:     "STATUS_1913",
      desc:     "Status register of cache line 1913",
      swaccess: "rw",
      hwaccess: "hrw",
      hwext:    "true",
      hwqe:     "true", // enable `qe` latched signal of software write pulse
      hwre:     "true",
      fields: [
        {
          bits: "5+3:5", // 2 bits for status
          name: "CL_STATUS",
          desc: "Contain the current status of the corresponding cache line                [0]: valid, [1]: dirty, [2]: cmpt",
        }
      ]
    },
    { name:     "TAG_1913",
      desc:     "Tag Address stored in cache line 1913",
      swaccess: "rw",
      hwaccess: "hrw",
      hwext:    "true",
      hwqe:     "true", // enable `qe` latched signal of software write pulse
      hwre:     "true",
      fields: [
        { bits: "5-1:0",
          name: "CL_TAG",
          desc: "Tag Address"
        }
      ]
    },
    {
      name:     "STATUS_1914",
      desc:     "Status register of cache line 1914",
      swaccess: "rw",
      hwaccess: "hrw",
      hwext:    "true",
      hwqe:     "true", // enable `qe` latched signal of software write pulse
      hwre:     "true",
      fields: [
        {
          bits: "5+3:5", // 2 bits for status
          name: "CL_STATUS",
          desc: "Contain the current status of the corresponding cache line                [0]: valid, [1]: dirty, [2]: cmpt",
        }
      ]
    },
    { name:     "TAG_1914",
      desc:     "Tag Address stored in cache line 1914",
      swaccess: "rw",
      hwaccess: "hrw",
      hwext:    "true",
      hwqe:     "true", // enable `qe` latched signal of software write pulse
      hwre:     "true",
      fields: [
        { bits: "5-1:0",
          name: "CL_TAG",
          desc: "Tag Address"
        }
      ]
    },
    {
      name:     "STATUS_1915",
      desc:     "Status register of cache line 1915",
      swaccess: "rw",
      hwaccess: "hrw",
      hwext:    "true",
      hwqe:     "true", // enable `qe` latched signal of software write pulse
      hwre:     "true",
      fields: [
        {
          bits: "5+3:5", // 2 bits for status
          name: "CL_STATUS",
          desc: "Contain the current status of the corresponding cache line                [0]: valid, [1]: dirty, [2]: cmpt",
        }
      ]
    },
    { name:     "TAG_1915",
      desc:     "Tag Address stored in cache line 1915",
      swaccess: "rw",
      hwaccess: "hrw",
      hwext:    "true",
      hwqe:     "true", // enable `qe` latched signal of software write pulse
      hwre:     "true",
      fields: [
        { bits: "5-1:0",
          name: "CL_TAG",
          desc: "Tag Address"
        }
      ]
    },
    {
      name:     "STATUS_1916",
      desc:     "Status register of cache line 1916",
      swaccess: "rw",
      hwaccess: "hrw",
      hwext:    "true",
      hwqe:     "true", // enable `qe` latched signal of software write pulse
      hwre:     "true",
      fields: [
        {
          bits: "5+3:5", // 2 bits for status
          name: "CL_STATUS",
          desc: "Contain the current status of the corresponding cache line                [0]: valid, [1]: dirty, [2]: cmpt",
        }
      ]
    },
    { name:     "TAG_1916",
      desc:     "Tag Address stored in cache line 1916",
      swaccess: "rw",
      hwaccess: "hrw",
      hwext:    "true",
      hwqe:     "true", // enable `qe` latched signal of software write pulse
      hwre:     "true",
      fields: [
        { bits: "5-1:0",
          name: "CL_TAG",
          desc: "Tag Address"
        }
      ]
    },
    {
      name:     "STATUS_1917",
      desc:     "Status register of cache line 1917",
      swaccess: "rw",
      hwaccess: "hrw",
      hwext:    "true",
      hwqe:     "true", // enable `qe` latched signal of software write pulse
      hwre:     "true",
      fields: [
        {
          bits: "5+3:5", // 2 bits for status
          name: "CL_STATUS",
          desc: "Contain the current status of the corresponding cache line                [0]: valid, [1]: dirty, [2]: cmpt",
        }
      ]
    },
    { name:     "TAG_1917",
      desc:     "Tag Address stored in cache line 1917",
      swaccess: "rw",
      hwaccess: "hrw",
      hwext:    "true",
      hwqe:     "true", // enable `qe` latched signal of software write pulse
      hwre:     "true",
      fields: [
        { bits: "5-1:0",
          name: "CL_TAG",
          desc: "Tag Address"
        }
      ]
    },
    {
      name:     "STATUS_1918",
      desc:     "Status register of cache line 1918",
      swaccess: "rw",
      hwaccess: "hrw",
      hwext:    "true",
      hwqe:     "true", // enable `qe` latched signal of software write pulse
      hwre:     "true",
      fields: [
        {
          bits: "5+3:5", // 2 bits for status
          name: "CL_STATUS",
          desc: "Contain the current status of the corresponding cache line                [0]: valid, [1]: dirty, [2]: cmpt",
        }
      ]
    },
    { name:     "TAG_1918",
      desc:     "Tag Address stored in cache line 1918",
      swaccess: "rw",
      hwaccess: "hrw",
      hwext:    "true",
      hwqe:     "true", // enable `qe` latched signal of software write pulse
      hwre:     "true",
      fields: [
        { bits: "5-1:0",
          name: "CL_TAG",
          desc: "Tag Address"
        }
      ]
    },
    {
      name:     "STATUS_1919",
      desc:     "Status register of cache line 1919",
      swaccess: "rw",
      hwaccess: "hrw",
      hwext:    "true",
      hwqe:     "true", // enable `qe` latched signal of software write pulse
      hwre:     "true",
      fields: [
        {
          bits: "5+3:5", // 2 bits for status
          name: "CL_STATUS",
          desc: "Contain the current status of the corresponding cache line                [0]: valid, [1]: dirty, [2]: cmpt",
        }
      ]
    },
    { name:     "TAG_1919",
      desc:     "Tag Address stored in cache line 1919",
      swaccess: "rw",
      hwaccess: "hrw",
      hwext:    "true",
      hwqe:     "true", // enable `qe` latched signal of software write pulse
      hwre:     "true",
      fields: [
        { bits: "5-1:0",
          name: "CL_TAG",
          desc: "Tag Address"
        }
      ]
    },
    {
      name:     "STATUS_1920",
      desc:     "Status register of cache line 1920",
      swaccess: "rw",
      hwaccess: "hrw",
      hwext:    "true",
      hwqe:     "true", // enable `qe` latched signal of software write pulse
      hwre:     "true",
      fields: [
        {
          bits: "5+3:5", // 2 bits for status
          name: "CL_STATUS",
          desc: "Contain the current status of the corresponding cache line                [0]: valid, [1]: dirty, [2]: cmpt",
        }
      ]
    },
    { name:     "TAG_1920",
      desc:     "Tag Address stored in cache line 1920",
      swaccess: "rw",
      hwaccess: "hrw",
      hwext:    "true",
      hwqe:     "true", // enable `qe` latched signal of software write pulse
      hwre:     "true",
      fields: [
        { bits: "5-1:0",
          name: "CL_TAG",
          desc: "Tag Address"
        }
      ]
    },
    {
      name:     "STATUS_1921",
      desc:     "Status register of cache line 1921",
      swaccess: "rw",
      hwaccess: "hrw",
      hwext:    "true",
      hwqe:     "true", // enable `qe` latched signal of software write pulse
      hwre:     "true",
      fields: [
        {
          bits: "5+3:5", // 2 bits for status
          name: "CL_STATUS",
          desc: "Contain the current status of the corresponding cache line                [0]: valid, [1]: dirty, [2]: cmpt",
        }
      ]
    },
    { name:     "TAG_1921",
      desc:     "Tag Address stored in cache line 1921",
      swaccess: "rw",
      hwaccess: "hrw",
      hwext:    "true",
      hwqe:     "true", // enable `qe` latched signal of software write pulse
      hwre:     "true",
      fields: [
        { bits: "5-1:0",
          name: "CL_TAG",
          desc: "Tag Address"
        }
      ]
    },
    {
      name:     "STATUS_1922",
      desc:     "Status register of cache line 1922",
      swaccess: "rw",
      hwaccess: "hrw",
      hwext:    "true",
      hwqe:     "true", // enable `qe` latched signal of software write pulse
      hwre:     "true",
      fields: [
        {
          bits: "5+3:5", // 2 bits for status
          name: "CL_STATUS",
          desc: "Contain the current status of the corresponding cache line                [0]: valid, [1]: dirty, [2]: cmpt",
        }
      ]
    },
    { name:     "TAG_1922",
      desc:     "Tag Address stored in cache line 1922",
      swaccess: "rw",
      hwaccess: "hrw",
      hwext:    "true",
      hwqe:     "true", // enable `qe` latched signal of software write pulse
      hwre:     "true",
      fields: [
        { bits: "5-1:0",
          name: "CL_TAG",
          desc: "Tag Address"
        }
      ]
    },
    {
      name:     "STATUS_1923",
      desc:     "Status register of cache line 1923",
      swaccess: "rw",
      hwaccess: "hrw",
      hwext:    "true",
      hwqe:     "true", // enable `qe` latched signal of software write pulse
      hwre:     "true",
      fields: [
        {
          bits: "5+3:5", // 2 bits for status
          name: "CL_STATUS",
          desc: "Contain the current status of the corresponding cache line                [0]: valid, [1]: dirty, [2]: cmpt",
        }
      ]
    },
    { name:     "TAG_1923",
      desc:     "Tag Address stored in cache line 1923",
      swaccess: "rw",
      hwaccess: "hrw",
      hwext:    "true",
      hwqe:     "true", // enable `qe` latched signal of software write pulse
      hwre:     "true",
      fields: [
        { bits: "5-1:0",
          name: "CL_TAG",
          desc: "Tag Address"
        }
      ]
    },
    {
      name:     "STATUS_1924",
      desc:     "Status register of cache line 1924",
      swaccess: "rw",
      hwaccess: "hrw",
      hwext:    "true",
      hwqe:     "true", // enable `qe` latched signal of software write pulse
      hwre:     "true",
      fields: [
        {
          bits: "5+3:5", // 2 bits for status
          name: "CL_STATUS",
          desc: "Contain the current status of the corresponding cache line                [0]: valid, [1]: dirty, [2]: cmpt",
        }
      ]
    },
    { name:     "TAG_1924",
      desc:     "Tag Address stored in cache line 1924",
      swaccess: "rw",
      hwaccess: "hrw",
      hwext:    "true",
      hwqe:     "true", // enable `qe` latched signal of software write pulse
      hwre:     "true",
      fields: [
        { bits: "5-1:0",
          name: "CL_TAG",
          desc: "Tag Address"
        }
      ]
    },
    {
      name:     "STATUS_1925",
      desc:     "Status register of cache line 1925",
      swaccess: "rw",
      hwaccess: "hrw",
      hwext:    "true",
      hwqe:     "true", // enable `qe` latched signal of software write pulse
      hwre:     "true",
      fields: [
        {
          bits: "5+3:5", // 2 bits for status
          name: "CL_STATUS",
          desc: "Contain the current status of the corresponding cache line                [0]: valid, [1]: dirty, [2]: cmpt",
        }
      ]
    },
    { name:     "TAG_1925",
      desc:     "Tag Address stored in cache line 1925",
      swaccess: "rw",
      hwaccess: "hrw",
      hwext:    "true",
      hwqe:     "true", // enable `qe` latched signal of software write pulse
      hwre:     "true",
      fields: [
        { bits: "5-1:0",
          name: "CL_TAG",
          desc: "Tag Address"
        }
      ]
    },
    {
      name:     "STATUS_1926",
      desc:     "Status register of cache line 1926",
      swaccess: "rw",
      hwaccess: "hrw",
      hwext:    "true",
      hwqe:     "true", // enable `qe` latched signal of software write pulse
      hwre:     "true",
      fields: [
        {
          bits: "5+3:5", // 2 bits for status
          name: "CL_STATUS",
          desc: "Contain the current status of the corresponding cache line                [0]: valid, [1]: dirty, [2]: cmpt",
        }
      ]
    },
    { name:     "TAG_1926",
      desc:     "Tag Address stored in cache line 1926",
      swaccess: "rw",
      hwaccess: "hrw",
      hwext:    "true",
      hwqe:     "true", // enable `qe` latched signal of software write pulse
      hwre:     "true",
      fields: [
        { bits: "5-1:0",
          name: "CL_TAG",
          desc: "Tag Address"
        }
      ]
    },
    {
      name:     "STATUS_1927",
      desc:     "Status register of cache line 1927",
      swaccess: "rw",
      hwaccess: "hrw",
      hwext:    "true",
      hwqe:     "true", // enable `qe` latched signal of software write pulse
      hwre:     "true",
      fields: [
        {
          bits: "5+3:5", // 2 bits for status
          name: "CL_STATUS",
          desc: "Contain the current status of the corresponding cache line                [0]: valid, [1]: dirty, [2]: cmpt",
        }
      ]
    },
    { name:     "TAG_1927",
      desc:     "Tag Address stored in cache line 1927",
      swaccess: "rw",
      hwaccess: "hrw",
      hwext:    "true",
      hwqe:     "true", // enable `qe` latched signal of software write pulse
      hwre:     "true",
      fields: [
        { bits: "5-1:0",
          name: "CL_TAG",
          desc: "Tag Address"
        }
      ]
    },
    {
      name:     "STATUS_1928",
      desc:     "Status register of cache line 1928",
      swaccess: "rw",
      hwaccess: "hrw",
      hwext:    "true",
      hwqe:     "true", // enable `qe` latched signal of software write pulse
      hwre:     "true",
      fields: [
        {
          bits: "5+3:5", // 2 bits for status
          name: "CL_STATUS",
          desc: "Contain the current status of the corresponding cache line                [0]: valid, [1]: dirty, [2]: cmpt",
        }
      ]
    },
    { name:     "TAG_1928",
      desc:     "Tag Address stored in cache line 1928",
      swaccess: "rw",
      hwaccess: "hrw",
      hwext:    "true",
      hwqe:     "true", // enable `qe` latched signal of software write pulse
      hwre:     "true",
      fields: [
        { bits: "5-1:0",
          name: "CL_TAG",
          desc: "Tag Address"
        }
      ]
    },
    {
      name:     "STATUS_1929",
      desc:     "Status register of cache line 1929",
      swaccess: "rw",
      hwaccess: "hrw",
      hwext:    "true",
      hwqe:     "true", // enable `qe` latched signal of software write pulse
      hwre:     "true",
      fields: [
        {
          bits: "5+3:5", // 2 bits for status
          name: "CL_STATUS",
          desc: "Contain the current status of the corresponding cache line                [0]: valid, [1]: dirty, [2]: cmpt",
        }
      ]
    },
    { name:     "TAG_1929",
      desc:     "Tag Address stored in cache line 1929",
      swaccess: "rw",
      hwaccess: "hrw",
      hwext:    "true",
      hwqe:     "true", // enable `qe` latched signal of software write pulse
      hwre:     "true",
      fields: [
        { bits: "5-1:0",
          name: "CL_TAG",
          desc: "Tag Address"
        }
      ]
    },
    {
      name:     "STATUS_1930",
      desc:     "Status register of cache line 1930",
      swaccess: "rw",
      hwaccess: "hrw",
      hwext:    "true",
      hwqe:     "true", // enable `qe` latched signal of software write pulse
      hwre:     "true",
      fields: [
        {
          bits: "5+3:5", // 2 bits for status
          name: "CL_STATUS",
          desc: "Contain the current status of the corresponding cache line                [0]: valid, [1]: dirty, [2]: cmpt",
        }
      ]
    },
    { name:     "TAG_1930",
      desc:     "Tag Address stored in cache line 1930",
      swaccess: "rw",
      hwaccess: "hrw",
      hwext:    "true",
      hwqe:     "true", // enable `qe` latched signal of software write pulse
      hwre:     "true",
      fields: [
        { bits: "5-1:0",
          name: "CL_TAG",
          desc: "Tag Address"
        }
      ]
    },
    {
      name:     "STATUS_1931",
      desc:     "Status register of cache line 1931",
      swaccess: "rw",
      hwaccess: "hrw",
      hwext:    "true",
      hwqe:     "true", // enable `qe` latched signal of software write pulse
      hwre:     "true",
      fields: [
        {
          bits: "5+3:5", // 2 bits for status
          name: "CL_STATUS",
          desc: "Contain the current status of the corresponding cache line                [0]: valid, [1]: dirty, [2]: cmpt",
        }
      ]
    },
    { name:     "TAG_1931",
      desc:     "Tag Address stored in cache line 1931",
      swaccess: "rw",
      hwaccess: "hrw",
      hwext:    "true",
      hwqe:     "true", // enable `qe` latched signal of software write pulse
      hwre:     "true",
      fields: [
        { bits: "5-1:0",
          name: "CL_TAG",
          desc: "Tag Address"
        }
      ]
    },
    {
      name:     "STATUS_1932",
      desc:     "Status register of cache line 1932",
      swaccess: "rw",
      hwaccess: "hrw",
      hwext:    "true",
      hwqe:     "true", // enable `qe` latched signal of software write pulse
      hwre:     "true",
      fields: [
        {
          bits: "5+3:5", // 2 bits for status
          name: "CL_STATUS",
          desc: "Contain the current status of the corresponding cache line                [0]: valid, [1]: dirty, [2]: cmpt",
        }
      ]
    },
    { name:     "TAG_1932",
      desc:     "Tag Address stored in cache line 1932",
      swaccess: "rw",
      hwaccess: "hrw",
      hwext:    "true",
      hwqe:     "true", // enable `qe` latched signal of software write pulse
      hwre:     "true",
      fields: [
        { bits: "5-1:0",
          name: "CL_TAG",
          desc: "Tag Address"
        }
      ]
    },
    {
      name:     "STATUS_1933",
      desc:     "Status register of cache line 1933",
      swaccess: "rw",
      hwaccess: "hrw",
      hwext:    "true",
      hwqe:     "true", // enable `qe` latched signal of software write pulse
      hwre:     "true",
      fields: [
        {
          bits: "5+3:5", // 2 bits for status
          name: "CL_STATUS",
          desc: "Contain the current status of the corresponding cache line                [0]: valid, [1]: dirty, [2]: cmpt",
        }
      ]
    },
    { name:     "TAG_1933",
      desc:     "Tag Address stored in cache line 1933",
      swaccess: "rw",
      hwaccess: "hrw",
      hwext:    "true",
      hwqe:     "true", // enable `qe` latched signal of software write pulse
      hwre:     "true",
      fields: [
        { bits: "5-1:0",
          name: "CL_TAG",
          desc: "Tag Address"
        }
      ]
    },
    {
      name:     "STATUS_1934",
      desc:     "Status register of cache line 1934",
      swaccess: "rw",
      hwaccess: "hrw",
      hwext:    "true",
      hwqe:     "true", // enable `qe` latched signal of software write pulse
      hwre:     "true",
      fields: [
        {
          bits: "5+3:5", // 2 bits for status
          name: "CL_STATUS",
          desc: "Contain the current status of the corresponding cache line                [0]: valid, [1]: dirty, [2]: cmpt",
        }
      ]
    },
    { name:     "TAG_1934",
      desc:     "Tag Address stored in cache line 1934",
      swaccess: "rw",
      hwaccess: "hrw",
      hwext:    "true",
      hwqe:     "true", // enable `qe` latched signal of software write pulse
      hwre:     "true",
      fields: [
        { bits: "5-1:0",
          name: "CL_TAG",
          desc: "Tag Address"
        }
      ]
    },
    {
      name:     "STATUS_1935",
      desc:     "Status register of cache line 1935",
      swaccess: "rw",
      hwaccess: "hrw",
      hwext:    "true",
      hwqe:     "true", // enable `qe` latched signal of software write pulse
      hwre:     "true",
      fields: [
        {
          bits: "5+3:5", // 2 bits for status
          name: "CL_STATUS",
          desc: "Contain the current status of the corresponding cache line                [0]: valid, [1]: dirty, [2]: cmpt",
        }
      ]
    },
    { name:     "TAG_1935",
      desc:     "Tag Address stored in cache line 1935",
      swaccess: "rw",
      hwaccess: "hrw",
      hwext:    "true",
      hwqe:     "true", // enable `qe` latched signal of software write pulse
      hwre:     "true",
      fields: [
        { bits: "5-1:0",
          name: "CL_TAG",
          desc: "Tag Address"
        }
      ]
    },
    {
      name:     "STATUS_1936",
      desc:     "Status register of cache line 1936",
      swaccess: "rw",
      hwaccess: "hrw",
      hwext:    "true",
      hwqe:     "true", // enable `qe` latched signal of software write pulse
      hwre:     "true",
      fields: [
        {
          bits: "5+3:5", // 2 bits for status
          name: "CL_STATUS",
          desc: "Contain the current status of the corresponding cache line                [0]: valid, [1]: dirty, [2]: cmpt",
        }
      ]
    },
    { name:     "TAG_1936",
      desc:     "Tag Address stored in cache line 1936",
      swaccess: "rw",
      hwaccess: "hrw",
      hwext:    "true",
      hwqe:     "true", // enable `qe` latched signal of software write pulse
      hwre:     "true",
      fields: [
        { bits: "5-1:0",
          name: "CL_TAG",
          desc: "Tag Address"
        }
      ]
    },
    {
      name:     "STATUS_1937",
      desc:     "Status register of cache line 1937",
      swaccess: "rw",
      hwaccess: "hrw",
      hwext:    "true",
      hwqe:     "true", // enable `qe` latched signal of software write pulse
      hwre:     "true",
      fields: [
        {
          bits: "5+3:5", // 2 bits for status
          name: "CL_STATUS",
          desc: "Contain the current status of the corresponding cache line                [0]: valid, [1]: dirty, [2]: cmpt",
        }
      ]
    },
    { name:     "TAG_1937",
      desc:     "Tag Address stored in cache line 1937",
      swaccess: "rw",
      hwaccess: "hrw",
      hwext:    "true",
      hwqe:     "true", // enable `qe` latched signal of software write pulse
      hwre:     "true",
      fields: [
        { bits: "5-1:0",
          name: "CL_TAG",
          desc: "Tag Address"
        }
      ]
    },
    {
      name:     "STATUS_1938",
      desc:     "Status register of cache line 1938",
      swaccess: "rw",
      hwaccess: "hrw",
      hwext:    "true",
      hwqe:     "true", // enable `qe` latched signal of software write pulse
      hwre:     "true",
      fields: [
        {
          bits: "5+3:5", // 2 bits for status
          name: "CL_STATUS",
          desc: "Contain the current status of the corresponding cache line                [0]: valid, [1]: dirty, [2]: cmpt",
        }
      ]
    },
    { name:     "TAG_1938",
      desc:     "Tag Address stored in cache line 1938",
      swaccess: "rw",
      hwaccess: "hrw",
      hwext:    "true",
      hwqe:     "true", // enable `qe` latched signal of software write pulse
      hwre:     "true",
      fields: [
        { bits: "5-1:0",
          name: "CL_TAG",
          desc: "Tag Address"
        }
      ]
    },
    {
      name:     "STATUS_1939",
      desc:     "Status register of cache line 1939",
      swaccess: "rw",
      hwaccess: "hrw",
      hwext:    "true",
      hwqe:     "true", // enable `qe` latched signal of software write pulse
      hwre:     "true",
      fields: [
        {
          bits: "5+3:5", // 2 bits for status
          name: "CL_STATUS",
          desc: "Contain the current status of the corresponding cache line                [0]: valid, [1]: dirty, [2]: cmpt",
        }
      ]
    },
    { name:     "TAG_1939",
      desc:     "Tag Address stored in cache line 1939",
      swaccess: "rw",
      hwaccess: "hrw",
      hwext:    "true",
      hwqe:     "true", // enable `qe` latched signal of software write pulse
      hwre:     "true",
      fields: [
        { bits: "5-1:0",
          name: "CL_TAG",
          desc: "Tag Address"
        }
      ]
    },
    {
      name:     "STATUS_1940",
      desc:     "Status register of cache line 1940",
      swaccess: "rw",
      hwaccess: "hrw",
      hwext:    "true",
      hwqe:     "true", // enable `qe` latched signal of software write pulse
      hwre:     "true",
      fields: [
        {
          bits: "5+3:5", // 2 bits for status
          name: "CL_STATUS",
          desc: "Contain the current status of the corresponding cache line                [0]: valid, [1]: dirty, [2]: cmpt",
        }
      ]
    },
    { name:     "TAG_1940",
      desc:     "Tag Address stored in cache line 1940",
      swaccess: "rw",
      hwaccess: "hrw",
      hwext:    "true",
      hwqe:     "true", // enable `qe` latched signal of software write pulse
      hwre:     "true",
      fields: [
        { bits: "5-1:0",
          name: "CL_TAG",
          desc: "Tag Address"
        }
      ]
    },
    {
      name:     "STATUS_1941",
      desc:     "Status register of cache line 1941",
      swaccess: "rw",
      hwaccess: "hrw",
      hwext:    "true",
      hwqe:     "true", // enable `qe` latched signal of software write pulse
      hwre:     "true",
      fields: [
        {
          bits: "5+3:5", // 2 bits for status
          name: "CL_STATUS",
          desc: "Contain the current status of the corresponding cache line                [0]: valid, [1]: dirty, [2]: cmpt",
        }
      ]
    },
    { name:     "TAG_1941",
      desc:     "Tag Address stored in cache line 1941",
      swaccess: "rw",
      hwaccess: "hrw",
      hwext:    "true",
      hwqe:     "true", // enable `qe` latched signal of software write pulse
      hwre:     "true",
      fields: [
        { bits: "5-1:0",
          name: "CL_TAG",
          desc: "Tag Address"
        }
      ]
    },
    {
      name:     "STATUS_1942",
      desc:     "Status register of cache line 1942",
      swaccess: "rw",
      hwaccess: "hrw",
      hwext:    "true",
      hwqe:     "true", // enable `qe` latched signal of software write pulse
      hwre:     "true",
      fields: [
        {
          bits: "5+3:5", // 2 bits for status
          name: "CL_STATUS",
          desc: "Contain the current status of the corresponding cache line                [0]: valid, [1]: dirty, [2]: cmpt",
        }
      ]
    },
    { name:     "TAG_1942",
      desc:     "Tag Address stored in cache line 1942",
      swaccess: "rw",
      hwaccess: "hrw",
      hwext:    "true",
      hwqe:     "true", // enable `qe` latched signal of software write pulse
      hwre:     "true",
      fields: [
        { bits: "5-1:0",
          name: "CL_TAG",
          desc: "Tag Address"
        }
      ]
    },
    {
      name:     "STATUS_1943",
      desc:     "Status register of cache line 1943",
      swaccess: "rw",
      hwaccess: "hrw",
      hwext:    "true",
      hwqe:     "true", // enable `qe` latched signal of software write pulse
      hwre:     "true",
      fields: [
        {
          bits: "5+3:5", // 2 bits for status
          name: "CL_STATUS",
          desc: "Contain the current status of the corresponding cache line                [0]: valid, [1]: dirty, [2]: cmpt",
        }
      ]
    },
    { name:     "TAG_1943",
      desc:     "Tag Address stored in cache line 1943",
      swaccess: "rw",
      hwaccess: "hrw",
      hwext:    "true",
      hwqe:     "true", // enable `qe` latched signal of software write pulse
      hwre:     "true",
      fields: [
        { bits: "5-1:0",
          name: "CL_TAG",
          desc: "Tag Address"
        }
      ]
    },
    {
      name:     "STATUS_1944",
      desc:     "Status register of cache line 1944",
      swaccess: "rw",
      hwaccess: "hrw",
      hwext:    "true",
      hwqe:     "true", // enable `qe` latched signal of software write pulse
      hwre:     "true",
      fields: [
        {
          bits: "5+3:5", // 2 bits for status
          name: "CL_STATUS",
          desc: "Contain the current status of the corresponding cache line                [0]: valid, [1]: dirty, [2]: cmpt",
        }
      ]
    },
    { name:     "TAG_1944",
      desc:     "Tag Address stored in cache line 1944",
      swaccess: "rw",
      hwaccess: "hrw",
      hwext:    "true",
      hwqe:     "true", // enable `qe` latched signal of software write pulse
      hwre:     "true",
      fields: [
        { bits: "5-1:0",
          name: "CL_TAG",
          desc: "Tag Address"
        }
      ]
    },
    {
      name:     "STATUS_1945",
      desc:     "Status register of cache line 1945",
      swaccess: "rw",
      hwaccess: "hrw",
      hwext:    "true",
      hwqe:     "true", // enable `qe` latched signal of software write pulse
      hwre:     "true",
      fields: [
        {
          bits: "5+3:5", // 2 bits for status
          name: "CL_STATUS",
          desc: "Contain the current status of the corresponding cache line                [0]: valid, [1]: dirty, [2]: cmpt",
        }
      ]
    },
    { name:     "TAG_1945",
      desc:     "Tag Address stored in cache line 1945",
      swaccess: "rw",
      hwaccess: "hrw",
      hwext:    "true",
      hwqe:     "true", // enable `qe` latched signal of software write pulse
      hwre:     "true",
      fields: [
        { bits: "5-1:0",
          name: "CL_TAG",
          desc: "Tag Address"
        }
      ]
    },
    {
      name:     "STATUS_1946",
      desc:     "Status register of cache line 1946",
      swaccess: "rw",
      hwaccess: "hrw",
      hwext:    "true",
      hwqe:     "true", // enable `qe` latched signal of software write pulse
      hwre:     "true",
      fields: [
        {
          bits: "5+3:5", // 2 bits for status
          name: "CL_STATUS",
          desc: "Contain the current status of the corresponding cache line                [0]: valid, [1]: dirty, [2]: cmpt",
        }
      ]
    },
    { name:     "TAG_1946",
      desc:     "Tag Address stored in cache line 1946",
      swaccess: "rw",
      hwaccess: "hrw",
      hwext:    "true",
      hwqe:     "true", // enable `qe` latched signal of software write pulse
      hwre:     "true",
      fields: [
        { bits: "5-1:0",
          name: "CL_TAG",
          desc: "Tag Address"
        }
      ]
    },
    {
      name:     "STATUS_1947",
      desc:     "Status register of cache line 1947",
      swaccess: "rw",
      hwaccess: "hrw",
      hwext:    "true",
      hwqe:     "true", // enable `qe` latched signal of software write pulse
      hwre:     "true",
      fields: [
        {
          bits: "5+3:5", // 2 bits for status
          name: "CL_STATUS",
          desc: "Contain the current status of the corresponding cache line                [0]: valid, [1]: dirty, [2]: cmpt",
        }
      ]
    },
    { name:     "TAG_1947",
      desc:     "Tag Address stored in cache line 1947",
      swaccess: "rw",
      hwaccess: "hrw",
      hwext:    "true",
      hwqe:     "true", // enable `qe` latched signal of software write pulse
      hwre:     "true",
      fields: [
        { bits: "5-1:0",
          name: "CL_TAG",
          desc: "Tag Address"
        }
      ]
    },
    {
      name:     "STATUS_1948",
      desc:     "Status register of cache line 1948",
      swaccess: "rw",
      hwaccess: "hrw",
      hwext:    "true",
      hwqe:     "true", // enable `qe` latched signal of software write pulse
      hwre:     "true",
      fields: [
        {
          bits: "5+3:5", // 2 bits for status
          name: "CL_STATUS",
          desc: "Contain the current status of the corresponding cache line                [0]: valid, [1]: dirty, [2]: cmpt",
        }
      ]
    },
    { name:     "TAG_1948",
      desc:     "Tag Address stored in cache line 1948",
      swaccess: "rw",
      hwaccess: "hrw",
      hwext:    "true",
      hwqe:     "true", // enable `qe` latched signal of software write pulse
      hwre:     "true",
      fields: [
        { bits: "5-1:0",
          name: "CL_TAG",
          desc: "Tag Address"
        }
      ]
    },
    {
      name:     "STATUS_1949",
      desc:     "Status register of cache line 1949",
      swaccess: "rw",
      hwaccess: "hrw",
      hwext:    "true",
      hwqe:     "true", // enable `qe` latched signal of software write pulse
      hwre:     "true",
      fields: [
        {
          bits: "5+3:5", // 2 bits for status
          name: "CL_STATUS",
          desc: "Contain the current status of the corresponding cache line                [0]: valid, [1]: dirty, [2]: cmpt",
        }
      ]
    },
    { name:     "TAG_1949",
      desc:     "Tag Address stored in cache line 1949",
      swaccess: "rw",
      hwaccess: "hrw",
      hwext:    "true",
      hwqe:     "true", // enable `qe` latched signal of software write pulse
      hwre:     "true",
      fields: [
        { bits: "5-1:0",
          name: "CL_TAG",
          desc: "Tag Address"
        }
      ]
    },
    {
      name:     "STATUS_1950",
      desc:     "Status register of cache line 1950",
      swaccess: "rw",
      hwaccess: "hrw",
      hwext:    "true",
      hwqe:     "true", // enable `qe` latched signal of software write pulse
      hwre:     "true",
      fields: [
        {
          bits: "5+3:5", // 2 bits for status
          name: "CL_STATUS",
          desc: "Contain the current status of the corresponding cache line                [0]: valid, [1]: dirty, [2]: cmpt",
        }
      ]
    },
    { name:     "TAG_1950",
      desc:     "Tag Address stored in cache line 1950",
      swaccess: "rw",
      hwaccess: "hrw",
      hwext:    "true",
      hwqe:     "true", // enable `qe` latched signal of software write pulse
      hwre:     "true",
      fields: [
        { bits: "5-1:0",
          name: "CL_TAG",
          desc: "Tag Address"
        }
      ]
    },
    {
      name:     "STATUS_1951",
      desc:     "Status register of cache line 1951",
      swaccess: "rw",
      hwaccess: "hrw",
      hwext:    "true",
      hwqe:     "true", // enable `qe` latched signal of software write pulse
      hwre:     "true",
      fields: [
        {
          bits: "5+3:5", // 2 bits for status
          name: "CL_STATUS",
          desc: "Contain the current status of the corresponding cache line                [0]: valid, [1]: dirty, [2]: cmpt",
        }
      ]
    },
    { name:     "TAG_1951",
      desc:     "Tag Address stored in cache line 1951",
      swaccess: "rw",
      hwaccess: "hrw",
      hwext:    "true",
      hwqe:     "true", // enable `qe` latched signal of software write pulse
      hwre:     "true",
      fields: [
        { bits: "5-1:0",
          name: "CL_TAG",
          desc: "Tag Address"
        }
      ]
    },
    {
      name:     "STATUS_1952",
      desc:     "Status register of cache line 1952",
      swaccess: "rw",
      hwaccess: "hrw",
      hwext:    "true",
      hwqe:     "true", // enable `qe` latched signal of software write pulse
      hwre:     "true",
      fields: [
        {
          bits: "5+3:5", // 2 bits for status
          name: "CL_STATUS",
          desc: "Contain the current status of the corresponding cache line                [0]: valid, [1]: dirty, [2]: cmpt",
        }
      ]
    },
    { name:     "TAG_1952",
      desc:     "Tag Address stored in cache line 1952",
      swaccess: "rw",
      hwaccess: "hrw",
      hwext:    "true",
      hwqe:     "true", // enable `qe` latched signal of software write pulse
      hwre:     "true",
      fields: [
        { bits: "5-1:0",
          name: "CL_TAG",
          desc: "Tag Address"
        }
      ]
    },
    {
      name:     "STATUS_1953",
      desc:     "Status register of cache line 1953",
      swaccess: "rw",
      hwaccess: "hrw",
      hwext:    "true",
      hwqe:     "true", // enable `qe` latched signal of software write pulse
      hwre:     "true",
      fields: [
        {
          bits: "5+3:5", // 2 bits for status
          name: "CL_STATUS",
          desc: "Contain the current status of the corresponding cache line                [0]: valid, [1]: dirty, [2]: cmpt",
        }
      ]
    },
    { name:     "TAG_1953",
      desc:     "Tag Address stored in cache line 1953",
      swaccess: "rw",
      hwaccess: "hrw",
      hwext:    "true",
      hwqe:     "true", // enable `qe` latched signal of software write pulse
      hwre:     "true",
      fields: [
        { bits: "5-1:0",
          name: "CL_TAG",
          desc: "Tag Address"
        }
      ]
    },
    {
      name:     "STATUS_1954",
      desc:     "Status register of cache line 1954",
      swaccess: "rw",
      hwaccess: "hrw",
      hwext:    "true",
      hwqe:     "true", // enable `qe` latched signal of software write pulse
      hwre:     "true",
      fields: [
        {
          bits: "5+3:5", // 2 bits for status
          name: "CL_STATUS",
          desc: "Contain the current status of the corresponding cache line                [0]: valid, [1]: dirty, [2]: cmpt",
        }
      ]
    },
    { name:     "TAG_1954",
      desc:     "Tag Address stored in cache line 1954",
      swaccess: "rw",
      hwaccess: "hrw",
      hwext:    "true",
      hwqe:     "true", // enable `qe` latched signal of software write pulse
      hwre:     "true",
      fields: [
        { bits: "5-1:0",
          name: "CL_TAG",
          desc: "Tag Address"
        }
      ]
    },
    {
      name:     "STATUS_1955",
      desc:     "Status register of cache line 1955",
      swaccess: "rw",
      hwaccess: "hrw",
      hwext:    "true",
      hwqe:     "true", // enable `qe` latched signal of software write pulse
      hwre:     "true",
      fields: [
        {
          bits: "5+3:5", // 2 bits for status
          name: "CL_STATUS",
          desc: "Contain the current status of the corresponding cache line                [0]: valid, [1]: dirty, [2]: cmpt",
        }
      ]
    },
    { name:     "TAG_1955",
      desc:     "Tag Address stored in cache line 1955",
      swaccess: "rw",
      hwaccess: "hrw",
      hwext:    "true",
      hwqe:     "true", // enable `qe` latched signal of software write pulse
      hwre:     "true",
      fields: [
        { bits: "5-1:0",
          name: "CL_TAG",
          desc: "Tag Address"
        }
      ]
    },
    {
      name:     "STATUS_1956",
      desc:     "Status register of cache line 1956",
      swaccess: "rw",
      hwaccess: "hrw",
      hwext:    "true",
      hwqe:     "true", // enable `qe` latched signal of software write pulse
      hwre:     "true",
      fields: [
        {
          bits: "5+3:5", // 2 bits for status
          name: "CL_STATUS",
          desc: "Contain the current status of the corresponding cache line                [0]: valid, [1]: dirty, [2]: cmpt",
        }
      ]
    },
    { name:     "TAG_1956",
      desc:     "Tag Address stored in cache line 1956",
      swaccess: "rw",
      hwaccess: "hrw",
      hwext:    "true",
      hwqe:     "true", // enable `qe` latched signal of software write pulse
      hwre:     "true",
      fields: [
        { bits: "5-1:0",
          name: "CL_TAG",
          desc: "Tag Address"
        }
      ]
    },
    {
      name:     "STATUS_1957",
      desc:     "Status register of cache line 1957",
      swaccess: "rw",
      hwaccess: "hrw",
      hwext:    "true",
      hwqe:     "true", // enable `qe` latched signal of software write pulse
      hwre:     "true",
      fields: [
        {
          bits: "5+3:5", // 2 bits for status
          name: "CL_STATUS",
          desc: "Contain the current status of the corresponding cache line                [0]: valid, [1]: dirty, [2]: cmpt",
        }
      ]
    },
    { name:     "TAG_1957",
      desc:     "Tag Address stored in cache line 1957",
      swaccess: "rw",
      hwaccess: "hrw",
      hwext:    "true",
      hwqe:     "true", // enable `qe` latched signal of software write pulse
      hwre:     "true",
      fields: [
        { bits: "5-1:0",
          name: "CL_TAG",
          desc: "Tag Address"
        }
      ]
    },
    {
      name:     "STATUS_1958",
      desc:     "Status register of cache line 1958",
      swaccess: "rw",
      hwaccess: "hrw",
      hwext:    "true",
      hwqe:     "true", // enable `qe` latched signal of software write pulse
      hwre:     "true",
      fields: [
        {
          bits: "5+3:5", // 2 bits for status
          name: "CL_STATUS",
          desc: "Contain the current status of the corresponding cache line                [0]: valid, [1]: dirty, [2]: cmpt",
        }
      ]
    },
    { name:     "TAG_1958",
      desc:     "Tag Address stored in cache line 1958",
      swaccess: "rw",
      hwaccess: "hrw",
      hwext:    "true",
      hwqe:     "true", // enable `qe` latched signal of software write pulse
      hwre:     "true",
      fields: [
        { bits: "5-1:0",
          name: "CL_TAG",
          desc: "Tag Address"
        }
      ]
    },
    {
      name:     "STATUS_1959",
      desc:     "Status register of cache line 1959",
      swaccess: "rw",
      hwaccess: "hrw",
      hwext:    "true",
      hwqe:     "true", // enable `qe` latched signal of software write pulse
      hwre:     "true",
      fields: [
        {
          bits: "5+3:5", // 2 bits for status
          name: "CL_STATUS",
          desc: "Contain the current status of the corresponding cache line                [0]: valid, [1]: dirty, [2]: cmpt",
        }
      ]
    },
    { name:     "TAG_1959",
      desc:     "Tag Address stored in cache line 1959",
      swaccess: "rw",
      hwaccess: "hrw",
      hwext:    "true",
      hwqe:     "true", // enable `qe` latched signal of software write pulse
      hwre:     "true",
      fields: [
        { bits: "5-1:0",
          name: "CL_TAG",
          desc: "Tag Address"
        }
      ]
    },
    {
      name:     "STATUS_1960",
      desc:     "Status register of cache line 1960",
      swaccess: "rw",
      hwaccess: "hrw",
      hwext:    "true",
      hwqe:     "true", // enable `qe` latched signal of software write pulse
      hwre:     "true",
      fields: [
        {
          bits: "5+3:5", // 2 bits for status
          name: "CL_STATUS",
          desc: "Contain the current status of the corresponding cache line                [0]: valid, [1]: dirty, [2]: cmpt",
        }
      ]
    },
    { name:     "TAG_1960",
      desc:     "Tag Address stored in cache line 1960",
      swaccess: "rw",
      hwaccess: "hrw",
      hwext:    "true",
      hwqe:     "true", // enable `qe` latched signal of software write pulse
      hwre:     "true",
      fields: [
        { bits: "5-1:0",
          name: "CL_TAG",
          desc: "Tag Address"
        }
      ]
    },
    {
      name:     "STATUS_1961",
      desc:     "Status register of cache line 1961",
      swaccess: "rw",
      hwaccess: "hrw",
      hwext:    "true",
      hwqe:     "true", // enable `qe` latched signal of software write pulse
      hwre:     "true",
      fields: [
        {
          bits: "5+3:5", // 2 bits for status
          name: "CL_STATUS",
          desc: "Contain the current status of the corresponding cache line                [0]: valid, [1]: dirty, [2]: cmpt",
        }
      ]
    },
    { name:     "TAG_1961",
      desc:     "Tag Address stored in cache line 1961",
      swaccess: "rw",
      hwaccess: "hrw",
      hwext:    "true",
      hwqe:     "true", // enable `qe` latched signal of software write pulse
      hwre:     "true",
      fields: [
        { bits: "5-1:0",
          name: "CL_TAG",
          desc: "Tag Address"
        }
      ]
    },
    {
      name:     "STATUS_1962",
      desc:     "Status register of cache line 1962",
      swaccess: "rw",
      hwaccess: "hrw",
      hwext:    "true",
      hwqe:     "true", // enable `qe` latched signal of software write pulse
      hwre:     "true",
      fields: [
        {
          bits: "5+3:5", // 2 bits for status
          name: "CL_STATUS",
          desc: "Contain the current status of the corresponding cache line                [0]: valid, [1]: dirty, [2]: cmpt",
        }
      ]
    },
    { name:     "TAG_1962",
      desc:     "Tag Address stored in cache line 1962",
      swaccess: "rw",
      hwaccess: "hrw",
      hwext:    "true",
      hwqe:     "true", // enable `qe` latched signal of software write pulse
      hwre:     "true",
      fields: [
        { bits: "5-1:0",
          name: "CL_TAG",
          desc: "Tag Address"
        }
      ]
    },
    {
      name:     "STATUS_1963",
      desc:     "Status register of cache line 1963",
      swaccess: "rw",
      hwaccess: "hrw",
      hwext:    "true",
      hwqe:     "true", // enable `qe` latched signal of software write pulse
      hwre:     "true",
      fields: [
        {
          bits: "5+3:5", // 2 bits for status
          name: "CL_STATUS",
          desc: "Contain the current status of the corresponding cache line                [0]: valid, [1]: dirty, [2]: cmpt",
        }
      ]
    },
    { name:     "TAG_1963",
      desc:     "Tag Address stored in cache line 1963",
      swaccess: "rw",
      hwaccess: "hrw",
      hwext:    "true",
      hwqe:     "true", // enable `qe` latched signal of software write pulse
      hwre:     "true",
      fields: [
        { bits: "5-1:0",
          name: "CL_TAG",
          desc: "Tag Address"
        }
      ]
    },
    {
      name:     "STATUS_1964",
      desc:     "Status register of cache line 1964",
      swaccess: "rw",
      hwaccess: "hrw",
      hwext:    "true",
      hwqe:     "true", // enable `qe` latched signal of software write pulse
      hwre:     "true",
      fields: [
        {
          bits: "5+3:5", // 2 bits for status
          name: "CL_STATUS",
          desc: "Contain the current status of the corresponding cache line                [0]: valid, [1]: dirty, [2]: cmpt",
        }
      ]
    },
    { name:     "TAG_1964",
      desc:     "Tag Address stored in cache line 1964",
      swaccess: "rw",
      hwaccess: "hrw",
      hwext:    "true",
      hwqe:     "true", // enable `qe` latched signal of software write pulse
      hwre:     "true",
      fields: [
        { bits: "5-1:0",
          name: "CL_TAG",
          desc: "Tag Address"
        }
      ]
    },
    {
      name:     "STATUS_1965",
      desc:     "Status register of cache line 1965",
      swaccess: "rw",
      hwaccess: "hrw",
      hwext:    "true",
      hwqe:     "true", // enable `qe` latched signal of software write pulse
      hwre:     "true",
      fields: [
        {
          bits: "5+3:5", // 2 bits for status
          name: "CL_STATUS",
          desc: "Contain the current status of the corresponding cache line                [0]: valid, [1]: dirty, [2]: cmpt",
        }
      ]
    },
    { name:     "TAG_1965",
      desc:     "Tag Address stored in cache line 1965",
      swaccess: "rw",
      hwaccess: "hrw",
      hwext:    "true",
      hwqe:     "true", // enable `qe` latched signal of software write pulse
      hwre:     "true",
      fields: [
        { bits: "5-1:0",
          name: "CL_TAG",
          desc: "Tag Address"
        }
      ]
    },
    {
      name:     "STATUS_1966",
      desc:     "Status register of cache line 1966",
      swaccess: "rw",
      hwaccess: "hrw",
      hwext:    "true",
      hwqe:     "true", // enable `qe` latched signal of software write pulse
      hwre:     "true",
      fields: [
        {
          bits: "5+3:5", // 2 bits for status
          name: "CL_STATUS",
          desc: "Contain the current status of the corresponding cache line                [0]: valid, [1]: dirty, [2]: cmpt",
        }
      ]
    },
    { name:     "TAG_1966",
      desc:     "Tag Address stored in cache line 1966",
      swaccess: "rw",
      hwaccess: "hrw",
      hwext:    "true",
      hwqe:     "true", // enable `qe` latched signal of software write pulse
      hwre:     "true",
      fields: [
        { bits: "5-1:0",
          name: "CL_TAG",
          desc: "Tag Address"
        }
      ]
    },
    {
      name:     "STATUS_1967",
      desc:     "Status register of cache line 1967",
      swaccess: "rw",
      hwaccess: "hrw",
      hwext:    "true",
      hwqe:     "true", // enable `qe` latched signal of software write pulse
      hwre:     "true",
      fields: [
        {
          bits: "5+3:5", // 2 bits for status
          name: "CL_STATUS",
          desc: "Contain the current status of the corresponding cache line                [0]: valid, [1]: dirty, [2]: cmpt",
        }
      ]
    },
    { name:     "TAG_1967",
      desc:     "Tag Address stored in cache line 1967",
      swaccess: "rw",
      hwaccess: "hrw",
      hwext:    "true",
      hwqe:     "true", // enable `qe` latched signal of software write pulse
      hwre:     "true",
      fields: [
        { bits: "5-1:0",
          name: "CL_TAG",
          desc: "Tag Address"
        }
      ]
    },
    {
      name:     "STATUS_1968",
      desc:     "Status register of cache line 1968",
      swaccess: "rw",
      hwaccess: "hrw",
      hwext:    "true",
      hwqe:     "true", // enable `qe` latched signal of software write pulse
      hwre:     "true",
      fields: [
        {
          bits: "5+3:5", // 2 bits for status
          name: "CL_STATUS",
          desc: "Contain the current status of the corresponding cache line                [0]: valid, [1]: dirty, [2]: cmpt",
        }
      ]
    },
    { name:     "TAG_1968",
      desc:     "Tag Address stored in cache line 1968",
      swaccess: "rw",
      hwaccess: "hrw",
      hwext:    "true",
      hwqe:     "true", // enable `qe` latched signal of software write pulse
      hwre:     "true",
      fields: [
        { bits: "5-1:0",
          name: "CL_TAG",
          desc: "Tag Address"
        }
      ]
    },
    {
      name:     "STATUS_1969",
      desc:     "Status register of cache line 1969",
      swaccess: "rw",
      hwaccess: "hrw",
      hwext:    "true",
      hwqe:     "true", // enable `qe` latched signal of software write pulse
      hwre:     "true",
      fields: [
        {
          bits: "5+3:5", // 2 bits for status
          name: "CL_STATUS",
          desc: "Contain the current status of the corresponding cache line                [0]: valid, [1]: dirty, [2]: cmpt",
        }
      ]
    },
    { name:     "TAG_1969",
      desc:     "Tag Address stored in cache line 1969",
      swaccess: "rw",
      hwaccess: "hrw",
      hwext:    "true",
      hwqe:     "true", // enable `qe` latched signal of software write pulse
      hwre:     "true",
      fields: [
        { bits: "5-1:0",
          name: "CL_TAG",
          desc: "Tag Address"
        }
      ]
    },
    {
      name:     "STATUS_1970",
      desc:     "Status register of cache line 1970",
      swaccess: "rw",
      hwaccess: "hrw",
      hwext:    "true",
      hwqe:     "true", // enable `qe` latched signal of software write pulse
      hwre:     "true",
      fields: [
        {
          bits: "5+3:5", // 2 bits for status
          name: "CL_STATUS",
          desc: "Contain the current status of the corresponding cache line                [0]: valid, [1]: dirty, [2]: cmpt",
        }
      ]
    },
    { name:     "TAG_1970",
      desc:     "Tag Address stored in cache line 1970",
      swaccess: "rw",
      hwaccess: "hrw",
      hwext:    "true",
      hwqe:     "true", // enable `qe` latched signal of software write pulse
      hwre:     "true",
      fields: [
        { bits: "5-1:0",
          name: "CL_TAG",
          desc: "Tag Address"
        }
      ]
    },
    {
      name:     "STATUS_1971",
      desc:     "Status register of cache line 1971",
      swaccess: "rw",
      hwaccess: "hrw",
      hwext:    "true",
      hwqe:     "true", // enable `qe` latched signal of software write pulse
      hwre:     "true",
      fields: [
        {
          bits: "5+3:5", // 2 bits for status
          name: "CL_STATUS",
          desc: "Contain the current status of the corresponding cache line                [0]: valid, [1]: dirty, [2]: cmpt",
        }
      ]
    },
    { name:     "TAG_1971",
      desc:     "Tag Address stored in cache line 1971",
      swaccess: "rw",
      hwaccess: "hrw",
      hwext:    "true",
      hwqe:     "true", // enable `qe` latched signal of software write pulse
      hwre:     "true",
      fields: [
        { bits: "5-1:0",
          name: "CL_TAG",
          desc: "Tag Address"
        }
      ]
    },
    {
      name:     "STATUS_1972",
      desc:     "Status register of cache line 1972",
      swaccess: "rw",
      hwaccess: "hrw",
      hwext:    "true",
      hwqe:     "true", // enable `qe` latched signal of software write pulse
      hwre:     "true",
      fields: [
        {
          bits: "5+3:5", // 2 bits for status
          name: "CL_STATUS",
          desc: "Contain the current status of the corresponding cache line                [0]: valid, [1]: dirty, [2]: cmpt",
        }
      ]
    },
    { name:     "TAG_1972",
      desc:     "Tag Address stored in cache line 1972",
      swaccess: "rw",
      hwaccess: "hrw",
      hwext:    "true",
      hwqe:     "true", // enable `qe` latched signal of software write pulse
      hwre:     "true",
      fields: [
        { bits: "5-1:0",
          name: "CL_TAG",
          desc: "Tag Address"
        }
      ]
    },
    {
      name:     "STATUS_1973",
      desc:     "Status register of cache line 1973",
      swaccess: "rw",
      hwaccess: "hrw",
      hwext:    "true",
      hwqe:     "true", // enable `qe` latched signal of software write pulse
      hwre:     "true",
      fields: [
        {
          bits: "5+3:5", // 2 bits for status
          name: "CL_STATUS",
          desc: "Contain the current status of the corresponding cache line                [0]: valid, [1]: dirty, [2]: cmpt",
        }
      ]
    },
    { name:     "TAG_1973",
      desc:     "Tag Address stored in cache line 1973",
      swaccess: "rw",
      hwaccess: "hrw",
      hwext:    "true",
      hwqe:     "true", // enable `qe` latched signal of software write pulse
      hwre:     "true",
      fields: [
        { bits: "5-1:0",
          name: "CL_TAG",
          desc: "Tag Address"
        }
      ]
    },
    {
      name:     "STATUS_1974",
      desc:     "Status register of cache line 1974",
      swaccess: "rw",
      hwaccess: "hrw",
      hwext:    "true",
      hwqe:     "true", // enable `qe` latched signal of software write pulse
      hwre:     "true",
      fields: [
        {
          bits: "5+3:5", // 2 bits for status
          name: "CL_STATUS",
          desc: "Contain the current status of the corresponding cache line                [0]: valid, [1]: dirty, [2]: cmpt",
        }
      ]
    },
    { name:     "TAG_1974",
      desc:     "Tag Address stored in cache line 1974",
      swaccess: "rw",
      hwaccess: "hrw",
      hwext:    "true",
      hwqe:     "true", // enable `qe` latched signal of software write pulse
      hwre:     "true",
      fields: [
        { bits: "5-1:0",
          name: "CL_TAG",
          desc: "Tag Address"
        }
      ]
    },
    {
      name:     "STATUS_1975",
      desc:     "Status register of cache line 1975",
      swaccess: "rw",
      hwaccess: "hrw",
      hwext:    "true",
      hwqe:     "true", // enable `qe` latched signal of software write pulse
      hwre:     "true",
      fields: [
        {
          bits: "5+3:5", // 2 bits for status
          name: "CL_STATUS",
          desc: "Contain the current status of the corresponding cache line                [0]: valid, [1]: dirty, [2]: cmpt",
        }
      ]
    },
    { name:     "TAG_1975",
      desc:     "Tag Address stored in cache line 1975",
      swaccess: "rw",
      hwaccess: "hrw",
      hwext:    "true",
      hwqe:     "true", // enable `qe` latched signal of software write pulse
      hwre:     "true",
      fields: [
        { bits: "5-1:0",
          name: "CL_TAG",
          desc: "Tag Address"
        }
      ]
    },
    {
      name:     "STATUS_1976",
      desc:     "Status register of cache line 1976",
      swaccess: "rw",
      hwaccess: "hrw",
      hwext:    "true",
      hwqe:     "true", // enable `qe` latched signal of software write pulse
      hwre:     "true",
      fields: [
        {
          bits: "5+3:5", // 2 bits for status
          name: "CL_STATUS",
          desc: "Contain the current status of the corresponding cache line                [0]: valid, [1]: dirty, [2]: cmpt",
        }
      ]
    },
    { name:     "TAG_1976",
      desc:     "Tag Address stored in cache line 1976",
      swaccess: "rw",
      hwaccess: "hrw",
      hwext:    "true",
      hwqe:     "true", // enable `qe` latched signal of software write pulse
      hwre:     "true",
      fields: [
        { bits: "5-1:0",
          name: "CL_TAG",
          desc: "Tag Address"
        }
      ]
    },
    {
      name:     "STATUS_1977",
      desc:     "Status register of cache line 1977",
      swaccess: "rw",
      hwaccess: "hrw",
      hwext:    "true",
      hwqe:     "true", // enable `qe` latched signal of software write pulse
      hwre:     "true",
      fields: [
        {
          bits: "5+3:5", // 2 bits for status
          name: "CL_STATUS",
          desc: "Contain the current status of the corresponding cache line                [0]: valid, [1]: dirty, [2]: cmpt",
        }
      ]
    },
    { name:     "TAG_1977",
      desc:     "Tag Address stored in cache line 1977",
      swaccess: "rw",
      hwaccess: "hrw",
      hwext:    "true",
      hwqe:     "true", // enable `qe` latched signal of software write pulse
      hwre:     "true",
      fields: [
        { bits: "5-1:0",
          name: "CL_TAG",
          desc: "Tag Address"
        }
      ]
    },
    {
      name:     "STATUS_1978",
      desc:     "Status register of cache line 1978",
      swaccess: "rw",
      hwaccess: "hrw",
      hwext:    "true",
      hwqe:     "true", // enable `qe` latched signal of software write pulse
      hwre:     "true",
      fields: [
        {
          bits: "5+3:5", // 2 bits for status
          name: "CL_STATUS",
          desc: "Contain the current status of the corresponding cache line                [0]: valid, [1]: dirty, [2]: cmpt",
        }
      ]
    },
    { name:     "TAG_1978",
      desc:     "Tag Address stored in cache line 1978",
      swaccess: "rw",
      hwaccess: "hrw",
      hwext:    "true",
      hwqe:     "true", // enable `qe` latched signal of software write pulse
      hwre:     "true",
      fields: [
        { bits: "5-1:0",
          name: "CL_TAG",
          desc: "Tag Address"
        }
      ]
    },
    {
      name:     "STATUS_1979",
      desc:     "Status register of cache line 1979",
      swaccess: "rw",
      hwaccess: "hrw",
      hwext:    "true",
      hwqe:     "true", // enable `qe` latched signal of software write pulse
      hwre:     "true",
      fields: [
        {
          bits: "5+3:5", // 2 bits for status
          name: "CL_STATUS",
          desc: "Contain the current status of the corresponding cache line                [0]: valid, [1]: dirty, [2]: cmpt",
        }
      ]
    },
    { name:     "TAG_1979",
      desc:     "Tag Address stored in cache line 1979",
      swaccess: "rw",
      hwaccess: "hrw",
      hwext:    "true",
      hwqe:     "true", // enable `qe` latched signal of software write pulse
      hwre:     "true",
      fields: [
        { bits: "5-1:0",
          name: "CL_TAG",
          desc: "Tag Address"
        }
      ]
    },
    {
      name:     "STATUS_1980",
      desc:     "Status register of cache line 1980",
      swaccess: "rw",
      hwaccess: "hrw",
      hwext:    "true",
      hwqe:     "true", // enable `qe` latched signal of software write pulse
      hwre:     "true",
      fields: [
        {
          bits: "5+3:5", // 2 bits for status
          name: "CL_STATUS",
          desc: "Contain the current status of the corresponding cache line                [0]: valid, [1]: dirty, [2]: cmpt",
        }
      ]
    },
    { name:     "TAG_1980",
      desc:     "Tag Address stored in cache line 1980",
      swaccess: "rw",
      hwaccess: "hrw",
      hwext:    "true",
      hwqe:     "true", // enable `qe` latched signal of software write pulse
      hwre:     "true",
      fields: [
        { bits: "5-1:0",
          name: "CL_TAG",
          desc: "Tag Address"
        }
      ]
    },
    {
      name:     "STATUS_1981",
      desc:     "Status register of cache line 1981",
      swaccess: "rw",
      hwaccess: "hrw",
      hwext:    "true",
      hwqe:     "true", // enable `qe` latched signal of software write pulse
      hwre:     "true",
      fields: [
        {
          bits: "5+3:5", // 2 bits for status
          name: "CL_STATUS",
          desc: "Contain the current status of the corresponding cache line                [0]: valid, [1]: dirty, [2]: cmpt",
        }
      ]
    },
    { name:     "TAG_1981",
      desc:     "Tag Address stored in cache line 1981",
      swaccess: "rw",
      hwaccess: "hrw",
      hwext:    "true",
      hwqe:     "true", // enable `qe` latched signal of software write pulse
      hwre:     "true",
      fields: [
        { bits: "5-1:0",
          name: "CL_TAG",
          desc: "Tag Address"
        }
      ]
    },
    {
      name:     "STATUS_1982",
      desc:     "Status register of cache line 1982",
      swaccess: "rw",
      hwaccess: "hrw",
      hwext:    "true",
      hwqe:     "true", // enable `qe` latched signal of software write pulse
      hwre:     "true",
      fields: [
        {
          bits: "5+3:5", // 2 bits for status
          name: "CL_STATUS",
          desc: "Contain the current status of the corresponding cache line                [0]: valid, [1]: dirty, [2]: cmpt",
        }
      ]
    },
    { name:     "TAG_1982",
      desc:     "Tag Address stored in cache line 1982",
      swaccess: "rw",
      hwaccess: "hrw",
      hwext:    "true",
      hwqe:     "true", // enable `qe` latched signal of software write pulse
      hwre:     "true",
      fields: [
        { bits: "5-1:0",
          name: "CL_TAG",
          desc: "Tag Address"
        }
      ]
    },
    {
      name:     "STATUS_1983",
      desc:     "Status register of cache line 1983",
      swaccess: "rw",
      hwaccess: "hrw",
      hwext:    "true",
      hwqe:     "true", // enable `qe` latched signal of software write pulse
      hwre:     "true",
      fields: [
        {
          bits: "5+3:5", // 2 bits for status
          name: "CL_STATUS",
          desc: "Contain the current status of the corresponding cache line                [0]: valid, [1]: dirty, [2]: cmpt",
        }
      ]
    },
    { name:     "TAG_1983",
      desc:     "Tag Address stored in cache line 1983",
      swaccess: "rw",
      hwaccess: "hrw",
      hwext:    "true",
      hwqe:     "true", // enable `qe` latched signal of software write pulse
      hwre:     "true",
      fields: [
        { bits: "5-1:0",
          name: "CL_TAG",
          desc: "Tag Address"
        }
      ]
    },
    {
      name:     "STATUS_1984",
      desc:     "Status register of cache line 1984",
      swaccess: "rw",
      hwaccess: "hrw",
      hwext:    "true",
      hwqe:     "true", // enable `qe` latched signal of software write pulse
      hwre:     "true",
      fields: [
        {
          bits: "5+3:5", // 2 bits for status
          name: "CL_STATUS",
          desc: "Contain the current status of the corresponding cache line                [0]: valid, [1]: dirty, [2]: cmpt",
        }
      ]
    },
    { name:     "TAG_1984",
      desc:     "Tag Address stored in cache line 1984",
      swaccess: "rw",
      hwaccess: "hrw",
      hwext:    "true",
      hwqe:     "true", // enable `qe` latched signal of software write pulse
      hwre:     "true",
      fields: [
        { bits: "5-1:0",
          name: "CL_TAG",
          desc: "Tag Address"
        }
      ]
    },
    {
      name:     "STATUS_1985",
      desc:     "Status register of cache line 1985",
      swaccess: "rw",
      hwaccess: "hrw",
      hwext:    "true",
      hwqe:     "true", // enable `qe` latched signal of software write pulse
      hwre:     "true",
      fields: [
        {
          bits: "5+3:5", // 2 bits for status
          name: "CL_STATUS",
          desc: "Contain the current status of the corresponding cache line                [0]: valid, [1]: dirty, [2]: cmpt",
        }
      ]
    },
    { name:     "TAG_1985",
      desc:     "Tag Address stored in cache line 1985",
      swaccess: "rw",
      hwaccess: "hrw",
      hwext:    "true",
      hwqe:     "true", // enable `qe` latched signal of software write pulse
      hwre:     "true",
      fields: [
        { bits: "5-1:0",
          name: "CL_TAG",
          desc: "Tag Address"
        }
      ]
    },
    {
      name:     "STATUS_1986",
      desc:     "Status register of cache line 1986",
      swaccess: "rw",
      hwaccess: "hrw",
      hwext:    "true",
      hwqe:     "true", // enable `qe` latched signal of software write pulse
      hwre:     "true",
      fields: [
        {
          bits: "5+3:5", // 2 bits for status
          name: "CL_STATUS",
          desc: "Contain the current status of the corresponding cache line                [0]: valid, [1]: dirty, [2]: cmpt",
        }
      ]
    },
    { name:     "TAG_1986",
      desc:     "Tag Address stored in cache line 1986",
      swaccess: "rw",
      hwaccess: "hrw",
      hwext:    "true",
      hwqe:     "true", // enable `qe` latched signal of software write pulse
      hwre:     "true",
      fields: [
        { bits: "5-1:0",
          name: "CL_TAG",
          desc: "Tag Address"
        }
      ]
    },
    {
      name:     "STATUS_1987",
      desc:     "Status register of cache line 1987",
      swaccess: "rw",
      hwaccess: "hrw",
      hwext:    "true",
      hwqe:     "true", // enable `qe` latched signal of software write pulse
      hwre:     "true",
      fields: [
        {
          bits: "5+3:5", // 2 bits for status
          name: "CL_STATUS",
          desc: "Contain the current status of the corresponding cache line                [0]: valid, [1]: dirty, [2]: cmpt",
        }
      ]
    },
    { name:     "TAG_1987",
      desc:     "Tag Address stored in cache line 1987",
      swaccess: "rw",
      hwaccess: "hrw",
      hwext:    "true",
      hwqe:     "true", // enable `qe` latched signal of software write pulse
      hwre:     "true",
      fields: [
        { bits: "5-1:0",
          name: "CL_TAG",
          desc: "Tag Address"
        }
      ]
    },
    {
      name:     "STATUS_1988",
      desc:     "Status register of cache line 1988",
      swaccess: "rw",
      hwaccess: "hrw",
      hwext:    "true",
      hwqe:     "true", // enable `qe` latched signal of software write pulse
      hwre:     "true",
      fields: [
        {
          bits: "5+3:5", // 2 bits for status
          name: "CL_STATUS",
          desc: "Contain the current status of the corresponding cache line                [0]: valid, [1]: dirty, [2]: cmpt",
        }
      ]
    },
    { name:     "TAG_1988",
      desc:     "Tag Address stored in cache line 1988",
      swaccess: "rw",
      hwaccess: "hrw",
      hwext:    "true",
      hwqe:     "true", // enable `qe` latched signal of software write pulse
      hwre:     "true",
      fields: [
        { bits: "5-1:0",
          name: "CL_TAG",
          desc: "Tag Address"
        }
      ]
    },
    {
      name:     "STATUS_1989",
      desc:     "Status register of cache line 1989",
      swaccess: "rw",
      hwaccess: "hrw",
      hwext:    "true",
      hwqe:     "true", // enable `qe` latched signal of software write pulse
      hwre:     "true",
      fields: [
        {
          bits: "5+3:5", // 2 bits for status
          name: "CL_STATUS",
          desc: "Contain the current status of the corresponding cache line                [0]: valid, [1]: dirty, [2]: cmpt",
        }
      ]
    },
    { name:     "TAG_1989",
      desc:     "Tag Address stored in cache line 1989",
      swaccess: "rw",
      hwaccess: "hrw",
      hwext:    "true",
      hwqe:     "true", // enable `qe` latched signal of software write pulse
      hwre:     "true",
      fields: [
        { bits: "5-1:0",
          name: "CL_TAG",
          desc: "Tag Address"
        }
      ]
    },
    {
      name:     "STATUS_1990",
      desc:     "Status register of cache line 1990",
      swaccess: "rw",
      hwaccess: "hrw",
      hwext:    "true",
      hwqe:     "true", // enable `qe` latched signal of software write pulse
      hwre:     "true",
      fields: [
        {
          bits: "5+3:5", // 2 bits for status
          name: "CL_STATUS",
          desc: "Contain the current status of the corresponding cache line                [0]: valid, [1]: dirty, [2]: cmpt",
        }
      ]
    },
    { name:     "TAG_1990",
      desc:     "Tag Address stored in cache line 1990",
      swaccess: "rw",
      hwaccess: "hrw",
      hwext:    "true",
      hwqe:     "true", // enable `qe` latched signal of software write pulse
      hwre:     "true",
      fields: [
        { bits: "5-1:0",
          name: "CL_TAG",
          desc: "Tag Address"
        }
      ]
    },
    {
      name:     "STATUS_1991",
      desc:     "Status register of cache line 1991",
      swaccess: "rw",
      hwaccess: "hrw",
      hwext:    "true",
      hwqe:     "true", // enable `qe` latched signal of software write pulse
      hwre:     "true",
      fields: [
        {
          bits: "5+3:5", // 2 bits for status
          name: "CL_STATUS",
          desc: "Contain the current status of the corresponding cache line                [0]: valid, [1]: dirty, [2]: cmpt",
        }
      ]
    },
    { name:     "TAG_1991",
      desc:     "Tag Address stored in cache line 1991",
      swaccess: "rw",
      hwaccess: "hrw",
      hwext:    "true",
      hwqe:     "true", // enable `qe` latched signal of software write pulse
      hwre:     "true",
      fields: [
        { bits: "5-1:0",
          name: "CL_TAG",
          desc: "Tag Address"
        }
      ]
    },
    {
      name:     "STATUS_1992",
      desc:     "Status register of cache line 1992",
      swaccess: "rw",
      hwaccess: "hrw",
      hwext:    "true",
      hwqe:     "true", // enable `qe` latched signal of software write pulse
      hwre:     "true",
      fields: [
        {
          bits: "5+3:5", // 2 bits for status
          name: "CL_STATUS",
          desc: "Contain the current status of the corresponding cache line                [0]: valid, [1]: dirty, [2]: cmpt",
        }
      ]
    },
    { name:     "TAG_1992",
      desc:     "Tag Address stored in cache line 1992",
      swaccess: "rw",
      hwaccess: "hrw",
      hwext:    "true",
      hwqe:     "true", // enable `qe` latched signal of software write pulse
      hwre:     "true",
      fields: [
        { bits: "5-1:0",
          name: "CL_TAG",
          desc: "Tag Address"
        }
      ]
    },
    {
      name:     "STATUS_1993",
      desc:     "Status register of cache line 1993",
      swaccess: "rw",
      hwaccess: "hrw",
      hwext:    "true",
      hwqe:     "true", // enable `qe` latched signal of software write pulse
      hwre:     "true",
      fields: [
        {
          bits: "5+3:5", // 2 bits for status
          name: "CL_STATUS",
          desc: "Contain the current status of the corresponding cache line                [0]: valid, [1]: dirty, [2]: cmpt",
        }
      ]
    },
    { name:     "TAG_1993",
      desc:     "Tag Address stored in cache line 1993",
      swaccess: "rw",
      hwaccess: "hrw",
      hwext:    "true",
      hwqe:     "true", // enable `qe` latched signal of software write pulse
      hwre:     "true",
      fields: [
        { bits: "5-1:0",
          name: "CL_TAG",
          desc: "Tag Address"
        }
      ]
    },
    {
      name:     "STATUS_1994",
      desc:     "Status register of cache line 1994",
      swaccess: "rw",
      hwaccess: "hrw",
      hwext:    "true",
      hwqe:     "true", // enable `qe` latched signal of software write pulse
      hwre:     "true",
      fields: [
        {
          bits: "5+3:5", // 2 bits for status
          name: "CL_STATUS",
          desc: "Contain the current status of the corresponding cache line                [0]: valid, [1]: dirty, [2]: cmpt",
        }
      ]
    },
    { name:     "TAG_1994",
      desc:     "Tag Address stored in cache line 1994",
      swaccess: "rw",
      hwaccess: "hrw",
      hwext:    "true",
      hwqe:     "true", // enable `qe` latched signal of software write pulse
      hwre:     "true",
      fields: [
        { bits: "5-1:0",
          name: "CL_TAG",
          desc: "Tag Address"
        }
      ]
    },
    {
      name:     "STATUS_1995",
      desc:     "Status register of cache line 1995",
      swaccess: "rw",
      hwaccess: "hrw",
      hwext:    "true",
      hwqe:     "true", // enable `qe` latched signal of software write pulse
      hwre:     "true",
      fields: [
        {
          bits: "5+3:5", // 2 bits for status
          name: "CL_STATUS",
          desc: "Contain the current status of the corresponding cache line                [0]: valid, [1]: dirty, [2]: cmpt",
        }
      ]
    },
    { name:     "TAG_1995",
      desc:     "Tag Address stored in cache line 1995",
      swaccess: "rw",
      hwaccess: "hrw",
      hwext:    "true",
      hwqe:     "true", // enable `qe` latched signal of software write pulse
      hwre:     "true",
      fields: [
        { bits: "5-1:0",
          name: "CL_TAG",
          desc: "Tag Address"
        }
      ]
    },
    {
      name:     "STATUS_1996",
      desc:     "Status register of cache line 1996",
      swaccess: "rw",
      hwaccess: "hrw",
      hwext:    "true",
      hwqe:     "true", // enable `qe` latched signal of software write pulse
      hwre:     "true",
      fields: [
        {
          bits: "5+3:5", // 2 bits for status
          name: "CL_STATUS",
          desc: "Contain the current status of the corresponding cache line                [0]: valid, [1]: dirty, [2]: cmpt",
        }
      ]
    },
    { name:     "TAG_1996",
      desc:     "Tag Address stored in cache line 1996",
      swaccess: "rw",
      hwaccess: "hrw",
      hwext:    "true",
      hwqe:     "true", // enable `qe` latched signal of software write pulse
      hwre:     "true",
      fields: [
        { bits: "5-1:0",
          name: "CL_TAG",
          desc: "Tag Address"
        }
      ]
    },
    {
      name:     "STATUS_1997",
      desc:     "Status register of cache line 1997",
      swaccess: "rw",
      hwaccess: "hrw",
      hwext:    "true",
      hwqe:     "true", // enable `qe` latched signal of software write pulse
      hwre:     "true",
      fields: [
        {
          bits: "5+3:5", // 2 bits for status
          name: "CL_STATUS",
          desc: "Contain the current status of the corresponding cache line                [0]: valid, [1]: dirty, [2]: cmpt",
        }
      ]
    },
    { name:     "TAG_1997",
      desc:     "Tag Address stored in cache line 1997",
      swaccess: "rw",
      hwaccess: "hrw",
      hwext:    "true",
      hwqe:     "true", // enable `qe` latched signal of software write pulse
      hwre:     "true",
      fields: [
        { bits: "5-1:0",
          name: "CL_TAG",
          desc: "Tag Address"
        }
      ]
    },
    {
      name:     "STATUS_1998",
      desc:     "Status register of cache line 1998",
      swaccess: "rw",
      hwaccess: "hrw",
      hwext:    "true",
      hwqe:     "true", // enable `qe` latched signal of software write pulse
      hwre:     "true",
      fields: [
        {
          bits: "5+3:5", // 2 bits for status
          name: "CL_STATUS",
          desc: "Contain the current status of the corresponding cache line                [0]: valid, [1]: dirty, [2]: cmpt",
        }
      ]
    },
    { name:     "TAG_1998",
      desc:     "Tag Address stored in cache line 1998",
      swaccess: "rw",
      hwaccess: "hrw",
      hwext:    "true",
      hwqe:     "true", // enable `qe` latched signal of software write pulse
      hwre:     "true",
      fields: [
        { bits: "5-1:0",
          name: "CL_TAG",
          desc: "Tag Address"
        }
      ]
    },
    {
      name:     "STATUS_1999",
      desc:     "Status register of cache line 1999",
      swaccess: "rw",
      hwaccess: "hrw",
      hwext:    "true",
      hwqe:     "true", // enable `qe` latched signal of software write pulse
      hwre:     "true",
      fields: [
        {
          bits: "5+3:5", // 2 bits for status
          name: "CL_STATUS",
          desc: "Contain the current status of the corresponding cache line                [0]: valid, [1]: dirty, [2]: cmpt",
        }
      ]
    },
    { name:     "TAG_1999",
      desc:     "Tag Address stored in cache line 1999",
      swaccess: "rw",
      hwaccess: "hrw",
      hwext:    "true",
      hwqe:     "true", // enable `qe` latched signal of software write pulse
      hwre:     "true",
      fields: [
        { bits: "5-1:0",
          name: "CL_TAG",
          desc: "Tag Address"
        }
      ]
    },
    {
      name:     "STATUS_2000",
      desc:     "Status register of cache line 2000",
      swaccess: "rw",
      hwaccess: "hrw",
      hwext:    "true",
      hwqe:     "true", // enable `qe` latched signal of software write pulse
      hwre:     "true",
      fields: [
        {
          bits: "5+3:5", // 2 bits for status
          name: "CL_STATUS",
          desc: "Contain the current status of the corresponding cache line                [0]: valid, [1]: dirty, [2]: cmpt",
        }
      ]
    },
    { name:     "TAG_2000",
      desc:     "Tag Address stored in cache line 2000",
      swaccess: "rw",
      hwaccess: "hrw",
      hwext:    "true",
      hwqe:     "true", // enable `qe` latched signal of software write pulse
      hwre:     "true",
      fields: [
        { bits: "5-1:0",
          name: "CL_TAG",
          desc: "Tag Address"
        }
      ]
    },
    {
      name:     "STATUS_2001",
      desc:     "Status register of cache line 2001",
      swaccess: "rw",
      hwaccess: "hrw",
      hwext:    "true",
      hwqe:     "true", // enable `qe` latched signal of software write pulse
      hwre:     "true",
      fields: [
        {
          bits: "5+3:5", // 2 bits for status
          name: "CL_STATUS",
          desc: "Contain the current status of the corresponding cache line                [0]: valid, [1]: dirty, [2]: cmpt",
        }
      ]
    },
    { name:     "TAG_2001",
      desc:     "Tag Address stored in cache line 2001",
      swaccess: "rw",
      hwaccess: "hrw",
      hwext:    "true",
      hwqe:     "true", // enable `qe` latched signal of software write pulse
      hwre:     "true",
      fields: [
        { bits: "5-1:0",
          name: "CL_TAG",
          desc: "Tag Address"
        }
      ]
    },
    {
      name:     "STATUS_2002",
      desc:     "Status register of cache line 2002",
      swaccess: "rw",
      hwaccess: "hrw",
      hwext:    "true",
      hwqe:     "true", // enable `qe` latched signal of software write pulse
      hwre:     "true",
      fields: [
        {
          bits: "5+3:5", // 2 bits for status
          name: "CL_STATUS",
          desc: "Contain the current status of the corresponding cache line                [0]: valid, [1]: dirty, [2]: cmpt",
        }
      ]
    },
    { name:     "TAG_2002",
      desc:     "Tag Address stored in cache line 2002",
      swaccess: "rw",
      hwaccess: "hrw",
      hwext:    "true",
      hwqe:     "true", // enable `qe` latched signal of software write pulse
      hwre:     "true",
      fields: [
        { bits: "5-1:0",
          name: "CL_TAG",
          desc: "Tag Address"
        }
      ]
    },
    {
      name:     "STATUS_2003",
      desc:     "Status register of cache line 2003",
      swaccess: "rw",
      hwaccess: "hrw",
      hwext:    "true",
      hwqe:     "true", // enable `qe` latched signal of software write pulse
      hwre:     "true",
      fields: [
        {
          bits: "5+3:5", // 2 bits for status
          name: "CL_STATUS",
          desc: "Contain the current status of the corresponding cache line                [0]: valid, [1]: dirty, [2]: cmpt",
        }
      ]
    },
    { name:     "TAG_2003",
      desc:     "Tag Address stored in cache line 2003",
      swaccess: "rw",
      hwaccess: "hrw",
      hwext:    "true",
      hwqe:     "true", // enable `qe` latched signal of software write pulse
      hwre:     "true",
      fields: [
        { bits: "5-1:0",
          name: "CL_TAG",
          desc: "Tag Address"
        }
      ]
    },
    {
      name:     "STATUS_2004",
      desc:     "Status register of cache line 2004",
      swaccess: "rw",
      hwaccess: "hrw",
      hwext:    "true",
      hwqe:     "true", // enable `qe` latched signal of software write pulse
      hwre:     "true",
      fields: [
        {
          bits: "5+3:5", // 2 bits for status
          name: "CL_STATUS",
          desc: "Contain the current status of the corresponding cache line                [0]: valid, [1]: dirty, [2]: cmpt",
        }
      ]
    },
    { name:     "TAG_2004",
      desc:     "Tag Address stored in cache line 2004",
      swaccess: "rw",
      hwaccess: "hrw",
      hwext:    "true",
      hwqe:     "true", // enable `qe` latched signal of software write pulse
      hwre:     "true",
      fields: [
        { bits: "5-1:0",
          name: "CL_TAG",
          desc: "Tag Address"
        }
      ]
    },
    {
      name:     "STATUS_2005",
      desc:     "Status register of cache line 2005",
      swaccess: "rw",
      hwaccess: "hrw",
      hwext:    "true",
      hwqe:     "true", // enable `qe` latched signal of software write pulse
      hwre:     "true",
      fields: [
        {
          bits: "5+3:5", // 2 bits for status
          name: "CL_STATUS",
          desc: "Contain the current status of the corresponding cache line                [0]: valid, [1]: dirty, [2]: cmpt",
        }
      ]
    },
    { name:     "TAG_2005",
      desc:     "Tag Address stored in cache line 2005",
      swaccess: "rw",
      hwaccess: "hrw",
      hwext:    "true",
      hwqe:     "true", // enable `qe` latched signal of software write pulse
      hwre:     "true",
      fields: [
        { bits: "5-1:0",
          name: "CL_TAG",
          desc: "Tag Address"
        }
      ]
    },
    {
      name:     "STATUS_2006",
      desc:     "Status register of cache line 2006",
      swaccess: "rw",
      hwaccess: "hrw",
      hwext:    "true",
      hwqe:     "true", // enable `qe` latched signal of software write pulse
      hwre:     "true",
      fields: [
        {
          bits: "5+3:5", // 2 bits for status
          name: "CL_STATUS",
          desc: "Contain the current status of the corresponding cache line                [0]: valid, [1]: dirty, [2]: cmpt",
        }
      ]
    },
    { name:     "TAG_2006",
      desc:     "Tag Address stored in cache line 2006",
      swaccess: "rw",
      hwaccess: "hrw",
      hwext:    "true",
      hwqe:     "true", // enable `qe` latched signal of software write pulse
      hwre:     "true",
      fields: [
        { bits: "5-1:0",
          name: "CL_TAG",
          desc: "Tag Address"
        }
      ]
    },
    {
      name:     "STATUS_2007",
      desc:     "Status register of cache line 2007",
      swaccess: "rw",
      hwaccess: "hrw",
      hwext:    "true",
      hwqe:     "true", // enable `qe` latched signal of software write pulse
      hwre:     "true",
      fields: [
        {
          bits: "5+3:5", // 2 bits for status
          name: "CL_STATUS",
          desc: "Contain the current status of the corresponding cache line                [0]: valid, [1]: dirty, [2]: cmpt",
        }
      ]
    },
    { name:     "TAG_2007",
      desc:     "Tag Address stored in cache line 2007",
      swaccess: "rw",
      hwaccess: "hrw",
      hwext:    "true",
      hwqe:     "true", // enable `qe` latched signal of software write pulse
      hwre:     "true",
      fields: [
        { bits: "5-1:0",
          name: "CL_TAG",
          desc: "Tag Address"
        }
      ]
    },
    {
      name:     "STATUS_2008",
      desc:     "Status register of cache line 2008",
      swaccess: "rw",
      hwaccess: "hrw",
      hwext:    "true",
      hwqe:     "true", // enable `qe` latched signal of software write pulse
      hwre:     "true",
      fields: [
        {
          bits: "5+3:5", // 2 bits for status
          name: "CL_STATUS",
          desc: "Contain the current status of the corresponding cache line                [0]: valid, [1]: dirty, [2]: cmpt",
        }
      ]
    },
    { name:     "TAG_2008",
      desc:     "Tag Address stored in cache line 2008",
      swaccess: "rw",
      hwaccess: "hrw",
      hwext:    "true",
      hwqe:     "true", // enable `qe` latched signal of software write pulse
      hwre:     "true",
      fields: [
        { bits: "5-1:0",
          name: "CL_TAG",
          desc: "Tag Address"
        }
      ]
    },
    {
      name:     "STATUS_2009",
      desc:     "Status register of cache line 2009",
      swaccess: "rw",
      hwaccess: "hrw",
      hwext:    "true",
      hwqe:     "true", // enable `qe` latched signal of software write pulse
      hwre:     "true",
      fields: [
        {
          bits: "5+3:5", // 2 bits for status
          name: "CL_STATUS",
          desc: "Contain the current status of the corresponding cache line                [0]: valid, [1]: dirty, [2]: cmpt",
        }
      ]
    },
    { name:     "TAG_2009",
      desc:     "Tag Address stored in cache line 2009",
      swaccess: "rw",
      hwaccess: "hrw",
      hwext:    "true",
      hwqe:     "true", // enable `qe` latched signal of software write pulse
      hwre:     "true",
      fields: [
        { bits: "5-1:0",
          name: "CL_TAG",
          desc: "Tag Address"
        }
      ]
    },
    {
      name:     "STATUS_2010",
      desc:     "Status register of cache line 2010",
      swaccess: "rw",
      hwaccess: "hrw",
      hwext:    "true",
      hwqe:     "true", // enable `qe` latched signal of software write pulse
      hwre:     "true",
      fields: [
        {
          bits: "5+3:5", // 2 bits for status
          name: "CL_STATUS",
          desc: "Contain the current status of the corresponding cache line                [0]: valid, [1]: dirty, [2]: cmpt",
        }
      ]
    },
    { name:     "TAG_2010",
      desc:     "Tag Address stored in cache line 2010",
      swaccess: "rw",
      hwaccess: "hrw",
      hwext:    "true",
      hwqe:     "true", // enable `qe` latched signal of software write pulse
      hwre:     "true",
      fields: [
        { bits: "5-1:0",
          name: "CL_TAG",
          desc: "Tag Address"
        }
      ]
    },
    {
      name:     "STATUS_2011",
      desc:     "Status register of cache line 2011",
      swaccess: "rw",
      hwaccess: "hrw",
      hwext:    "true",
      hwqe:     "true", // enable `qe` latched signal of software write pulse
      hwre:     "true",
      fields: [
        {
          bits: "5+3:5", // 2 bits for status
          name: "CL_STATUS",
          desc: "Contain the current status of the corresponding cache line                [0]: valid, [1]: dirty, [2]: cmpt",
        }
      ]
    },
    { name:     "TAG_2011",
      desc:     "Tag Address stored in cache line 2011",
      swaccess: "rw",
      hwaccess: "hrw",
      hwext:    "true",
      hwqe:     "true", // enable `qe` latched signal of software write pulse
      hwre:     "true",
      fields: [
        { bits: "5-1:0",
          name: "CL_TAG",
          desc: "Tag Address"
        }
      ]
    },
    {
      name:     "STATUS_2012",
      desc:     "Status register of cache line 2012",
      swaccess: "rw",
      hwaccess: "hrw",
      hwext:    "true",
      hwqe:     "true", // enable `qe` latched signal of software write pulse
      hwre:     "true",
      fields: [
        {
          bits: "5+3:5", // 2 bits for status
          name: "CL_STATUS",
          desc: "Contain the current status of the corresponding cache line                [0]: valid, [1]: dirty, [2]: cmpt",
        }
      ]
    },
    { name:     "TAG_2012",
      desc:     "Tag Address stored in cache line 2012",
      swaccess: "rw",
      hwaccess: "hrw",
      hwext:    "true",
      hwqe:     "true", // enable `qe` latched signal of software write pulse
      hwre:     "true",
      fields: [
        { bits: "5-1:0",
          name: "CL_TAG",
          desc: "Tag Address"
        }
      ]
    },
    {
      name:     "STATUS_2013",
      desc:     "Status register of cache line 2013",
      swaccess: "rw",
      hwaccess: "hrw",
      hwext:    "true",
      hwqe:     "true", // enable `qe` latched signal of software write pulse
      hwre:     "true",
      fields: [
        {
          bits: "5+3:5", // 2 bits for status
          name: "CL_STATUS",
          desc: "Contain the current status of the corresponding cache line                [0]: valid, [1]: dirty, [2]: cmpt",
        }
      ]
    },
    { name:     "TAG_2013",
      desc:     "Tag Address stored in cache line 2013",
      swaccess: "rw",
      hwaccess: "hrw",
      hwext:    "true",
      hwqe:     "true", // enable `qe` latched signal of software write pulse
      hwre:     "true",
      fields: [
        { bits: "5-1:0",
          name: "CL_TAG",
          desc: "Tag Address"
        }
      ]
    },
    {
      name:     "STATUS_2014",
      desc:     "Status register of cache line 2014",
      swaccess: "rw",
      hwaccess: "hrw",
      hwext:    "true",
      hwqe:     "true", // enable `qe` latched signal of software write pulse
      hwre:     "true",
      fields: [
        {
          bits: "5+3:5", // 2 bits for status
          name: "CL_STATUS",
          desc: "Contain the current status of the corresponding cache line                [0]: valid, [1]: dirty, [2]: cmpt",
        }
      ]
    },
    { name:     "TAG_2014",
      desc:     "Tag Address stored in cache line 2014",
      swaccess: "rw",
      hwaccess: "hrw",
      hwext:    "true",
      hwqe:     "true", // enable `qe` latched signal of software write pulse
      hwre:     "true",
      fields: [
        { bits: "5-1:0",
          name: "CL_TAG",
          desc: "Tag Address"
        }
      ]
    },
    {
      name:     "STATUS_2015",
      desc:     "Status register of cache line 2015",
      swaccess: "rw",
      hwaccess: "hrw",
      hwext:    "true",
      hwqe:     "true", // enable `qe` latched signal of software write pulse
      hwre:     "true",
      fields: [
        {
          bits: "5+3:5", // 2 bits for status
          name: "CL_STATUS",
          desc: "Contain the current status of the corresponding cache line                [0]: valid, [1]: dirty, [2]: cmpt",
        }
      ]
    },
    { name:     "TAG_2015",
      desc:     "Tag Address stored in cache line 2015",
      swaccess: "rw",
      hwaccess: "hrw",
      hwext:    "true",
      hwqe:     "true", // enable `qe` latched signal of software write pulse
      hwre:     "true",
      fields: [
        { bits: "5-1:0",
          name: "CL_TAG",
          desc: "Tag Address"
        }
      ]
    },
    {
      name:     "STATUS_2016",
      desc:     "Status register of cache line 2016",
      swaccess: "rw",
      hwaccess: "hrw",
      hwext:    "true",
      hwqe:     "true", // enable `qe` latched signal of software write pulse
      hwre:     "true",
      fields: [
        {
          bits: "5+3:5", // 2 bits for status
          name: "CL_STATUS",
          desc: "Contain the current status of the corresponding cache line                [0]: valid, [1]: dirty, [2]: cmpt",
        }
      ]
    },
    { name:     "TAG_2016",
      desc:     "Tag Address stored in cache line 2016",
      swaccess: "rw",
      hwaccess: "hrw",
      hwext:    "true",
      hwqe:     "true", // enable `qe` latched signal of software write pulse
      hwre:     "true",
      fields: [
        { bits: "5-1:0",
          name: "CL_TAG",
          desc: "Tag Address"
        }
      ]
    },
    {
      name:     "STATUS_2017",
      desc:     "Status register of cache line 2017",
      swaccess: "rw",
      hwaccess: "hrw",
      hwext:    "true",
      hwqe:     "true", // enable `qe` latched signal of software write pulse
      hwre:     "true",
      fields: [
        {
          bits: "5+3:5", // 2 bits for status
          name: "CL_STATUS",
          desc: "Contain the current status of the corresponding cache line                [0]: valid, [1]: dirty, [2]: cmpt",
        }
      ]
    },
    { name:     "TAG_2017",
      desc:     "Tag Address stored in cache line 2017",
      swaccess: "rw",
      hwaccess: "hrw",
      hwext:    "true",
      hwqe:     "true", // enable `qe` latched signal of software write pulse
      hwre:     "true",
      fields: [
        { bits: "5-1:0",
          name: "CL_TAG",
          desc: "Tag Address"
        }
      ]
    },
    {
      name:     "STATUS_2018",
      desc:     "Status register of cache line 2018",
      swaccess: "rw",
      hwaccess: "hrw",
      hwext:    "true",
      hwqe:     "true", // enable `qe` latched signal of software write pulse
      hwre:     "true",
      fields: [
        {
          bits: "5+3:5", // 2 bits for status
          name: "CL_STATUS",
          desc: "Contain the current status of the corresponding cache line                [0]: valid, [1]: dirty, [2]: cmpt",
        }
      ]
    },
    { name:     "TAG_2018",
      desc:     "Tag Address stored in cache line 2018",
      swaccess: "rw",
      hwaccess: "hrw",
      hwext:    "true",
      hwqe:     "true", // enable `qe` latched signal of software write pulse
      hwre:     "true",
      fields: [
        { bits: "5-1:0",
          name: "CL_TAG",
          desc: "Tag Address"
        }
      ]
    },
    {
      name:     "STATUS_2019",
      desc:     "Status register of cache line 2019",
      swaccess: "rw",
      hwaccess: "hrw",
      hwext:    "true",
      hwqe:     "true", // enable `qe` latched signal of software write pulse
      hwre:     "true",
      fields: [
        {
          bits: "5+3:5", // 2 bits for status
          name: "CL_STATUS",
          desc: "Contain the current status of the corresponding cache line                [0]: valid, [1]: dirty, [2]: cmpt",
        }
      ]
    },
    { name:     "TAG_2019",
      desc:     "Tag Address stored in cache line 2019",
      swaccess: "rw",
      hwaccess: "hrw",
      hwext:    "true",
      hwqe:     "true", // enable `qe` latched signal of software write pulse
      hwre:     "true",
      fields: [
        { bits: "5-1:0",
          name: "CL_TAG",
          desc: "Tag Address"
        }
      ]
    },
    {
      name:     "STATUS_2020",
      desc:     "Status register of cache line 2020",
      swaccess: "rw",
      hwaccess: "hrw",
      hwext:    "true",
      hwqe:     "true", // enable `qe` latched signal of software write pulse
      hwre:     "true",
      fields: [
        {
          bits: "5+3:5", // 2 bits for status
          name: "CL_STATUS",
          desc: "Contain the current status of the corresponding cache line                [0]: valid, [1]: dirty, [2]: cmpt",
        }
      ]
    },
    { name:     "TAG_2020",
      desc:     "Tag Address stored in cache line 2020",
      swaccess: "rw",
      hwaccess: "hrw",
      hwext:    "true",
      hwqe:     "true", // enable `qe` latched signal of software write pulse
      hwre:     "true",
      fields: [
        { bits: "5-1:0",
          name: "CL_TAG",
          desc: "Tag Address"
        }
      ]
    },
    {
      name:     "STATUS_2021",
      desc:     "Status register of cache line 2021",
      swaccess: "rw",
      hwaccess: "hrw",
      hwext:    "true",
      hwqe:     "true", // enable `qe` latched signal of software write pulse
      hwre:     "true",
      fields: [
        {
          bits: "5+3:5", // 2 bits for status
          name: "CL_STATUS",
          desc: "Contain the current status of the corresponding cache line                [0]: valid, [1]: dirty, [2]: cmpt",
        }
      ]
    },
    { name:     "TAG_2021",
      desc:     "Tag Address stored in cache line 2021",
      swaccess: "rw",
      hwaccess: "hrw",
      hwext:    "true",
      hwqe:     "true", // enable `qe` latched signal of software write pulse
      hwre:     "true",
      fields: [
        { bits: "5-1:0",
          name: "CL_TAG",
          desc: "Tag Address"
        }
      ]
    },
    {
      name:     "STATUS_2022",
      desc:     "Status register of cache line 2022",
      swaccess: "rw",
      hwaccess: "hrw",
      hwext:    "true",
      hwqe:     "true", // enable `qe` latched signal of software write pulse
      hwre:     "true",
      fields: [
        {
          bits: "5+3:5", // 2 bits for status
          name: "CL_STATUS",
          desc: "Contain the current status of the corresponding cache line                [0]: valid, [1]: dirty, [2]: cmpt",
        }
      ]
    },
    { name:     "TAG_2022",
      desc:     "Tag Address stored in cache line 2022",
      swaccess: "rw",
      hwaccess: "hrw",
      hwext:    "true",
      hwqe:     "true", // enable `qe` latched signal of software write pulse
      hwre:     "true",
      fields: [
        { bits: "5-1:0",
          name: "CL_TAG",
          desc: "Tag Address"
        }
      ]
    },
    {
      name:     "STATUS_2023",
      desc:     "Status register of cache line 2023",
      swaccess: "rw",
      hwaccess: "hrw",
      hwext:    "true",
      hwqe:     "true", // enable `qe` latched signal of software write pulse
      hwre:     "true",
      fields: [
        {
          bits: "5+3:5", // 2 bits for status
          name: "CL_STATUS",
          desc: "Contain the current status of the corresponding cache line                [0]: valid, [1]: dirty, [2]: cmpt",
        }
      ]
    },
    { name:     "TAG_2023",
      desc:     "Tag Address stored in cache line 2023",
      swaccess: "rw",
      hwaccess: "hrw",
      hwext:    "true",
      hwqe:     "true", // enable `qe` latched signal of software write pulse
      hwre:     "true",
      fields: [
        { bits: "5-1:0",
          name: "CL_TAG",
          desc: "Tag Address"
        }
      ]
    },
    {
      name:     "STATUS_2024",
      desc:     "Status register of cache line 2024",
      swaccess: "rw",
      hwaccess: "hrw",
      hwext:    "true",
      hwqe:     "true", // enable `qe` latched signal of software write pulse
      hwre:     "true",
      fields: [
        {
          bits: "5+3:5", // 2 bits for status
          name: "CL_STATUS",
          desc: "Contain the current status of the corresponding cache line                [0]: valid, [1]: dirty, [2]: cmpt",
        }
      ]
    },
    { name:     "TAG_2024",
      desc:     "Tag Address stored in cache line 2024",
      swaccess: "rw",
      hwaccess: "hrw",
      hwext:    "true",
      hwqe:     "true", // enable `qe` latched signal of software write pulse
      hwre:     "true",
      fields: [
        { bits: "5-1:0",
          name: "CL_TAG",
          desc: "Tag Address"
        }
      ]
    },
    {
      name:     "STATUS_2025",
      desc:     "Status register of cache line 2025",
      swaccess: "rw",
      hwaccess: "hrw",
      hwext:    "true",
      hwqe:     "true", // enable `qe` latched signal of software write pulse
      hwre:     "true",
      fields: [
        {
          bits: "5+3:5", // 2 bits for status
          name: "CL_STATUS",
          desc: "Contain the current status of the corresponding cache line                [0]: valid, [1]: dirty, [2]: cmpt",
        }
      ]
    },
    { name:     "TAG_2025",
      desc:     "Tag Address stored in cache line 2025",
      swaccess: "rw",
      hwaccess: "hrw",
      hwext:    "true",
      hwqe:     "true", // enable `qe` latched signal of software write pulse
      hwre:     "true",
      fields: [
        { bits: "5-1:0",
          name: "CL_TAG",
          desc: "Tag Address"
        }
      ]
    },
    {
      name:     "STATUS_2026",
      desc:     "Status register of cache line 2026",
      swaccess: "rw",
      hwaccess: "hrw",
      hwext:    "true",
      hwqe:     "true", // enable `qe` latched signal of software write pulse
      hwre:     "true",
      fields: [
        {
          bits: "5+3:5", // 2 bits for status
          name: "CL_STATUS",
          desc: "Contain the current status of the corresponding cache line                [0]: valid, [1]: dirty, [2]: cmpt",
        }
      ]
    },
    { name:     "TAG_2026",
      desc:     "Tag Address stored in cache line 2026",
      swaccess: "rw",
      hwaccess: "hrw",
      hwext:    "true",
      hwqe:     "true", // enable `qe` latched signal of software write pulse
      hwre:     "true",
      fields: [
        { bits: "5-1:0",
          name: "CL_TAG",
          desc: "Tag Address"
        }
      ]
    },
    {
      name:     "STATUS_2027",
      desc:     "Status register of cache line 2027",
      swaccess: "rw",
      hwaccess: "hrw",
      hwext:    "true",
      hwqe:     "true", // enable `qe` latched signal of software write pulse
      hwre:     "true",
      fields: [
        {
          bits: "5+3:5", // 2 bits for status
          name: "CL_STATUS",
          desc: "Contain the current status of the corresponding cache line                [0]: valid, [1]: dirty, [2]: cmpt",
        }
      ]
    },
    { name:     "TAG_2027",
      desc:     "Tag Address stored in cache line 2027",
      swaccess: "rw",
      hwaccess: "hrw",
      hwext:    "true",
      hwqe:     "true", // enable `qe` latched signal of software write pulse
      hwre:     "true",
      fields: [
        { bits: "5-1:0",
          name: "CL_TAG",
          desc: "Tag Address"
        }
      ]
    },
    {
      name:     "STATUS_2028",
      desc:     "Status register of cache line 2028",
      swaccess: "rw",
      hwaccess: "hrw",
      hwext:    "true",
      hwqe:     "true", // enable `qe` latched signal of software write pulse
      hwre:     "true",
      fields: [
        {
          bits: "5+3:5", // 2 bits for status
          name: "CL_STATUS",
          desc: "Contain the current status of the corresponding cache line                [0]: valid, [1]: dirty, [2]: cmpt",
        }
      ]
    },
    { name:     "TAG_2028",
      desc:     "Tag Address stored in cache line 2028",
      swaccess: "rw",
      hwaccess: "hrw",
      hwext:    "true",
      hwqe:     "true", // enable `qe` latched signal of software write pulse
      hwre:     "true",
      fields: [
        { bits: "5-1:0",
          name: "CL_TAG",
          desc: "Tag Address"
        }
      ]
    },
    {
      name:     "STATUS_2029",
      desc:     "Status register of cache line 2029",
      swaccess: "rw",
      hwaccess: "hrw",
      hwext:    "true",
      hwqe:     "true", // enable `qe` latched signal of software write pulse
      hwre:     "true",
      fields: [
        {
          bits: "5+3:5", // 2 bits for status
          name: "CL_STATUS",
          desc: "Contain the current status of the corresponding cache line                [0]: valid, [1]: dirty, [2]: cmpt",
        }
      ]
    },
    { name:     "TAG_2029",
      desc:     "Tag Address stored in cache line 2029",
      swaccess: "rw",
      hwaccess: "hrw",
      hwext:    "true",
      hwqe:     "true", // enable `qe` latched signal of software write pulse
      hwre:     "true",
      fields: [
        { bits: "5-1:0",
          name: "CL_TAG",
          desc: "Tag Address"
        }
      ]
    },
    {
      name:     "STATUS_2030",
      desc:     "Status register of cache line 2030",
      swaccess: "rw",
      hwaccess: "hrw",
      hwext:    "true",
      hwqe:     "true", // enable `qe` latched signal of software write pulse
      hwre:     "true",
      fields: [
        {
          bits: "5+3:5", // 2 bits for status
          name: "CL_STATUS",
          desc: "Contain the current status of the corresponding cache line                [0]: valid, [1]: dirty, [2]: cmpt",
        }
      ]
    },
    { name:     "TAG_2030",
      desc:     "Tag Address stored in cache line 2030",
      swaccess: "rw",
      hwaccess: "hrw",
      hwext:    "true",
      hwqe:     "true", // enable `qe` latched signal of software write pulse
      hwre:     "true",
      fields: [
        { bits: "5-1:0",
          name: "CL_TAG",
          desc: "Tag Address"
        }
      ]
    },
    {
      name:     "STATUS_2031",
      desc:     "Status register of cache line 2031",
      swaccess: "rw",
      hwaccess: "hrw",
      hwext:    "true",
      hwqe:     "true", // enable `qe` latched signal of software write pulse
      hwre:     "true",
      fields: [
        {
          bits: "5+3:5", // 2 bits for status
          name: "CL_STATUS",
          desc: "Contain the current status of the corresponding cache line                [0]: valid, [1]: dirty, [2]: cmpt",
        }
      ]
    },
    { name:     "TAG_2031",
      desc:     "Tag Address stored in cache line 2031",
      swaccess: "rw",
      hwaccess: "hrw",
      hwext:    "true",
      hwqe:     "true", // enable `qe` latched signal of software write pulse
      hwre:     "true",
      fields: [
        { bits: "5-1:0",
          name: "CL_TAG",
          desc: "Tag Address"
        }
      ]
    },
    {
      name:     "STATUS_2032",
      desc:     "Status register of cache line 2032",
      swaccess: "rw",
      hwaccess: "hrw",
      hwext:    "true",
      hwqe:     "true", // enable `qe` latched signal of software write pulse
      hwre:     "true",
      fields: [
        {
          bits: "5+3:5", // 2 bits for status
          name: "CL_STATUS",
          desc: "Contain the current status of the corresponding cache line                [0]: valid, [1]: dirty, [2]: cmpt",
        }
      ]
    },
    { name:     "TAG_2032",
      desc:     "Tag Address stored in cache line 2032",
      swaccess: "rw",
      hwaccess: "hrw",
      hwext:    "true",
      hwqe:     "true", // enable `qe` latched signal of software write pulse
      hwre:     "true",
      fields: [
        { bits: "5-1:0",
          name: "CL_TAG",
          desc: "Tag Address"
        }
      ]
    },
    {
      name:     "STATUS_2033",
      desc:     "Status register of cache line 2033",
      swaccess: "rw",
      hwaccess: "hrw",
      hwext:    "true",
      hwqe:     "true", // enable `qe` latched signal of software write pulse
      hwre:     "true",
      fields: [
        {
          bits: "5+3:5", // 2 bits for status
          name: "CL_STATUS",
          desc: "Contain the current status of the corresponding cache line                [0]: valid, [1]: dirty, [2]: cmpt",
        }
      ]
    },
    { name:     "TAG_2033",
      desc:     "Tag Address stored in cache line 2033",
      swaccess: "rw",
      hwaccess: "hrw",
      hwext:    "true",
      hwqe:     "true", // enable `qe` latched signal of software write pulse
      hwre:     "true",
      fields: [
        { bits: "5-1:0",
          name: "CL_TAG",
          desc: "Tag Address"
        }
      ]
    },
    {
      name:     "STATUS_2034",
      desc:     "Status register of cache line 2034",
      swaccess: "rw",
      hwaccess: "hrw",
      hwext:    "true",
      hwqe:     "true", // enable `qe` latched signal of software write pulse
      hwre:     "true",
      fields: [
        {
          bits: "5+3:5", // 2 bits for status
          name: "CL_STATUS",
          desc: "Contain the current status of the corresponding cache line                [0]: valid, [1]: dirty, [2]: cmpt",
        }
      ]
    },
    { name:     "TAG_2034",
      desc:     "Tag Address stored in cache line 2034",
      swaccess: "rw",
      hwaccess: "hrw",
      hwext:    "true",
      hwqe:     "true", // enable `qe` latched signal of software write pulse
      hwre:     "true",
      fields: [
        { bits: "5-1:0",
          name: "CL_TAG",
          desc: "Tag Address"
        }
      ]
    },
    {
      name:     "STATUS_2035",
      desc:     "Status register of cache line 2035",
      swaccess: "rw",
      hwaccess: "hrw",
      hwext:    "true",
      hwqe:     "true", // enable `qe` latched signal of software write pulse
      hwre:     "true",
      fields: [
        {
          bits: "5+3:5", // 2 bits for status
          name: "CL_STATUS",
          desc: "Contain the current status of the corresponding cache line                [0]: valid, [1]: dirty, [2]: cmpt",
        }
      ]
    },
    { name:     "TAG_2035",
      desc:     "Tag Address stored in cache line 2035",
      swaccess: "rw",
      hwaccess: "hrw",
      hwext:    "true",
      hwqe:     "true", // enable `qe` latched signal of software write pulse
      hwre:     "true",
      fields: [
        { bits: "5-1:0",
          name: "CL_TAG",
          desc: "Tag Address"
        }
      ]
    },
    {
      name:     "STATUS_2036",
      desc:     "Status register of cache line 2036",
      swaccess: "rw",
      hwaccess: "hrw",
      hwext:    "true",
      hwqe:     "true", // enable `qe` latched signal of software write pulse
      hwre:     "true",
      fields: [
        {
          bits: "5+3:5", // 2 bits for status
          name: "CL_STATUS",
          desc: "Contain the current status of the corresponding cache line                [0]: valid, [1]: dirty, [2]: cmpt",
        }
      ]
    },
    { name:     "TAG_2036",
      desc:     "Tag Address stored in cache line 2036",
      swaccess: "rw",
      hwaccess: "hrw",
      hwext:    "true",
      hwqe:     "true", // enable `qe` latched signal of software write pulse
      hwre:     "true",
      fields: [
        { bits: "5-1:0",
          name: "CL_TAG",
          desc: "Tag Address"
        }
      ]
    },
    {
      name:     "STATUS_2037",
      desc:     "Status register of cache line 2037",
      swaccess: "rw",
      hwaccess: "hrw",
      hwext:    "true",
      hwqe:     "true", // enable `qe` latched signal of software write pulse
      hwre:     "true",
      fields: [
        {
          bits: "5+3:5", // 2 bits for status
          name: "CL_STATUS",
          desc: "Contain the current status of the corresponding cache line                [0]: valid, [1]: dirty, [2]: cmpt",
        }
      ]
    },
    { name:     "TAG_2037",
      desc:     "Tag Address stored in cache line 2037",
      swaccess: "rw",
      hwaccess: "hrw",
      hwext:    "true",
      hwqe:     "true", // enable `qe` latched signal of software write pulse
      hwre:     "true",
      fields: [
        { bits: "5-1:0",
          name: "CL_TAG",
          desc: "Tag Address"
        }
      ]
    },
    {
      name:     "STATUS_2038",
      desc:     "Status register of cache line 2038",
      swaccess: "rw",
      hwaccess: "hrw",
      hwext:    "true",
      hwqe:     "true", // enable `qe` latched signal of software write pulse
      hwre:     "true",
      fields: [
        {
          bits: "5+3:5", // 2 bits for status
          name: "CL_STATUS",
          desc: "Contain the current status of the corresponding cache line                [0]: valid, [1]: dirty, [2]: cmpt",
        }
      ]
    },
    { name:     "TAG_2038",
      desc:     "Tag Address stored in cache line 2038",
      swaccess: "rw",
      hwaccess: "hrw",
      hwext:    "true",
      hwqe:     "true", // enable `qe` latched signal of software write pulse
      hwre:     "true",
      fields: [
        { bits: "5-1:0",
          name: "CL_TAG",
          desc: "Tag Address"
        }
      ]
    },
    {
      name:     "STATUS_2039",
      desc:     "Status register of cache line 2039",
      swaccess: "rw",
      hwaccess: "hrw",
      hwext:    "true",
      hwqe:     "true", // enable `qe` latched signal of software write pulse
      hwre:     "true",
      fields: [
        {
          bits: "5+3:5", // 2 bits for status
          name: "CL_STATUS",
          desc: "Contain the current status of the corresponding cache line                [0]: valid, [1]: dirty, [2]: cmpt",
        }
      ]
    },
    { name:     "TAG_2039",
      desc:     "Tag Address stored in cache line 2039",
      swaccess: "rw",
      hwaccess: "hrw",
      hwext:    "true",
      hwqe:     "true", // enable `qe` latched signal of software write pulse
      hwre:     "true",
      fields: [
        { bits: "5-1:0",
          name: "CL_TAG",
          desc: "Tag Address"
        }
      ]
    },
    {
      name:     "STATUS_2040",
      desc:     "Status register of cache line 2040",
      swaccess: "rw",
      hwaccess: "hrw",
      hwext:    "true",
      hwqe:     "true", // enable `qe` latched signal of software write pulse
      hwre:     "true",
      fields: [
        {
          bits: "5+3:5", // 2 bits for status
          name: "CL_STATUS",
          desc: "Contain the current status of the corresponding cache line                [0]: valid, [1]: dirty, [2]: cmpt",
        }
      ]
    },
    { name:     "TAG_2040",
      desc:     "Tag Address stored in cache line 2040",
      swaccess: "rw",
      hwaccess: "hrw",
      hwext:    "true",
      hwqe:     "true", // enable `qe` latched signal of software write pulse
      hwre:     "true",
      fields: [
        { bits: "5-1:0",
          name: "CL_TAG",
          desc: "Tag Address"
        }
      ]
    },
    {
      name:     "STATUS_2041",
      desc:     "Status register of cache line 2041",
      swaccess: "rw",
      hwaccess: "hrw",
      hwext:    "true",
      hwqe:     "true", // enable `qe` latched signal of software write pulse
      hwre:     "true",
      fields: [
        {
          bits: "5+3:5", // 2 bits for status
          name: "CL_STATUS",
          desc: "Contain the current status of the corresponding cache line                [0]: valid, [1]: dirty, [2]: cmpt",
        }
      ]
    },
    { name:     "TAG_2041",
      desc:     "Tag Address stored in cache line 2041",
      swaccess: "rw",
      hwaccess: "hrw",
      hwext:    "true",
      hwqe:     "true", // enable `qe` latched signal of software write pulse
      hwre:     "true",
      fields: [
        { bits: "5-1:0",
          name: "CL_TAG",
          desc: "Tag Address"
        }
      ]
    },
    {
      name:     "STATUS_2042",
      desc:     "Status register of cache line 2042",
      swaccess: "rw",
      hwaccess: "hrw",
      hwext:    "true",
      hwqe:     "true", // enable `qe` latched signal of software write pulse
      hwre:     "true",
      fields: [
        {
          bits: "5+3:5", // 2 bits for status
          name: "CL_STATUS",
          desc: "Contain the current status of the corresponding cache line                [0]: valid, [1]: dirty, [2]: cmpt",
        }
      ]
    },
    { name:     "TAG_2042",
      desc:     "Tag Address stored in cache line 2042",
      swaccess: "rw",
      hwaccess: "hrw",
      hwext:    "true",
      hwqe:     "true", // enable `qe` latched signal of software write pulse
      hwre:     "true",
      fields: [
        { bits: "5-1:0",
          name: "CL_TAG",
          desc: "Tag Address"
        }
      ]
    },
    {
      name:     "STATUS_2043",
      desc:     "Status register of cache line 2043",
      swaccess: "rw",
      hwaccess: "hrw",
      hwext:    "true",
      hwqe:     "true", // enable `qe` latched signal of software write pulse
      hwre:     "true",
      fields: [
        {
          bits: "5+3:5", // 2 bits for status
          name: "CL_STATUS",
          desc: "Contain the current status of the corresponding cache line                [0]: valid, [1]: dirty, [2]: cmpt",
        }
      ]
    },
    { name:     "TAG_2043",
      desc:     "Tag Address stored in cache line 2043",
      swaccess: "rw",
      hwaccess: "hrw",
      hwext:    "true",
      hwqe:     "true", // enable `qe` latched signal of software write pulse
      hwre:     "true",
      fields: [
        { bits: "5-1:0",
          name: "CL_TAG",
          desc: "Tag Address"
        }
      ]
    },
    {
      name:     "STATUS_2044",
      desc:     "Status register of cache line 2044",
      swaccess: "rw",
      hwaccess: "hrw",
      hwext:    "true",
      hwqe:     "true", // enable `qe` latched signal of software write pulse
      hwre:     "true",
      fields: [
        {
          bits: "5+3:5", // 2 bits for status
          name: "CL_STATUS",
          desc: "Contain the current status of the corresponding cache line                [0]: valid, [1]: dirty, [2]: cmpt",
        }
      ]
    },
    { name:     "TAG_2044",
      desc:     "Tag Address stored in cache line 2044",
      swaccess: "rw",
      hwaccess: "hrw",
      hwext:    "true",
      hwqe:     "true", // enable `qe` latched signal of software write pulse
      hwre:     "true",
      fields: [
        { bits: "5-1:0",
          name: "CL_TAG",
          desc: "Tag Address"
        }
      ]
    },
    {
      name:     "STATUS_2045",
      desc:     "Status register of cache line 2045",
      swaccess: "rw",
      hwaccess: "hrw",
      hwext:    "true",
      hwqe:     "true", // enable `qe` latched signal of software write pulse
      hwre:     "true",
      fields: [
        {
          bits: "5+3:5", // 2 bits for status
          name: "CL_STATUS",
          desc: "Contain the current status of the corresponding cache line                [0]: valid, [1]: dirty, [2]: cmpt",
        }
      ]
    },
    { name:     "TAG_2045",
      desc:     "Tag Address stored in cache line 2045",
      swaccess: "rw",
      hwaccess: "hrw",
      hwext:    "true",
      hwqe:     "true", // enable `qe` latched signal of software write pulse
      hwre:     "true",
      fields: [
        { bits: "5-1:0",
          name: "CL_TAG",
          desc: "Tag Address"
        }
      ]
    },
    {
      name:     "STATUS_2046",
      desc:     "Status register of cache line 2046",
      swaccess: "rw",
      hwaccess: "hrw",
      hwext:    "true",
      hwqe:     "true", // enable `qe` latched signal of software write pulse
      hwre:     "true",
      fields: [
        {
          bits: "5+3:5", // 2 bits for status
          name: "CL_STATUS",
          desc: "Contain the current status of the corresponding cache line                [0]: valid, [1]: dirty, [2]: cmpt",
        }
      ]
    },
    { name:     "TAG_2046",
      desc:     "Tag Address stored in cache line 2046",
      swaccess: "rw",
      hwaccess: "hrw",
      hwext:    "true",
      hwqe:     "true", // enable `qe` latched signal of software write pulse
      hwre:     "true",
      fields: [
        { bits: "5-1:0",
          name: "CL_TAG",
          desc: "Tag Address"
        }
      ]
    },
    {
      name:     "STATUS_2047",
      desc:     "Status register of cache line 2047",
      swaccess: "rw",
      hwaccess: "hrw",
      hwext:    "true",
      hwqe:     "true", // enable `qe` latched signal of software write pulse
      hwre:     "true",
      fields: [
        {
          bits: "5+3:5", // 2 bits for status
          name: "CL_STATUS",
          desc: "Contain the current status of the corresponding cache line                [0]: valid, [1]: dirty, [2]: cmpt",
        }
      ]
    },
    { name:     "TAG_2047",
      desc:     "Tag Address stored in cache line 2047",
      swaccess: "rw",
      hwaccess: "hrw",
      hwext:    "true",
      hwqe:     "true", // enable `qe` latched signal of software write pulse
      hwre:     "true",
      fields: [
        { bits: "5-1:0",
          name: "CL_TAG",
          desc: "Tag Address"
        }
      ]
    },
  ]
}